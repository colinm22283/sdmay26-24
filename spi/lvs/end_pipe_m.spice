* NGSPICE file created from end_pipe_m.ext - technology: sky130A

* Black-box entry subcircuit for sky130_fd_sc_hd__conb_1 abstract view
.subckt sky130_fd_sc_hd__conb_1 VGND VNB VPB VPWR HI LO
.ends

* Black-box entry subcircuit for sky130_fd_sc_hd__fill_2 abstract view
.subckt sky130_fd_sc_hd__fill_2 VGND VNB VPB VPWR
.ends

* Black-box entry subcircuit for sky130_fd_sc_hd__diode_2 abstract view
.subckt sky130_fd_sc_hd__diode_2 DIODE VGND VNB VPB VPWR
.ends

* Black-box entry subcircuit for sky130_fd_sc_hd__decap_4 abstract view
.subckt sky130_fd_sc_hd__decap_4 VGND VNB VPB VPWR
.ends

* Black-box entry subcircuit for sky130_fd_sc_hd__dfxtp_1 abstract view
.subckt sky130_fd_sc_hd__dfxtp_1 CLK D VGND VNB VPB VPWR Q
.ends

* Black-box entry subcircuit for sky130_fd_sc_hd__fill_1 abstract view
.subckt sky130_fd_sc_hd__fill_1 VGND VNB VPB VPWR
.ends

* Black-box entry subcircuit for sky130_fd_sc_hd__dfrtp_4 abstract view
.subckt sky130_fd_sc_hd__dfrtp_4 CLK D RESET_B VGND VNB VPB VPWR Q
.ends

* Black-box entry subcircuit for sky130_fd_sc_hd__and3_1 abstract view
.subckt sky130_fd_sc_hd__and3_1 A B C VGND VNB VPB VPWR X
.ends

* Black-box entry subcircuit for sky130_fd_sc_hd__xnor2_1 abstract view
.subckt sky130_fd_sc_hd__xnor2_1 A B VGND VNB VPB VPWR Y
.ends

* Black-box entry subcircuit for sky130_fd_sc_hd__decap_3 abstract view
.subckt sky130_fd_sc_hd__decap_3 VGND VNB VPB VPWR
.ends

* Black-box entry subcircuit for sky130_fd_sc_hd__mux2_1 abstract view
.subckt sky130_fd_sc_hd__mux2_1 A0 A1 S VGND VNB VPB VPWR X
.ends

* Black-box entry subcircuit for sky130_fd_sc_hd__a21o_1 abstract view
.subckt sky130_fd_sc_hd__a21o_1 A1 A2 B1 VGND VNB VPB VPWR X
.ends

* Black-box entry subcircuit for sky130_fd_sc_hd__xor2_2 abstract view
.subckt sky130_fd_sc_hd__xor2_2 A B VGND VNB VPB VPWR X
.ends

* Black-box entry subcircuit for sky130_ef_sc_hd__decap_12 abstract view
.subckt sky130_ef_sc_hd__decap_12 VGND VNB VPB VPWR
.ends

* Black-box entry subcircuit for sky130_fd_sc_hd__nand4_1 abstract view
.subckt sky130_fd_sc_hd__nand4_1 A B C D VGND VNB VPB VPWR Y
.ends

* Black-box entry subcircuit for sky130_fd_sc_hd__a22o_1 abstract view
.subckt sky130_fd_sc_hd__a22o_1 A1 A2 B1 B2 VGND VNB VPB VPWR X
.ends

* Black-box entry subcircuit for sky130_fd_sc_hd__a21oi_1 abstract view
.subckt sky130_fd_sc_hd__a21oi_1 A1 A2 B1 VGND VNB VPB VPWR Y
.ends

* Black-box entry subcircuit for sky130_fd_sc_hd__dfstp_1 abstract view
.subckt sky130_fd_sc_hd__dfstp_1 CLK D SET_B VGND VNB VPB VPWR Q
.ends

* Black-box entry subcircuit for sky130_fd_sc_hd__a211o_1 abstract view
.subckt sky130_fd_sc_hd__a211o_1 A1 A2 B1 C1 VGND VNB VPB VPWR X
.ends

* Black-box entry subcircuit for sky130_fd_sc_hd__decap_6 abstract view
.subckt sky130_fd_sc_hd__decap_6 VGND VNB VPB VPWR
.ends

* Black-box entry subcircuit for sky130_fd_sc_hd__or2_1 abstract view
.subckt sky130_fd_sc_hd__or2_1 A B VGND VNB VPB VPWR X
.ends

* Black-box entry subcircuit for sky130_fd_sc_hd__nor2_1 abstract view
.subckt sky130_fd_sc_hd__nor2_1 A B VGND VNB VPB VPWR Y
.ends

* Black-box entry subcircuit for sky130_fd_sc_hd__buf_4 abstract view
.subckt sky130_fd_sc_hd__buf_4 A VGND VNB VPB VPWR X
.ends

* Black-box entry subcircuit for sky130_fd_sc_hd__clkbuf_4 abstract view
.subckt sky130_fd_sc_hd__clkbuf_4 A VGND VNB VPB VPWR X
.ends

* Black-box entry subcircuit for sky130_fd_sc_hd__nand2_1 abstract view
.subckt sky130_fd_sc_hd__nand2_1 A B VGND VNB VPB VPWR Y
.ends

* Black-box entry subcircuit for sky130_fd_sc_hd__xnor2_2 abstract view
.subckt sky130_fd_sc_hd__xnor2_2 A B VGND VNB VPB VPWR Y
.ends

* Black-box entry subcircuit for sky130_fd_sc_hd__tapvpwrvgnd_1 abstract view
.subckt sky130_fd_sc_hd__tapvpwrvgnd_1 VGND VPWR
.ends

* Black-box entry subcircuit for sky130_fd_sc_hd__decap_8 abstract view
.subckt sky130_fd_sc_hd__decap_8 VGND VNB VPB VPWR
.ends

* Black-box entry subcircuit for sky130_fd_sc_hd__dlygate4sd3_1 abstract view
.subckt sky130_fd_sc_hd__dlygate4sd3_1 A VGND VNB VPB VPWR X
.ends

* Black-box entry subcircuit for sky130_fd_sc_hd__a22oi_1 abstract view
.subckt sky130_fd_sc_hd__a22oi_1 A1 A2 B1 B2 VGND VNB VPB VPWR Y
.ends

* Black-box entry subcircuit for sky130_fd_sc_hd__dfxtp_2 abstract view
.subckt sky130_fd_sc_hd__dfxtp_2 CLK D VGND VNB VPB VPWR Q
.ends

* Black-box entry subcircuit for sky130_fd_sc_hd__and2_1 abstract view
.subckt sky130_fd_sc_hd__and2_1 A B VGND VNB VPB VPWR X
.ends

* Black-box entry subcircuit for sky130_fd_sc_hd__a211oi_2 abstract view
.subckt sky130_fd_sc_hd__a211oi_2 A1 A2 B1 C1 VGND VNB VPB VPWR Y
.ends

* Black-box entry subcircuit for sky130_fd_sc_hd__o21ai_1 abstract view
.subckt sky130_fd_sc_hd__o21ai_1 A1 A2 B1 VGND VNB VPB VPWR Y
.ends

* Black-box entry subcircuit for sky130_fd_sc_hd__a31o_1 abstract view
.subckt sky130_fd_sc_hd__a31o_1 A1 A2 A3 B1 VGND VNB VPB VPWR X
.ends

* Black-box entry subcircuit for sky130_fd_sc_hd__or3_1 abstract view
.subckt sky130_fd_sc_hd__or3_1 A B C VGND VNB VPB VPWR X
.ends

* Black-box entry subcircuit for sky130_fd_sc_hd__and2b_1 abstract view
.subckt sky130_fd_sc_hd__and2b_1 A_N B VGND VNB VPB VPWR X
.ends

* Black-box entry subcircuit for sky130_fd_sc_hd__and4_1 abstract view
.subckt sky130_fd_sc_hd__and4_1 A B C D VGND VNB VPB VPWR X
.ends

* Black-box entry subcircuit for sky130_fd_sc_hd__a21boi_1 abstract view
.subckt sky130_fd_sc_hd__a21boi_1 A1 A2 B1_N VGND VNB VPB VPWR Y
.ends

* Black-box entry subcircuit for sky130_fd_sc_hd__o2111a_1 abstract view
.subckt sky130_fd_sc_hd__o2111a_1 A1 A2 B1 C1 D1 VGND VNB VPB VPWR X
.ends

* Black-box entry subcircuit for sky130_fd_sc_hd__o21bai_2 abstract view
.subckt sky130_fd_sc_hd__o21bai_2 A1 A2 B1_N VGND VNB VPB VPWR Y
.ends

* Black-box entry subcircuit for sky130_fd_sc_hd__or2_2 abstract view
.subckt sky130_fd_sc_hd__or2_2 A B VGND VNB VPB VPWR X
.ends

* Black-box entry subcircuit for sky130_fd_sc_hd__or4_2 abstract view
.subckt sky130_fd_sc_hd__or4_2 A B C D VGND VNB VPB VPWR X
.ends

* Black-box entry subcircuit for sky130_fd_sc_hd__xor2_1 abstract view
.subckt sky130_fd_sc_hd__xor2_1 A B VGND VNB VPB VPWR X
.ends

* Black-box entry subcircuit for sky130_fd_sc_hd__inv_2 abstract view
.subckt sky130_fd_sc_hd__inv_2 A VGND VNB VPB VPWR Y
.ends

* Black-box entry subcircuit for sky130_fd_sc_hd__nand3_2 abstract view
.subckt sky130_fd_sc_hd__nand3_2 A B C VGND VNB VPB VPWR Y
.ends

* Black-box entry subcircuit for sky130_fd_sc_hd__a221o_1 abstract view
.subckt sky130_fd_sc_hd__a221o_1 A1 A2 B1 B2 C1 VGND VNB VPB VPWR X
.ends

* Black-box entry subcircuit for sky130_fd_sc_hd__or2_4 abstract view
.subckt sky130_fd_sc_hd__or2_4 A B VGND VNB VPB VPWR X
.ends

* Black-box entry subcircuit for sky130_fd_sc_hd__o2bb2a_1 abstract view
.subckt sky130_fd_sc_hd__o2bb2a_1 A1_N A2_N B1 B2 VGND VNB VPB VPWR X
.ends

* Black-box entry subcircuit for sky130_fd_sc_hd__or4bb_1 abstract view
.subckt sky130_fd_sc_hd__or4bb_1 A B C_N D_N VGND VNB VPB VPWR X
.ends

* Black-box entry subcircuit for sky130_fd_sc_hd__o211ai_1 abstract view
.subckt sky130_fd_sc_hd__o211ai_1 A1 A2 B1 C1 VGND VNB VPB VPWR Y
.ends

* Black-box entry subcircuit for sky130_fd_sc_hd__nand3_1 abstract view
.subckt sky130_fd_sc_hd__nand3_1 A B C VGND VNB VPB VPWR Y
.ends

* Black-box entry subcircuit for sky130_fd_sc_hd__buf_2 abstract view
.subckt sky130_fd_sc_hd__buf_2 A VGND VNB VPB VPWR X
.ends

* Black-box entry subcircuit for sky130_fd_sc_hd__clkbuf_8 abstract view
.subckt sky130_fd_sc_hd__clkbuf_8 A VGND VNB VPB VPWR X
.ends

* Black-box entry subcircuit for sky130_fd_sc_hd__and4b_1 abstract view
.subckt sky130_fd_sc_hd__and4b_1 A_N B C D VGND VNB VPB VPWR X
.ends

* Black-box entry subcircuit for sky130_fd_sc_hd__nor3_1 abstract view
.subckt sky130_fd_sc_hd__nor3_1 A B C VGND VNB VPB VPWR Y
.ends

* Black-box entry subcircuit for sky130_fd_sc_hd__o211a_1 abstract view
.subckt sky130_fd_sc_hd__o211a_1 A1 A2 B1 C1 VGND VNB VPB VPWR X
.ends

* Black-box entry subcircuit for sky130_fd_sc_hd__o211ai_2 abstract view
.subckt sky130_fd_sc_hd__o211ai_2 A1 A2 B1 C1 VGND VNB VPB VPWR Y
.ends

* Black-box entry subcircuit for sky130_fd_sc_hd__and3_2 abstract view
.subckt sky130_fd_sc_hd__and3_2 A B C VGND VNB VPB VPWR X
.ends

* Black-box entry subcircuit for sky130_fd_sc_hd__nand2b_1 abstract view
.subckt sky130_fd_sc_hd__nand2b_1 A_N B VGND VNB VPB VPWR Y
.ends

* Black-box entry subcircuit for sky130_fd_sc_hd__a21oi_2 abstract view
.subckt sky130_fd_sc_hd__a21oi_2 A1 A2 B1 VGND VNB VPB VPWR Y
.ends

* Black-box entry subcircuit for sky130_fd_sc_hd__and3b_1 abstract view
.subckt sky130_fd_sc_hd__and3b_1 A_N B C VGND VNB VPB VPWR X
.ends

* Black-box entry subcircuit for sky130_fd_sc_hd__a31o_2 abstract view
.subckt sky130_fd_sc_hd__a31o_2 A1 A2 A3 B1 VGND VNB VPB VPWR X
.ends

* Black-box entry subcircuit for sky130_fd_sc_hd__and4bb_1 abstract view
.subckt sky130_fd_sc_hd__and4bb_1 A_N B_N C D VGND VNB VPB VPWR X
.ends

* Black-box entry subcircuit for sky130_fd_sc_hd__o21a_1 abstract view
.subckt sky130_fd_sc_hd__o21a_1 A1 A2 B1 VGND VNB VPB VPWR X
.ends

* Black-box entry subcircuit for sky130_fd_sc_hd__o221a_1 abstract view
.subckt sky130_fd_sc_hd__o221a_1 A1 A2 B1 B2 C1 VGND VNB VPB VPWR X
.ends

* Black-box entry subcircuit for sky130_fd_sc_hd__a21bo_1 abstract view
.subckt sky130_fd_sc_hd__a21bo_1 A1 A2 B1_N VGND VNB VPB VPWR X
.ends

* Black-box entry subcircuit for sky130_fd_sc_hd__nor2_4 abstract view
.subckt sky130_fd_sc_hd__nor2_4 A B VGND VNB VPB VPWR Y
.ends

* Black-box entry subcircuit for sky130_fd_sc_hd__nand2_2 abstract view
.subckt sky130_fd_sc_hd__nand2_2 A B VGND VNB VPB VPWR Y
.ends

* Black-box entry subcircuit for sky130_fd_sc_hd__o21bai_1 abstract view
.subckt sky130_fd_sc_hd__o21bai_1 A1 A2 B1_N VGND VNB VPB VPWR Y
.ends

* Black-box entry subcircuit for sky130_fd_sc_hd__buf_6 abstract view
.subckt sky130_fd_sc_hd__buf_6 A VGND VNB VPB VPWR X
.ends

* Black-box entry subcircuit for sky130_fd_sc_hd__nand4_4 abstract view
.subckt sky130_fd_sc_hd__nand4_4 A B C D VGND VNB VPB VPWR Y
.ends

* Black-box entry subcircuit for sky130_fd_sc_hd__nand4_2 abstract view
.subckt sky130_fd_sc_hd__nand4_2 A B C D VGND VNB VPB VPWR Y
.ends

* Black-box entry subcircuit for sky130_fd_sc_hd__dfrtp_1 abstract view
.subckt sky130_fd_sc_hd__dfrtp_1 CLK D RESET_B VGND VNB VPB VPWR Q
.ends

* Black-box entry subcircuit for sky130_fd_sc_hd__or3_2 abstract view
.subckt sky130_fd_sc_hd__or3_2 A B C VGND VNB VPB VPWR X
.ends

* Black-box entry subcircuit for sky130_fd_sc_hd__a32o_1 abstract view
.subckt sky130_fd_sc_hd__a32o_1 A1 A2 A3 B1 B2 VGND VNB VPB VPWR X
.ends

* Black-box entry subcircuit for sky130_fd_sc_hd__o22a_1 abstract view
.subckt sky130_fd_sc_hd__o22a_1 A1 A2 B1 B2 VGND VNB VPB VPWR X
.ends

* Black-box entry subcircuit for sky130_fd_sc_hd__clkbuf_16 abstract view
.subckt sky130_fd_sc_hd__clkbuf_16 A VGND VNB VPB VPWR X
.ends

* Black-box entry subcircuit for sky130_fd_sc_hd__or3b_1 abstract view
.subckt sky130_fd_sc_hd__or3b_1 A B C_N VGND VNB VPB VPWR X
.ends

* Black-box entry subcircuit for sky130_fd_sc_hd__and2_2 abstract view
.subckt sky130_fd_sc_hd__and2_2 A B VGND VNB VPB VPWR X
.ends

* Black-box entry subcircuit for sky130_fd_sc_hd__a2bb2o_1 abstract view
.subckt sky130_fd_sc_hd__a2bb2o_1 A1_N A2_N B1 B2 VGND VNB VPB VPWR X
.ends

* Black-box entry subcircuit for sky130_fd_sc_hd__dfxtp_4 abstract view
.subckt sky130_fd_sc_hd__dfxtp_4 CLK D VGND VNB VPB VPWR Q
.ends

* Black-box entry subcircuit for sky130_fd_sc_hd__o211ai_4 abstract view
.subckt sky130_fd_sc_hd__o211ai_4 A1 A2 B1 C1 VGND VNB VPB VPWR Y
.ends

* Black-box entry subcircuit for sky130_fd_sc_hd__xnor2_4 abstract view
.subckt sky130_fd_sc_hd__xnor2_4 A B VGND VNB VPB VPWR Y
.ends

* Black-box entry subcircuit for sky130_fd_sc_hd__o211a_2 abstract view
.subckt sky130_fd_sc_hd__o211a_2 A1 A2 B1 C1 VGND VNB VPB VPWR X
.ends

* Black-box entry subcircuit for sky130_fd_sc_hd__a31oi_4 abstract view
.subckt sky130_fd_sc_hd__a31oi_4 A1 A2 A3 B1 VGND VNB VPB VPWR Y
.ends

* Black-box entry subcircuit for sky130_fd_sc_hd__xor2_4 abstract view
.subckt sky130_fd_sc_hd__xor2_4 A B VGND VNB VPB VPWR X
.ends

* Black-box entry subcircuit for sky130_fd_sc_hd__a211oi_1 abstract view
.subckt sky130_fd_sc_hd__a211oi_1 A1 A2 B1 C1 VGND VNB VPB VPWR Y
.ends

* Black-box entry subcircuit for sky130_fd_sc_hd__nor2_2 abstract view
.subckt sky130_fd_sc_hd__nor2_2 A B VGND VNB VPB VPWR Y
.ends

* Black-box entry subcircuit for sky130_fd_sc_hd__o21ba_1 abstract view
.subckt sky130_fd_sc_hd__o21ba_1 A1 A2 B1_N VGND VNB VPB VPWR X
.ends

* Black-box entry subcircuit for sky130_fd_sc_hd__a211o_2 abstract view
.subckt sky130_fd_sc_hd__a211o_2 A1 A2 B1 C1 VGND VNB VPB VPWR X
.ends

* Black-box entry subcircuit for sky130_fd_sc_hd__a32o_2 abstract view
.subckt sky130_fd_sc_hd__a32o_2 A1 A2 A3 B1 B2 VGND VNB VPB VPWR X
.ends

* Black-box entry subcircuit for sky130_fd_sc_hd__a31oi_1 abstract view
.subckt sky130_fd_sc_hd__a31oi_1 A1 A2 A3 B1 VGND VNB VPB VPWR Y
.ends

* Black-box entry subcircuit for sky130_fd_sc_hd__nor3_2 abstract view
.subckt sky130_fd_sc_hd__nor3_2 A B C VGND VNB VPB VPWR Y
.ends

* Black-box entry subcircuit for sky130_fd_sc_hd__o21ai_2 abstract view
.subckt sky130_fd_sc_hd__o21ai_2 A1 A2 B1 VGND VNB VPB VPWR Y
.ends

* Black-box entry subcircuit for sky130_fd_sc_hd__o41a_1 abstract view
.subckt sky130_fd_sc_hd__o41a_1 A1 A2 A3 A4 B1 VGND VNB VPB VPWR X
.ends

* Black-box entry subcircuit for sky130_fd_sc_hd__nor4_2 abstract view
.subckt sky130_fd_sc_hd__nor4_2 A B C D VGND VNB VPB VPWR Y
.ends

* Black-box entry subcircuit for sky130_fd_sc_hd__a311o_1 abstract view
.subckt sky130_fd_sc_hd__a311o_1 A1 A2 A3 B1 C1 VGND VNB VPB VPWR X
.ends

* Black-box entry subcircuit for sky130_fd_sc_hd__a21oi_4 abstract view
.subckt sky130_fd_sc_hd__a21oi_4 A1 A2 B1 VGND VNB VPB VPWR Y
.ends

* Black-box entry subcircuit for sky130_fd_sc_hd__nand3_4 abstract view
.subckt sky130_fd_sc_hd__nand3_4 A B C VGND VNB VPB VPWR Y
.ends

* Black-box entry subcircuit for sky130_fd_sc_hd__nor3b_4 abstract view
.subckt sky130_fd_sc_hd__nor3b_4 A B C_N VGND VNB VPB VPWR Y
.ends

* Black-box entry subcircuit for sky130_fd_sc_hd__nand3b_4 abstract view
.subckt sky130_fd_sc_hd__nand3b_4 A_N B C VGND VNB VPB VPWR Y
.ends

* Black-box entry subcircuit for sky130_fd_sc_hd__and3_4 abstract view
.subckt sky130_fd_sc_hd__and3_4 A B C VGND VNB VPB VPWR X
.ends

* Black-box entry subcircuit for sky130_fd_sc_hd__or4_1 abstract view
.subckt sky130_fd_sc_hd__or4_1 A B C D VGND VNB VPB VPWR X
.ends

* Black-box entry subcircuit for sky130_fd_sc_hd__a22oi_2 abstract view
.subckt sky130_fd_sc_hd__a22oi_2 A1 A2 B1 B2 VGND VNB VPB VPWR Y
.ends

* Black-box entry subcircuit for sky130_fd_sc_hd__nand2b_2 abstract view
.subckt sky130_fd_sc_hd__nand2b_2 A_N B VGND VNB VPB VPWR Y
.ends

* Black-box entry subcircuit for sky130_fd_sc_hd__o22ai_1 abstract view
.subckt sky130_fd_sc_hd__o22ai_1 A1 A2 B1 B2 VGND VNB VPB VPWR Y
.ends

* Black-box entry subcircuit for sky130_fd_sc_hd__o31a_1 abstract view
.subckt sky130_fd_sc_hd__o31a_1 A1 A2 A3 B1 VGND VNB VPB VPWR X
.ends

* Black-box entry subcircuit for sky130_fd_sc_hd__mux2_2 abstract view
.subckt sky130_fd_sc_hd__mux2_2 A0 A1 S VGND VNB VPB VPWR X
.ends

* Black-box entry subcircuit for sky130_fd_sc_hd__a41o_1 abstract view
.subckt sky130_fd_sc_hd__a41o_1 A1 A2 A3 A4 B1 VGND VNB VPB VPWR X
.ends

* Black-box entry subcircuit for sky130_fd_sc_hd__o311a_4 abstract view
.subckt sky130_fd_sc_hd__o311a_4 A1 A2 A3 B1 C1 VGND VNB VPB VPWR X
.ends

* Black-box entry subcircuit for sky130_fd_sc_hd__o31ai_1 abstract view
.subckt sky130_fd_sc_hd__o31ai_1 A1 A2 A3 B1 VGND VNB VPB VPWR Y
.ends

* Black-box entry subcircuit for sky130_fd_sc_hd__and2b_4 abstract view
.subckt sky130_fd_sc_hd__and2b_4 A_N B VGND VNB VPB VPWR X
.ends

* Black-box entry subcircuit for sky130_fd_sc_hd__o32a_1 abstract view
.subckt sky130_fd_sc_hd__o32a_1 A1 A2 A3 B1 B2 VGND VNB VPB VPWR X
.ends

* Black-box entry subcircuit for sky130_fd_sc_hd__buf_8 abstract view
.subckt sky130_fd_sc_hd__buf_8 A VGND VNB VPB VPWR X
.ends

* Black-box entry subcircuit for sky130_fd_sc_hd__a211oi_4 abstract view
.subckt sky130_fd_sc_hd__a211oi_4 A1 A2 B1 C1 VGND VNB VPB VPWR Y
.ends

* Black-box entry subcircuit for sky130_fd_sc_hd__o311a_1 abstract view
.subckt sky130_fd_sc_hd__o311a_1 A1 A2 A3 B1 C1 VGND VNB VPB VPWR X
.ends

* Black-box entry subcircuit for sky130_fd_sc_hd__nand2_8 abstract view
.subckt sky130_fd_sc_hd__nand2_8 A B VGND VNB VPB VPWR Y
.ends

* Black-box entry subcircuit for sky130_fd_sc_hd__and4b_2 abstract view
.subckt sky130_fd_sc_hd__and4b_2 A_N B C D VGND VNB VPB VPWR X
.ends

* Black-box entry subcircuit for sky130_fd_sc_hd__o21a_2 abstract view
.subckt sky130_fd_sc_hd__o21a_2 A1 A2 B1 VGND VNB VPB VPWR X
.ends

* Black-box entry subcircuit for sky130_fd_sc_hd__or4b_2 abstract view
.subckt sky130_fd_sc_hd__or4b_2 A B C D_N VGND VNB VPB VPWR X
.ends

* Black-box entry subcircuit for sky130_fd_sc_hd__nor3_4 abstract view
.subckt sky130_fd_sc_hd__nor3_4 A B C VGND VNB VPB VPWR Y
.ends

* Black-box entry subcircuit for sky130_fd_sc_hd__and4_2 abstract view
.subckt sky130_fd_sc_hd__and4_2 A B C D VGND VNB VPB VPWR X
.ends

* Black-box entry subcircuit for sky130_fd_sc_hd__nor4b_1 abstract view
.subckt sky130_fd_sc_hd__nor4b_1 A B C D_N VGND VNB VPB VPWR Y
.ends

* Black-box entry subcircuit for sky130_fd_sc_hd__o221ai_1 abstract view
.subckt sky130_fd_sc_hd__o221ai_1 A1 A2 B1 B2 C1 VGND VNB VPB VPWR Y
.ends

* Black-box entry subcircuit for sky130_fd_sc_hd__o31ai_2 abstract view
.subckt sky130_fd_sc_hd__o31ai_2 A1 A2 A3 B1 VGND VNB VPB VPWR Y
.ends

* Black-box entry subcircuit for sky130_fd_sc_hd__a41oi_1 abstract view
.subckt sky130_fd_sc_hd__a41oi_1 A1 A2 A3 A4 B1 VGND VNB VPB VPWR Y
.ends

* Black-box entry subcircuit for sky130_fd_sc_hd__o41ai_1 abstract view
.subckt sky130_fd_sc_hd__o41ai_1 A1 A2 A3 A4 B1 VGND VNB VPB VPWR Y
.ends

* Black-box entry subcircuit for sky130_fd_sc_hd__or4_4 abstract view
.subckt sky130_fd_sc_hd__or4_4 A B C D VGND VNB VPB VPWR X
.ends

* Black-box entry subcircuit for sky130_fd_sc_hd__a21o_2 abstract view
.subckt sky130_fd_sc_hd__a21o_2 A1 A2 B1 VGND VNB VPB VPWR X
.ends

* Black-box entry subcircuit for sky130_fd_sc_hd__o21ai_4 abstract view
.subckt sky130_fd_sc_hd__o21ai_4 A1 A2 B1 VGND VNB VPB VPWR Y
.ends

* Black-box entry subcircuit for sky130_fd_sc_hd__or3_4 abstract view
.subckt sky130_fd_sc_hd__or3_4 A B C VGND VNB VPB VPWR X
.ends

* Black-box entry subcircuit for sky130_fd_sc_hd__or4b_1 abstract view
.subckt sky130_fd_sc_hd__or4b_1 A B C D_N VGND VNB VPB VPWR X
.ends

* Black-box entry subcircuit for sky130_fd_sc_hd__a32oi_4 abstract view
.subckt sky130_fd_sc_hd__a32oi_4 A1 A2 A3 B1 B2 VGND VNB VPB VPWR Y
.ends

* Black-box entry subcircuit for sky130_fd_sc_hd__a2111oi_1 abstract view
.subckt sky130_fd_sc_hd__a2111oi_1 A1 A2 B1 C1 D1 VGND VNB VPB VPWR Y
.ends

* Black-box entry subcircuit for sky130_fd_sc_hd__a31oi_2 abstract view
.subckt sky130_fd_sc_hd__a31oi_2 A1 A2 A3 B1 VGND VNB VPB VPWR Y
.ends

* Black-box entry subcircuit for sky130_fd_sc_hd__nor4_4 abstract view
.subckt sky130_fd_sc_hd__nor4_4 A B C D VGND VNB VPB VPWR Y
.ends

* Black-box entry subcircuit for sky130_fd_sc_hd__and2_4 abstract view
.subckt sky130_fd_sc_hd__and2_4 A B VGND VNB VPB VPWR X
.ends

* Black-box entry subcircuit for sky130_fd_sc_hd__nor3b_2 abstract view
.subckt sky130_fd_sc_hd__nor3b_2 A B C_N VGND VNB VPB VPWR Y
.ends

* Black-box entry subcircuit for sky130_fd_sc_hd__o2111ai_2 abstract view
.subckt sky130_fd_sc_hd__o2111ai_2 A1 A2 B1 C1 D1 VGND VNB VPB VPWR Y
.ends

* Black-box entry subcircuit for sky130_fd_sc_hd__or3b_2 abstract view
.subckt sky130_fd_sc_hd__or3b_2 A B C_N VGND VNB VPB VPWR X
.ends

* Black-box entry subcircuit for sky130_fd_sc_hd__a311oi_4 abstract view
.subckt sky130_fd_sc_hd__a311oi_4 A1 A2 A3 B1 C1 VGND VNB VPB VPWR Y
.ends

* Black-box entry subcircuit for sky130_fd_sc_hd__a41oi_4 abstract view
.subckt sky130_fd_sc_hd__a41oi_4 A1 A2 A3 A4 B1 VGND VNB VPB VPWR Y
.ends

* Black-box entry subcircuit for sky130_fd_sc_hd__nand2b_4 abstract view
.subckt sky130_fd_sc_hd__nand2b_4 A_N B VGND VNB VPB VPWR Y
.ends

* Black-box entry subcircuit for sky130_fd_sc_hd__and3b_2 abstract view
.subckt sky130_fd_sc_hd__and3b_2 A_N B C VGND VNB VPB VPWR X
.ends

.subckt end_pipe_m busy_o clk_i depth_mport_i[0] depth_mport_i[10] depth_mport_i[11]
+ depth_mport_i[12] depth_mport_i[13] depth_mport_i[14] depth_mport_i[15] depth_mport_i[16]
+ depth_mport_i[17] depth_mport_i[18] depth_mport_i[19] depth_mport_i[1] depth_mport_i[20]
+ depth_mport_i[21] depth_mport_i[22] depth_mport_i[23] depth_mport_i[24] depth_mport_i[25]
+ depth_mport_i[26] depth_mport_i[27] depth_mport_i[28] depth_mport_i[29] depth_mport_i[2]
+ depth_mport_i[30] depth_mport_i[31] depth_mport_i[32] depth_mport_i[33] depth_mport_i[3]
+ depth_mport_i[4] depth_mport_i[5] depth_mport_i[6] depth_mport_i[7] depth_mport_i[8]
+ depth_mport_i[9] depth_mport_o[0] depth_mport_o[10] depth_mport_o[11] depth_mport_o[12]
+ depth_mport_o[13] depth_mport_o[14] depth_mport_o[15] depth_mport_o[16] depth_mport_o[17]
+ depth_mport_o[18] depth_mport_o[19] depth_mport_o[1] depth_mport_o[20] depth_mport_o[21]
+ depth_mport_o[22] depth_mport_o[23] depth_mport_o[24] depth_mport_o[25] depth_mport_o[26]
+ depth_mport_o[27] depth_mport_o[28] depth_mport_o[29] depth_mport_o[2] depth_mport_o[30]
+ depth_mport_o[31] depth_mport_o[32] depth_mport_o[33] depth_mport_o[34] depth_mport_o[35]
+ depth_mport_o[36] depth_mport_o[37] depth_mport_o[38] depth_mport_o[39] depth_mport_o[3]
+ depth_mport_o[40] depth_mport_o[41] depth_mport_o[42] depth_mport_o[43] depth_mport_o[44]
+ depth_mport_o[45] depth_mport_o[46] depth_mport_o[47] depth_mport_o[48] depth_mport_o[49]
+ depth_mport_o[4] depth_mport_o[50] depth_mport_o[51] depth_mport_o[52] depth_mport_o[53]
+ depth_mport_o[54] depth_mport_o[55] depth_mport_o[56] depth_mport_o[57] depth_mport_o[58]
+ depth_mport_o[59] depth_mport_o[5] depth_mport_o[60] depth_mport_o[61] depth_mport_o[62]
+ depth_mport_o[63] depth_mport_o[64] depth_mport_o[65] depth_mport_o[66] depth_mport_o[67]
+ depth_mport_o[68] depth_mport_o[6] depth_mport_o[7] depth_mport_o[8] depth_mport_o[9]
+ fb_i filt_depth_fly_o nrst_i pix_mport_i[0] pix_mport_i[10] pix_mport_i[11] pix_mport_i[12]
+ pix_mport_i[13] pix_mport_i[14] pix_mport_i[15] pix_mport_i[16] pix_mport_i[17]
+ pix_mport_i[18] pix_mport_i[19] pix_mport_i[1] pix_mport_i[20] pix_mport_i[21] pix_mport_i[22]
+ pix_mport_i[23] pix_mport_i[24] pix_mport_i[25] pix_mport_i[26] pix_mport_i[27]
+ pix_mport_i[28] pix_mport_i[29] pix_mport_i[2] pix_mport_i[30] pix_mport_i[31] pix_mport_i[32]
+ pix_mport_i[33] pix_mport_i[3] pix_mport_i[4] pix_mport_i[5] pix_mport_i[6] pix_mport_i[7]
+ pix_mport_i[8] pix_mport_i[9] pix_mport_o[0] pix_mport_o[10] pix_mport_o[11] pix_mport_o[12]
+ pix_mport_o[13] pix_mport_o[14] pix_mport_o[15] pix_mport_o[16] pix_mport_o[17]
+ pix_mport_o[18] pix_mport_o[19] pix_mport_o[1] pix_mport_o[20] pix_mport_o[21] pix_mport_o[22]
+ pix_mport_o[23] pix_mport_o[24] pix_mport_o[25] pix_mport_o[26] pix_mport_o[27]
+ pix_mport_o[28] pix_mport_o[29] pix_mport_o[2] pix_mport_o[30] pix_mport_o[31] pix_mport_o[32]
+ pix_mport_o[33] pix_mport_o[34] pix_mport_o[35] pix_mport_o[36] pix_mport_o[37]
+ pix_mport_o[38] pix_mport_o[39] pix_mport_o[3] pix_mport_o[40] pix_mport_o[41] pix_mport_o[42]
+ pix_mport_o[43] pix_mport_o[44] pix_mport_o[45] pix_mport_o[46] pix_mport_o[47]
+ pix_mport_o[48] pix_mport_o[49] pix_mport_o[4] pix_mport_o[50] pix_mport_o[51] pix_mport_o[52]
+ pix_mport_o[53] pix_mport_o[54] pix_mport_o[55] pix_mport_o[56] pix_mport_o[57]
+ pix_mport_o[58] pix_mport_o[59] pix_mport_o[5] pix_mport_o[60] pix_mport_o[61] pix_mport_o[62]
+ pix_mport_o[63] pix_mport_o[64] pix_mport_o[65] pix_mport_o[66] pix_mport_o[67]
+ pix_mport_o[68] pix_mport_o[6] pix_mport_o[7] pix_mport_o[8] pix_mport_o[9] sstream_i[0]
+ sstream_i[100] sstream_i[101] sstream_i[102] sstream_i[103] sstream_i[104] sstream_i[105]
+ sstream_i[106] sstream_i[107] sstream_i[108] sstream_i[109] sstream_i[10] sstream_i[110]
+ sstream_i[111] sstream_i[112] sstream_i[113] sstream_i[114] sstream_i[115] sstream_i[11]
+ sstream_i[12] sstream_i[13] sstream_i[14] sstream_i[15] sstream_i[16] sstream_i[17]
+ sstream_i[18] sstream_i[19] sstream_i[1] sstream_i[20] sstream_i[21] sstream_i[22]
+ sstream_i[23] sstream_i[24] sstream_i[25] sstream_i[26] sstream_i[27] sstream_i[28]
+ sstream_i[29] sstream_i[2] sstream_i[30] sstream_i[31] sstream_i[32] sstream_i[33]
+ sstream_i[34] sstream_i[35] sstream_i[36] sstream_i[37] sstream_i[38] sstream_i[39]
+ sstream_i[3] sstream_i[40] sstream_i[41] sstream_i[42] sstream_i[43] sstream_i[44]
+ sstream_i[45] sstream_i[46] sstream_i[47] sstream_i[48] sstream_i[49] sstream_i[4]
+ sstream_i[50] sstream_i[51] sstream_i[52] sstream_i[53] sstream_i[54] sstream_i[55]
+ sstream_i[56] sstream_i[57] sstream_i[58] sstream_i[59] sstream_i[5] sstream_i[60]
+ sstream_i[61] sstream_i[62] sstream_i[63] sstream_i[64] sstream_i[65] sstream_i[66]
+ sstream_i[67] sstream_i[68] sstream_i[69] sstream_i[6] sstream_i[70] sstream_i[71]
+ sstream_i[72] sstream_i[73] sstream_i[74] sstream_i[75] sstream_i[76] sstream_i[77]
+ sstream_i[78] sstream_i[79] sstream_i[7] sstream_i[80] sstream_i[81] sstream_i[82]
+ sstream_i[83] sstream_i[84] sstream_i[85] sstream_i[86] sstream_i[87] sstream_i[88]
+ sstream_i[89] sstream_i[8] sstream_i[90] sstream_i[91] sstream_i[92] sstream_i[93]
+ sstream_i[94] sstream_i[95] sstream_i[96] sstream_i[97] sstream_i[98] sstream_i[99]
+ sstream_i[9] sstream_o tex_addr_i[0] tex_addr_i[10] tex_addr_i[11] tex_addr_i[12]
+ tex_addr_i[13] tex_addr_i[14] tex_addr_i[15] tex_addr_i[16] tex_addr_i[17] tex_addr_i[18]
+ tex_addr_i[19] tex_addr_i[1] tex_addr_i[20] tex_addr_i[21] tex_addr_i[22] tex_addr_i[23]
+ tex_addr_i[24] tex_addr_i[25] tex_addr_i[26] tex_addr_i[27] tex_addr_i[28] tex_addr_i[29]
+ tex_addr_i[2] tex_addr_i[30] tex_addr_i[31] tex_addr_i[3] tex_addr_i[4] tex_addr_i[5]
+ tex_addr_i[6] tex_addr_i[7] tex_addr_i[8] tex_addr_i[9] tex_fly_o tex_height_i[0]
+ tex_height_i[10] tex_height_i[11] tex_height_i[12] tex_height_i[13] tex_height_i[14]
+ tex_height_i[15] tex_height_i[1] tex_height_i[2] tex_height_i[3] tex_height_i[4]
+ tex_height_i[5] tex_height_i[6] tex_height_i[7] tex_height_i[8] tex_height_i[9]
+ tex_mport_i[0] tex_mport_i[10] tex_mport_i[11] tex_mport_i[12] tex_mport_i[13] tex_mport_i[14]
+ tex_mport_i[15] tex_mport_i[16] tex_mport_i[17] tex_mport_i[18] tex_mport_i[19]
+ tex_mport_i[1] tex_mport_i[20] tex_mport_i[21] tex_mport_i[22] tex_mport_i[23] tex_mport_i[24]
+ tex_mport_i[25] tex_mport_i[26] tex_mport_i[27] tex_mport_i[28] tex_mport_i[29]
+ tex_mport_i[2] tex_mport_i[30] tex_mport_i[31] tex_mport_i[32] tex_mport_i[33] tex_mport_i[3]
+ tex_mport_i[4] tex_mport_i[5] tex_mport_i[6] tex_mport_i[7] tex_mport_i[8] tex_mport_i[9]
+ tex_mport_o[0] tex_mport_o[10] tex_mport_o[11] tex_mport_o[12] tex_mport_o[13] tex_mport_o[14]
+ tex_mport_o[15] tex_mport_o[16] tex_mport_o[17] tex_mport_o[18] tex_mport_o[19]
+ tex_mport_o[1] tex_mport_o[20] tex_mport_o[21] tex_mport_o[22] tex_mport_o[23] tex_mport_o[24]
+ tex_mport_o[25] tex_mport_o[26] tex_mport_o[27] tex_mport_o[28] tex_mport_o[29]
+ tex_mport_o[2] tex_mport_o[30] tex_mport_o[31] tex_mport_o[32] tex_mport_o[33] tex_mport_o[34]
+ tex_mport_o[35] tex_mport_o[36] tex_mport_o[37] tex_mport_o[38] tex_mport_o[39]
+ tex_mport_o[3] tex_mport_o[40] tex_mport_o[41] tex_mport_o[42] tex_mport_o[43] tex_mport_o[44]
+ tex_mport_o[45] tex_mport_o[46] tex_mport_o[47] tex_mport_o[48] tex_mport_o[49]
+ tex_mport_o[4] tex_mport_o[50] tex_mport_o[51] tex_mport_o[52] tex_mport_o[53] tex_mport_o[54]
+ tex_mport_o[55] tex_mport_o[56] tex_mport_o[57] tex_mport_o[58] tex_mport_o[59]
+ tex_mport_o[5] tex_mport_o[60] tex_mport_o[61] tex_mport_o[62] tex_mport_o[63] tex_mport_o[64]
+ tex_mport_o[65] tex_mport_o[66] tex_mport_o[67] tex_mport_o[68] tex_mport_o[6] tex_mport_o[7]
+ tex_mport_o[8] tex_mport_o[9] tex_width_i[0] tex_width_i[10] tex_width_i[11] tex_width_i[12]
+ tex_width_i[13] tex_width_i[14] tex_width_i[15] tex_width_i[1] tex_width_i[2] tex_width_i[3]
+ tex_width_i[4] tex_width_i[5] tex_width_i[6] tex_width_i[7] tex_width_i[8] tex_width_i[9]
+ vccd1 vssd1
X_6914_ vssd1 vssd1 vccd1 vccd1 _6914_/HI pix_mport_o[15] sky130_fd_sc_hd__conb_1
XFILLER_0_134_72 vssd1 vssd1 vccd1 vccd1 sky130_fd_sc_hd__fill_2
XANTENNA__4373__C _4614_/C vssd1 vssd1 vccd1 vccd1 sky130_fd_sc_hd__diode_2
XFILLER_0_76_133 vssd1 vssd1 vccd1 vccd1 sky130_fd_sc_hd__decap_4
XFILLER_0_76_122 vssd1 vssd1 vccd1 vccd1 sky130_fd_sc_hd__fill_2
X_6845_ _6862_/CLK _6845_/D vssd1 vssd1 vccd1 vccd1 _6845_/Q sky130_fd_sc_hd__dfxtp_1
XANTENNA__4092__D _4841_/C vssd1 vssd1 vccd1 vccd1 sky130_fd_sc_hd__diode_2
XFILLER_0_76_155 vssd1 vssd1 vccd1 vccd1 sky130_fd_sc_hd__fill_1
XANTENNA__5766__A _5766_/A vssd1 vssd1 vccd1 vccd1 sky130_fd_sc_hd__diode_2
XFILLER_0_43_70 vssd1 vssd1 vccd1 vccd1 sky130_fd_sc_hd__fill_2
X_6776_ _6832_/CLK _6776_/D fanout152/X vssd1 vssd1 vccd1 vccd1 pix_mport_o[48] sky130_fd_sc_hd__dfrtp_4
X_3988_ _3989_/A _3989_/B _3989_/C vssd1 vssd1 vccd1 vccd1 _3988_/X sky130_fd_sc_hd__and3_1
XFILLER_0_57_391 vssd1 vssd1 vccd1 vccd1 sky130_fd_sc_hd__fill_1
X_5727_ _5727_/A _5727_/B vssd1 vssd1 vccd1 vccd1 _5727_/Y sky130_fd_sc_hd__xnor2_1
XFILLER_0_17_233 vssd1 vssd1 vccd1 vccd1 sky130_fd_sc_hd__fill_1
XANTENNA__4943__A2 _5083_/A vssd1 vssd1 vccd1 vccd1 sky130_fd_sc_hd__diode_2
XFILLER_0_134_249 vssd1 vssd1 vccd1 vccd1 sky130_fd_sc_hd__decap_3
XFILLER_0_17_266 vssd1 vssd1 vccd1 vccd1 sky130_fd_sc_hd__fill_1
X_5658_ _5657_/Y _6508_/Q _5802_/B vssd1 vssd1 vccd1 vccd1 _5660_/B sky130_fd_sc_hd__mux2_1
X_5589_ tex_mport_o[54] _5576_/S _5588_/X vssd1 vssd1 vccd1 vccd1 _6611_/D sky130_fd_sc_hd__a21o_1
X_4609_ _4609_/A _4609_/B vssd1 vssd1 vccd1 vccd1 _5364_/A sky130_fd_sc_hd__xor2_2
XFILLER_0_7_81 vssd1 vssd1 vccd1 vccd1 sky130_ef_sc_hd__decap_12
XANTENNA_fanout75_A _4841_/C vssd1 vssd1 vccd1 vccd1 sky130_fd_sc_hd__diode_2
XANTENNA__5120__A2 _5083_/B vssd1 vssd1 vccd1 vccd1 sky130_fd_sc_hd__diode_2
XFILLER_0_99_225 vssd1 vssd1 vccd1 vccd1 sky130_fd_sc_hd__fill_2
XFILLER_0_67_111 vssd1 vssd1 vccd1 vccd1 sky130_fd_sc_hd__fill_1
XANTENNA__3434__A2 _5276_/B vssd1 vssd1 vccd1 vccd1 sky130_fd_sc_hd__diode_2
XANTENNA__5187__A2 _4488_/A vssd1 vssd1 vccd1 vccd1 sky130_fd_sc_hd__diode_2
XFILLER_0_70_309 vssd1 vssd1 vccd1 vccd1 sky130_fd_sc_hd__fill_2
XFILLER_0_133_260 vssd1 vssd1 vccd1 vccd1 sky130_fd_sc_hd__decap_3
XFILLER_0_23_225 vssd1 vssd1 vccd1 vccd1 sky130_fd_sc_hd__fill_1
XFILLER_0_23_269 vssd1 vssd1 vccd1 vccd1 sky130_fd_sc_hd__fill_1
XFILLER_0_3_39 vssd1 vssd1 vccd1 vccd1 sky130_ef_sc_hd__decap_12
XANTENNA_clkbuf_leaf_14_clk_i_A clkbuf_2_3__f_clk_i/X vssd1 vssd1 vccd1 vccd1 sky130_fd_sc_hd__diode_2
XANTENNA__4474__B _4551_/D vssd1 vssd1 vccd1 vccd1 sky130_fd_sc_hd__diode_2
XFILLER_0_98_291 vssd1 vssd1 vccd1 vccd1 sky130_fd_sc_hd__decap_4
XANTENNA__4193__C _4527_/B vssd1 vssd1 vccd1 vccd1 sky130_fd_sc_hd__diode_2
X_4960_ _6674_/Q _5083_/B _5086_/A _4960_/D vssd1 vssd1 vccd1 vccd1 _5086_/B sky130_fd_sc_hd__nand4_1
X_3911_ _5801_/A _4970_/B _4966_/B _4832_/C vssd1 vssd1 vccd1 vccd1 _3912_/C sky130_fd_sc_hd__a22o_1
X_4891_ _4890_/B _4890_/C _4890_/A vssd1 vssd1 vccd1 vccd1 _4891_/Y sky130_fd_sc_hd__a21oi_1
XFILLER_0_58_166 vssd1 vssd1 vccd1 vccd1 sky130_fd_sc_hd__fill_1
X_6630_ _6802_/CLK _6630_/D fanout142/X vssd1 vssd1 vccd1 vccd1 _6630_/Q sky130_fd_sc_hd__dfstp_1
XFILLER_0_13_51 vssd1 vssd1 vccd1 vccd1 sky130_fd_sc_hd__decap_4
X_3842_ _3999_/A _6684_/Q _3827_/X _3830_/B vssd1 vssd1 vccd1 vccd1 _3843_/B sky130_fd_sc_hd__a211o_1
XFILLER_0_58_188 vssd1 vssd1 vccd1 vccd1 sky130_fd_sc_hd__fill_2
X_6561_ _6853_/CLK _6561_/D _5468_/A vssd1 vssd1 vccd1 vccd1 depth_mport_o[5] sky130_fd_sc_hd__dfrtp_4
XFILLER_0_73_169 vssd1 vssd1 vccd1 vccd1 sky130_ef_sc_hd__decap_12
X_5512_ hold70/X sstream_i[103] _6473_/S vssd1 vssd1 vccd1 vccd1 _6545_/D sky130_fd_sc_hd__mux2_1
XFILLER_0_116_249 vssd1 vssd1 vccd1 vccd1 sky130_fd_sc_hd__decap_3
XFILLER_0_116_238 vssd1 vssd1 vccd1 vccd1 sky130_fd_sc_hd__fill_2
XFILLER_0_14_214 vssd1 vssd1 vccd1 vccd1 sky130_fd_sc_hd__decap_6
X_3773_ _3774_/A _3774_/B vssd1 vssd1 vccd1 vccd1 _3773_/X sky130_fd_sc_hd__or2_1
XANTENNA__4925__A2 _4488_/A vssd1 vssd1 vccd1 vccd1 sky130_fd_sc_hd__diode_2
X_6492_ hold19/X sstream_i[50] _6501_/S vssd1 vssd1 vccd1 vccd1 _6883_/D sky130_fd_sc_hd__mux2_1
XANTENNA__4138__B1 _4841_/D vssd1 vssd1 vccd1 vccd1 sky130_fd_sc_hd__diode_2
X_5443_ _6748_/Q _5444_/B vssd1 vssd1 vccd1 vccd1 _5443_/Y sky130_fd_sc_hd__nor2_1
X_5374_ _6721_/Q _5561_/B vssd1 vssd1 vccd1 vccd1 _5380_/B sky130_fd_sc_hd__xnor2_1
X_4325_ _5701_/A tex_width_i[5] _4614_/C _4582_/D vssd1 vssd1 vccd1 vccd1 _4328_/A
+ sky130_fd_sc_hd__nand4_1
XANTENNA__3361__A1 _5049_/A vssd1 vssd1 vccd1 vccd1 sky130_fd_sc_hd__diode_2
Xfanout127 _5754_/A vssd1 vssd1 vccd1 vccd1 _5272_/A sky130_fd_sc_hd__buf_4
Xfanout116 tex_width_i[1] vssd1 vssd1 vccd1 vccd1 _4789_/C sky130_fd_sc_hd__buf_4
Xfanout138 tex_width_i[0] vssd1 vssd1 vccd1 vccd1 _4789_/B sky130_fd_sc_hd__buf_4
Xfanout105 _5106_/A vssd1 vssd1 vccd1 vccd1 _4488_/A sky130_fd_sc_hd__buf_4
Xfanout149 nrst_i vssd1 vssd1 vccd1 vccd1 fanout149/X sky130_fd_sc_hd__clkbuf_4
X_4256_ _4842_/A _5718_/B vssd1 vssd1 vccd1 vccd1 _4313_/A sky130_fd_sc_hd__nand2_1
X_4187_ _4187_/A _4187_/B vssd1 vssd1 vccd1 vccd1 _4196_/A sky130_fd_sc_hd__xnor2_2
XTAP_1129 vssd1 vccd1 sky130_fd_sc_hd__tapvpwrvgnd_1
XTAP_1118 vssd1 vccd1 sky130_fd_sc_hd__tapvpwrvgnd_1
XTAP_1107 vssd1 vccd1 sky130_fd_sc_hd__tapvpwrvgnd_1
XFILLER_0_49_111 vssd1 vssd1 vccd1 vccd1 sky130_fd_sc_hd__fill_1
XFILLER_0_92_401 vssd1 vssd1 vccd1 vccd1 sky130_fd_sc_hd__decap_6
X_6828_ _6832_/CLK _6828_/D fanout152/X vssd1 vssd1 vccd1 vccd1 depth_mport_o[50]
+ sky130_fd_sc_hd__dfrtp_4
XANTENNA__6091__S _6095_/S vssd1 vssd1 vccd1 vccd1 sky130_fd_sc_hd__diode_2
X_6759_ _6862_/CLK _6759_/D _5468_/A vssd1 vssd1 vccd1 vccd1 pix_mport_o[7] sky130_fd_sc_hd__dfrtp_4
XFILLER_0_45_350 vssd1 vssd1 vccd1 vccd1 sky130_fd_sc_hd__fill_2
XFILLER_0_60_353 vssd1 vssd1 vccd1 vccd1 sky130_fd_sc_hd__decap_4
XFILLER_0_60_397 vssd1 vssd1 vccd1 vccd1 sky130_fd_sc_hd__decap_8
Xhold170 _6516_/Q vssd1 vssd1 vccd1 vccd1 hold170/X sky130_fd_sc_hd__dlygate4sd3_1
Xhold181 _6550_/Q vssd1 vssd1 vccd1 vccd1 hold181/X sky130_fd_sc_hd__dlygate4sd3_1
Xhold192 _6631_/Q vssd1 vssd1 vccd1 vccd1 hold192/X sky130_fd_sc_hd__dlygate4sd3_1
XFILLER_0_18_29 vssd1 vssd1 vccd1 vccd1 sky130_fd_sc_hd__decap_8
XFILLER_0_138_363 vssd1 vssd1 vccd1 vccd1 sky130_fd_sc_hd__fill_1
XANTENNA__3638__B _5286_/A vssd1 vssd1 vccd1 vccd1 sky130_fd_sc_hd__diode_2
XFILLER_0_50_49 vssd1 vssd1 vccd1 vccd1 sky130_fd_sc_hd__decap_3
XANTENNA__4741__C _4794_/B vssd1 vssd1 vccd1 vccd1 sky130_fd_sc_hd__diode_2
XFILLER_0_36_361 vssd1 vssd1 vccd1 vccd1 sky130_fd_sc_hd__decap_3
XFILLER_0_70_139 vssd1 vssd1 vccd1 vccd1 sky130_fd_sc_hd__fill_1
XFILLER_0_63_180 vssd1 vssd1 vccd1 vccd1 sky130_fd_sc_hd__decap_3
XFILLER_0_75_24 vssd1 vssd1 vccd1 vccd1 sky130_fd_sc_hd__fill_2
X_4110_ _4110_/A _4110_/B vssd1 vssd1 vccd1 vccd1 _4119_/A sky130_fd_sc_hd__xnor2_1
X_5090_ _5091_/B _6682_/Q _5286_/B _5091_/A vssd1 vssd1 vccd1 vccd1 _5092_/A sky130_fd_sc_hd__a22oi_1
XFILLER_0_75_57 vssd1 vssd1 vccd1 vccd1 sky130_fd_sc_hd__fill_2
X_4041_ _4041_/A _4041_/B vssd1 vssd1 vccd1 vccd1 _4043_/A sky130_fd_sc_hd__nor2_1
XANTENNA__4843__A1 _5801_/A vssd1 vssd1 vccd1 vccd1 sky130_fd_sc_hd__diode_2
XANTENNA__4843__B2 _5787_/A vssd1 vssd1 vccd1 vccd1 sky130_fd_sc_hd__diode_2
XFILLER_0_78_239 vssd1 vssd1 vccd1 vccd1 sky130_fd_sc_hd__fill_2
X_5992_ _5991_/Y hold136/X _6000_/S vssd1 vssd1 vccd1 vccd1 _5992_/X sky130_fd_sc_hd__mux2_1
XFILLER_0_115_63 vssd1 vssd1 vccd1 vccd1 sky130_fd_sc_hd__fill_2
XFILLER_0_91_78 vssd1 vssd1 vccd1 vccd1 sky130_fd_sc_hd__fill_2
X_4943_ _4942_/A _5083_/A _5049_/D _4942_/B vssd1 vssd1 vccd1 vccd1 _4944_/D sky130_fd_sc_hd__a22o_1
XFILLER_0_115_74 vssd1 vssd1 vccd1 vccd1 sky130_fd_sc_hd__fill_2
XFILLER_0_46_125 vssd1 vssd1 vccd1 vccd1 sky130_fd_sc_hd__fill_1
XFILLER_0_129_385 vssd1 vssd1 vccd1 vccd1 sky130_fd_sc_hd__decap_6
X_6613_ _6792_/CLK _6613_/D fanout142/X vssd1 vssd1 vccd1 vccd1 tex_mport_o[56] sky130_fd_sc_hd__dfrtp_4
XFILLER_0_46_136 vssd1 vssd1 vccd1 vccd1 sky130_fd_sc_hd__fill_2
XFILLER_0_46_158 vssd1 vssd1 vccd1 vccd1 sky130_fd_sc_hd__decap_3
X_4874_ _4862_/A _4862_/C _4862_/B vssd1 vssd1 vccd1 vccd1 _4876_/B sky130_fd_sc_hd__a21o_1
XFILLER_0_6_222 vssd1 vssd1 vccd1 vccd1 sky130_fd_sc_hd__fill_2
X_3825_ _5327_/A _5276_/B _6686_/Q _5290_/A vssd1 vssd1 vccd1 vccd1 _3829_/D sky130_fd_sc_hd__a22o_1
XFILLER_0_27_350 vssd1 vssd1 vccd1 vccd1 sky130_fd_sc_hd__decap_8
XFILLER_0_61_117 vssd1 vssd1 vccd1 vccd1 sky130_fd_sc_hd__decap_3
X_6544_ _6862_/CLK _6544_/D vssd1 vssd1 vccd1 vccd1 hold7/A sky130_fd_sc_hd__dfxtp_2
X_3756_ _3756_/A _3756_/B vssd1 vssd1 vccd1 vccd1 _3757_/B sky130_fd_sc_hd__nor2_1
XFILLER_0_27_383 vssd1 vssd1 vccd1 vccd1 sky130_fd_sc_hd__decap_8
XANTENNA_fanout125_A _5766_/A vssd1 vssd1 vccd1 vccd1 sky130_fd_sc_hd__diode_2
XFILLER_0_40_82 vssd1 vssd1 vccd1 vccd1 sky130_fd_sc_hd__fill_2
X_6475_ hold121/X sstream_i[33] _6493_/S vssd1 vssd1 vccd1 vccd1 _6866_/D sky130_fd_sc_hd__mux2_1
XFILLER_0_71_3 vssd1 vssd1 vccd1 vccd1 sky130_fd_sc_hd__fill_2
X_3687_ _3687_/A _3687_/B vssd1 vssd1 vccd1 vccd1 _3691_/A sky130_fd_sc_hd__nand2_1
X_5426_ _5428_/B _5428_/C vssd1 vssd1 vccd1 vccd1 _5426_/X sky130_fd_sc_hd__and2_1
XANTENNA__4379__B _4476_/D vssd1 vssd1 vccd1 vccd1 sky130_fd_sc_hd__diode_2
X_5357_ _5357_/A _5357_/B vssd1 vssd1 vccd1 vccd1 _5583_/B sky130_fd_sc_hd__and2_1
X_4308_ _4303_/Y _4306_/Y _4248_/Y _4249_/X vssd1 vssd1 vccd1 vccd1 _4713_/B sky130_fd_sc_hd__a211oi_2
X_5288_ _5288_/A _5288_/B vssd1 vssd1 vccd1 vccd1 _5294_/A sky130_fd_sc_hd__xnor2_1
XANTENNA__6086__S _6098_/S vssd1 vssd1 vccd1 vccd1 sky130_fd_sc_hd__diode_2
X_4239_ _4237_/A _4237_/B _4264_/A vssd1 vssd1 vccd1 vccd1 _4240_/D sky130_fd_sc_hd__o21ai_1
XANTENNA__4834__A1 _4842_/A vssd1 vssd1 vccd1 vccd1 sky130_fd_sc_hd__diode_2
XANTENNA__4842__B _5787_/B vssd1 vssd1 vccd1 vccd1 sky130_fd_sc_hd__diode_2
XANTENNA__4062__A2 _4971_/D vssd1 vssd1 vccd1 vccd1 sky130_fd_sc_hd__diode_2
XANTENNA_fanout38_A _6682_/Q vssd1 vssd1 vccd1 vccd1 sky130_fd_sc_hd__diode_2
XANTENNA__3739__A _5049_/A vssd1 vssd1 vccd1 vccd1 sky130_fd_sc_hd__diode_2
XFILLER_0_37_103 vssd1 vssd1 vccd1 vccd1 sky130_fd_sc_hd__fill_2
XFILLER_0_77_294 vssd1 vssd1 vccd1 vccd1 sky130_fd_sc_hd__fill_2
XFILLER_0_37_147 vssd1 vssd1 vccd1 vccd1 sky130_fd_sc_hd__decap_3
XFILLER_0_92_275 vssd1 vssd1 vccd1 vccd1 sky130_fd_sc_hd__decap_4
XFILLER_0_92_253 vssd1 vssd1 vccd1 vccd1 sky130_fd_sc_hd__fill_2
XFILLER_0_18_361 vssd1 vssd1 vccd1 vccd1 sky130_fd_sc_hd__decap_3
XFILLER_0_37_169 vssd1 vssd1 vccd1 vccd1 sky130_fd_sc_hd__fill_1
XFILLER_0_135_355 vssd1 vssd1 vccd1 vccd1 sky130_ef_sc_hd__decap_12
XFILLER_0_18_372 vssd1 vssd1 vccd1 vccd1 sky130_ef_sc_hd__decap_12
XFILLER_0_60_150 vssd1 vssd1 vccd1 vccd1 sky130_fd_sc_hd__fill_2
XFILLER_0_103_230 vssd1 vssd1 vccd1 vccd1 sky130_fd_sc_hd__fill_1
XANTENNA__3474__A _5290_/A vssd1 vssd1 vccd1 vccd1 sky130_fd_sc_hd__diode_2
XFILLER_0_60_194 vssd1 vssd1 vccd1 vccd1 sky130_fd_sc_hd__fill_2
XFILLER_0_29_39 vssd1 vssd1 vccd1 vccd1 sky130_fd_sc_hd__fill_2
XFILLER_0_136_29 vssd1 vssd1 vccd1 vccd1 sky130_fd_sc_hd__fill_2
XANTENNA__4825__A1 _4966_/C vssd1 vssd1 vccd1 vccd1 sky130_fd_sc_hd__diode_2
XANTENNA__4736__C _5051_/B vssd1 vssd1 vccd1 vccd1 sky130_fd_sc_hd__diode_2
XFILLER_0_68_250 vssd1 vssd1 vccd1 vccd1 sky130_fd_sc_hd__fill_2
XFILLER_0_0_29 vssd1 vssd1 vccd1 vccd1 sky130_ef_sc_hd__decap_12
XFILLER_0_68_261 vssd1 vssd1 vccd1 vccd1 sky130_fd_sc_hd__fill_2
XFILLER_0_61_37 vssd1 vssd1 vccd1 vccd1 sky130_fd_sc_hd__fill_1
XFILLER_0_126_300 vssd1 vssd1 vccd1 vccd1 sky130_fd_sc_hd__fill_1
XANTENNA__5567__C _5588_/C vssd1 vssd1 vccd1 vccd1 sky130_fd_sc_hd__diode_2
XFILLER_0_83_220 vssd1 vssd1 vccd1 vccd1 sky130_fd_sc_hd__fill_2
XFILLER_0_28_136 vssd1 vssd1 vccd1 vccd1 sky130_fd_sc_hd__fill_1
XFILLER_0_138_182 vssd1 vssd1 vccd1 vccd1 sky130_fd_sc_hd__fill_2
XFILLER_0_16_309 vssd1 vssd1 vccd1 vccd1 sky130_fd_sc_hd__decap_4
XFILLER_0_43_106 vssd1 vssd1 vccd1 vccd1 sky130_fd_sc_hd__decap_4
X_4590_ _5666_/A _4637_/D _4588_/A _4589_/X vssd1 vssd1 vccd1 vccd1 _4600_/A sky130_fd_sc_hd__a31o_1
XFILLER_0_9_27 vssd1 vssd1 vccd1 vccd1 sky130_ef_sc_hd__decap_12
X_3610_ _3580_/X _3591_/Y _3608_/A _3607_/Y vssd1 vssd1 vccd1 vccd1 _3612_/B sky130_fd_sc_hd__a211oi_2
XFILLER_0_101_21 vssd1 vssd1 vccd1 vccd1 sky130_fd_sc_hd__fill_1
X_3541_ _3541_/A _3541_/B _3541_/C vssd1 vssd1 vccd1 vccd1 _3543_/A sky130_fd_sc_hd__and3_1
XFILLER_0_3_203 vssd1 vssd1 vccd1 vccd1 sky130_fd_sc_hd__decap_3
XFILLER_0_101_65 vssd1 vssd1 vccd1 vccd1 sky130_fd_sc_hd__fill_1
XFILLER_0_10_41 vssd1 vssd1 vccd1 vccd1 sky130_ef_sc_hd__decap_12
X_6260_ depth_mport_i[2] _3326_/Y depth_mport_i[1] _6259_/B vssd1 vssd1 vccd1 vccd1
+ _6260_/X sky130_fd_sc_hd__a22o_1
XFILLER_0_101_98 vssd1 vssd1 vccd1 vccd1 sky130_fd_sc_hd__decap_3
XFILLER_0_10_85 vssd1 vssd1 vccd1 vccd1 sky130_ef_sc_hd__decap_12
X_3472_ _3558_/A _3558_/B vssd1 vssd1 vccd1 vccd1 _3489_/B sky130_fd_sc_hd__and2_1
X_6191_ _6191_/A _6191_/B vssd1 vssd1 vccd1 vccd1 _6194_/B sky130_fd_sc_hd__nor2_1
XFILLER_0_86_23 vssd1 vssd1 vccd1 vccd1 sky130_fd_sc_hd__decap_4
X_5211_ _4004_/B _3996_/C _3996_/D _3996_/A vssd1 vssd1 vccd1 vccd1 _5211_/X sky130_fd_sc_hd__a22o_1
X_5142_ _5142_/A _5142_/B vssd1 vssd1 vccd1 vccd1 _5145_/B sky130_fd_sc_hd__xnor2_1
X_5073_ _5073_/A _5073_/B vssd1 vssd1 vccd1 vccd1 _5188_/B sky130_fd_sc_hd__xnor2_1
X_4024_ _5336_/A _4024_/B _5264_/C vssd1 vssd1 vccd1 vccd1 _5263_/A sky130_fd_sc_hd__or3_1
X_5975_ _4841_/C _5974_/X _6037_/S vssd1 vssd1 vccd1 vccd1 _6663_/D sky130_fd_sc_hd__mux2_1
XANTENNA__4381__C _4433_/D vssd1 vssd1 vccd1 vccd1 sky130_fd_sc_hd__diode_2
XFILLER_0_19_125 vssd1 vssd1 vccd1 vccd1 sky130_fd_sc_hd__decap_3
X_4926_ _4804_/Y _4926_/B vssd1 vssd1 vccd1 vccd1 _4933_/A sky130_fd_sc_hd__and2b_1
XFILLER_0_117_311 vssd1 vssd1 vccd1 vccd1 sky130_fd_sc_hd__fill_2
XFILLER_0_74_253 vssd1 vssd1 vccd1 vccd1 sky130_fd_sc_hd__fill_1
XFILLER_0_19_169 vssd1 vssd1 vccd1 vccd1 sky130_fd_sc_hd__fill_2
X_4857_ _4844_/A _4844_/C _4844_/B vssd1 vssd1 vccd1 vccd1 _4859_/B sky130_fd_sc_hd__a21o_1
XFILLER_0_74_297 vssd1 vssd1 vccd1 vccd1 sky130_fd_sc_hd__decap_8
X_3808_ _5277_/A _5320_/A _3725_/C _3725_/D vssd1 vssd1 vccd1 vccd1 _3809_/C sky130_fd_sc_hd__a22o_1
X_6527_ _6841_/CLK _6527_/D vssd1 vssd1 vccd1 vccd1 hold8/A sky130_fd_sc_hd__dfxtp_1
X_4788_ _5071_/A _4789_/C _5064_/B _4789_/B vssd1 vssd1 vccd1 vccd1 _4790_/A sky130_fd_sc_hd__a22oi_1
X_3739_ _5049_/A _5049_/B _5300_/B _5106_/B vssd1 vssd1 vccd1 vccd1 _3739_/X sky130_fd_sc_hd__and4_1
X_6458_ hold153/X sstream_i[16] _6472_/S vssd1 vssd1 vccd1 vccd1 _6849_/D sky130_fd_sc_hd__mux2_1
X_6389_ _6402_/A _6388_/C _6375_/A vssd1 vssd1 vccd1 vccd1 _6390_/B sky130_fd_sc_hd__a21boi_1
X_5409_ _5358_/A _5583_/B _5402_/X _5407_/Y _5408_/Y vssd1 vssd1 vccd1 vccd1 _5409_/X
+ sky130_fd_sc_hd__o2111a_1
XANTENNA__4035__A2 _5718_/B vssd1 vssd1 vccd1 vccd1 sky130_fd_sc_hd__diode_2
XFILLER_0_65_220 vssd1 vssd1 vccd1 vccd1 sky130_fd_sc_hd__fill_2
XFILLER_0_65_264 vssd1 vssd1 vccd1 vccd1 sky130_fd_sc_hd__decap_3
XFILLER_0_108_377 vssd1 vssd1 vccd1 vccd1 sky130_ef_sc_hd__decap_12
XFILLER_0_18_180 vssd1 vssd1 vccd1 vccd1 sky130_fd_sc_hd__decap_6
XFILLER_0_21_389 vssd1 vssd1 vccd1 vccd1 sky130_fd_sc_hd__decap_3
XTAP_507 vssd1 vccd1 sky130_fd_sc_hd__tapvpwrvgnd_1
XTAP_518 vssd1 vccd1 sky130_fd_sc_hd__tapvpwrvgnd_1
XTAP_529 vssd1 vccd1 sky130_fd_sc_hd__tapvpwrvgnd_1
XFILLER_0_88_389 vssd1 vssd1 vccd1 vccd1 sky130_ef_sc_hd__decap_12
X_5760_ _5761_/A _5761_/B _5759_/Y vssd1 vssd1 vccd1 vccd1 _5772_/B sky130_fd_sc_hd__o21bai_2
XFILLER_0_8_317 vssd1 vssd1 vccd1 vccd1 sky130_fd_sc_hd__fill_2
XFILLER_0_56_231 vssd1 vssd1 vccd1 vccd1 sky130_fd_sc_hd__fill_1
X_5691_ tex_addr_i[5] _5693_/B vssd1 vssd1 vccd1 vccd1 _5692_/A sky130_fd_sc_hd__or2_2
X_4711_ _4713_/A _4713_/B vssd1 vssd1 vccd1 vccd1 _5406_/A sky130_fd_sc_hd__nor2_1
XANTENNA__3529__D _5277_/B vssd1 vssd1 vccd1 vccd1 sky130_fd_sc_hd__diode_2
XFILLER_0_56_253 vssd1 vssd1 vccd1 vccd1 sky130_fd_sc_hd__fill_2
X_4642_ _5666_/A _4688_/C vssd1 vssd1 vccd1 vccd1 _4644_/B sky130_fd_sc_hd__nand2_1
XFILLER_0_16_139 vssd1 vssd1 vccd1 vccd1 sky130_fd_sc_hd__fill_1
XANTENNA__5594__A _5922_/S vssd1 vssd1 vccd1 vccd1 sky130_fd_sc_hd__diode_2
XFILLER_0_112_64 vssd1 vssd1 vccd1 vccd1 sky130_fd_sc_hd__fill_2
X_4573_ _4573_/A _4573_/B _4573_/C _4573_/D vssd1 vssd1 vccd1 vccd1 _4603_/A sky130_fd_sc_hd__or4_2
XFILLER_0_71_278 vssd1 vssd1 vccd1 vccd1 sky130_fd_sc_hd__fill_2
X_6312_ hold17/X hold23/X _6319_/S vssd1 vssd1 vccd1 vccd1 _6795_/D sky130_fd_sc_hd__mux2_1
XFILLER_0_12_345 vssd1 vssd1 vccd1 vccd1 sky130_fd_sc_hd__decap_3
X_3524_ _3524_/A _3534_/A vssd1 vssd1 vccd1 vccd1 _3525_/B sky130_fd_sc_hd__or2_1
XFILLER_0_24_183 vssd1 vssd1 vccd1 vccd1 sky130_fd_sc_hd__fill_1
Xfanout7 _5803_/D vssd1 vssd1 vccd1 vccd1 _5919_/B sky130_fd_sc_hd__buf_4
X_6243_ _6276_/A _6243_/B vssd1 vssd1 vccd1 vccd1 _6243_/X sky130_fd_sc_hd__or2_1
X_3455_ _3455_/A _3455_/B vssd1 vssd1 vccd1 vccd1 _3457_/B sky130_fd_sc_hd__xor2_1
XANTENNA__4938__A _5091_/A vssd1 vssd1 vccd1 vccd1 sky130_fd_sc_hd__diode_2
X_6174_ _6162_/A _6184_/A _6184_/B vssd1 vssd1 vccd1 vccd1 _6174_/Y sky130_fd_sc_hd__a21oi_1
X_3386_ _3389_/D vssd1 vssd1 vccd1 vccd1 _3386_/Y sky130_fd_sc_hd__inv_2
XFILLER_0_34_3 vssd1 vssd1 vccd1 vccd1 sky130_fd_sc_hd__fill_2
X_5125_ _5142_/A _5124_/B _5121_/X vssd1 vssd1 vccd1 vccd1 _5127_/B sky130_fd_sc_hd__a21o_1
XFILLER_0_98_109 vssd1 vssd1 vccd1 vccd1 sky130_fd_sc_hd__fill_2
X_5056_ _5056_/A _5101_/A _5056_/C vssd1 vssd1 vccd1 vccd1 _5101_/B sky130_fd_sc_hd__nand3_2
X_4007_ _4004_/A _4004_/B _4008_/B vssd1 vssd1 vccd1 vccd1 _4007_/X sky130_fd_sc_hd__a21o_1
XFILLER_0_79_345 vssd1 vssd1 vccd1 vccd1 sky130_fd_sc_hd__fill_1
X_5958_ _6871_/Q _5951_/B _6870_/Q _3288_/Y _5957_/X vssd1 vssd1 vccd1 vccd1 _5958_/X
+ sky130_fd_sc_hd__a221o_1
XFILLER_0_62_91 vssd1 vssd1 vccd1 vccd1 sky130_fd_sc_hd__fill_1
X_4909_ _4909_/A _4909_/B vssd1 vssd1 vccd1 vccd1 _5009_/B sky130_fd_sc_hd__xnor2_1
XFILLER_0_117_141 vssd1 vssd1 vccd1 vccd1 sky130_fd_sc_hd__fill_2
XFILLER_0_117_130 vssd1 vssd1 vccd1 vccd1 sky130_fd_sc_hd__fill_2
XANTENNA__5708__S _5844_/S vssd1 vssd1 vccd1 vccd1 sky130_fd_sc_hd__diode_2
X_5889_ hold271/X _5888_/X _5923_/S vssd1 vssd1 vccd1 vccd1 _6647_/D sky130_fd_sc_hd__mux2_1
XFILLER_0_105_369 vssd1 vssd1 vccd1 vccd1 sky130_ef_sc_hd__decap_12
XFILLER_0_30_131 vssd1 vssd1 vccd1 vccd1 sky130_fd_sc_hd__fill_1
Xhold30 hold30/A vssd1 vssd1 vccd1 vccd1 hold30/X sky130_fd_sc_hd__dlygate4sd3_1
Xhold41 hold41/A vssd1 vssd1 vccd1 vccd1 hold41/X sky130_fd_sc_hd__dlygate4sd3_1
Xhold52 hold52/A vssd1 vssd1 vccd1 vccd1 hold52/X sky130_fd_sc_hd__dlygate4sd3_1
Xhold63 hold63/A vssd1 vssd1 vccd1 vccd1 hold63/X sky130_fd_sc_hd__dlygate4sd3_1
XFILLER_0_26_29 vssd1 vssd1 vccd1 vccd1 sky130_fd_sc_hd__decap_4
Xhold74 hold74/A vssd1 vssd1 vccd1 vccd1 hold74/X sky130_fd_sc_hd__dlygate4sd3_1
Xhold96 hold96/A vssd1 vssd1 vccd1 vccd1 hold96/X sky130_fd_sc_hd__dlygate4sd3_1
Xhold85 hold85/A vssd1 vssd1 vccd1 vccd1 hold85/X sky130_fd_sc_hd__dlygate4sd3_1
XFILLER_0_97_131 vssd1 vssd1 vccd1 vccd1 sky130_fd_sc_hd__decap_4
XFILLER_0_133_19 vssd1 vssd1 vccd1 vccd1 sky130_fd_sc_hd__decap_4
XFILLER_0_97_175 vssd1 vssd1 vccd1 vccd1 sky130_fd_sc_hd__fill_1
XFILLER_0_85_326 vssd1 vssd1 vccd1 vccd1 sky130_fd_sc_hd__decap_3
XFILLER_0_128_406 vssd1 vssd1 vccd1 vccd1 sky130_fd_sc_hd__fill_1
XFILLER_0_93_370 vssd1 vssd1 vccd1 vccd1 sky130_ef_sc_hd__decap_12
XFILLER_0_53_234 vssd1 vssd1 vccd1 vccd1 sky130_fd_sc_hd__decap_4
XANTENNA_5 sstream_i[10] vssd1 vssd1 vccd1 vccd1 sky130_fd_sc_hd__diode_2
XANTENNA__3365__C _5311_/A vssd1 vssd1 vccd1 vccd1 sky130_fd_sc_hd__diode_2
XFILLER_0_21_120 vssd1 vssd1 vccd1 vccd1 sky130_fd_sc_hd__fill_2
XTAP_304 vssd1 vccd1 sky130_fd_sc_hd__tapvpwrvgnd_1
XTAP_315 vssd1 vccd1 sky130_fd_sc_hd__tapvpwrvgnd_1
XFILLER_0_21_197 vssd1 vssd1 vccd1 vccd1 sky130_fd_sc_hd__decap_4
XANTENNA__3662__A _5051_/A vssd1 vssd1 vccd1 vccd1 sky130_fd_sc_hd__diode_2
XTAP_348 vssd1 vccd1 sky130_fd_sc_hd__tapvpwrvgnd_1
XTAP_337 vssd1 vccd1 sky130_fd_sc_hd__tapvpwrvgnd_1
XTAP_326 vssd1 vccd1 sky130_fd_sc_hd__tapvpwrvgnd_1
XTAP_359 vssd1 vccd1 sky130_fd_sc_hd__tapvpwrvgnd_1
X_6930_ vssd1 vssd1 vccd1 vccd1 _6930_/HI pix_mport_o[31] sky130_fd_sc_hd__conb_1
X_6861_ _6864_/CLK _6861_/D vssd1 vssd1 vccd1 vccd1 _6861_/Q sky130_fd_sc_hd__dfxtp_1
XFILLER_0_88_153 vssd1 vssd1 vccd1 vccd1 sky130_fd_sc_hd__decap_3
XFILLER_0_76_326 vssd1 vssd1 vccd1 vccd1 sky130_fd_sc_hd__decap_8
X_6792_ _6792_/CLK hold30/X vssd1 vssd1 vccd1 vccd1 _6792_/Q sky130_fd_sc_hd__dfxtp_2
X_5812_ _5812_/A _5812_/B vssd1 vssd1 vccd1 vccd1 _5812_/X sky130_fd_sc_hd__or2_2
XFILLER_0_123_52 vssd1 vssd1 vccd1 vccd1 sky130_fd_sc_hd__fill_2
X_5743_ _5754_/B _5754_/C vssd1 vssd1 vccd1 vccd1 _5743_/Y sky130_fd_sc_hd__xnor2_1
XFILLER_0_84_381 vssd1 vssd1 vccd1 vccd1 sky130_ef_sc_hd__decap_12
XANTENNA__4940__B _5656_/A vssd1 vssd1 vccd1 vccd1 sky130_fd_sc_hd__diode_2
X_5674_ _5565_/B _5673_/Y _5784_/S vssd1 vssd1 vccd1 vccd1 _5674_/X sky130_fd_sc_hd__mux2_1
X_4625_ _4625_/A _4625_/B _4625_/C vssd1 vssd1 vccd1 vccd1 _4626_/B sky130_fd_sc_hd__and3_1
XFILLER_0_114_166 vssd1 vssd1 vccd1 vccd1 sky130_fd_sc_hd__fill_2
X_4556_ _5666_/A _4614_/C vssd1 vssd1 vccd1 vccd1 _4558_/B sky130_fd_sc_hd__and2_1
XFILLER_0_12_120 vssd1 vssd1 vccd1 vccd1 sky130_fd_sc_hd__fill_2
X_3507_ _3507_/A _3507_/B vssd1 vssd1 vccd1 vccd1 _3508_/B sky130_fd_sc_hd__nor2_1
X_4487_ _4488_/A _4551_/D vssd1 vssd1 vccd1 vccd1 _4489_/B sky130_fd_sc_hd__nand2_1
XFILLER_0_12_197 vssd1 vssd1 vccd1 vccd1 sky130_fd_sc_hd__fill_2
X_6226_ _6784_/Q _6231_/A vssd1 vssd1 vccd1 vccd1 _6333_/S sky130_fd_sc_hd__or2_4
X_3438_ _5311_/A _6687_/Q _3435_/Y _3483_/A vssd1 vssd1 vccd1 vccd1 _3441_/B sky130_fd_sc_hd__o2bb2a_1
XFILLER_0_110_394 vssd1 vssd1 vccd1 vccd1 sky130_ef_sc_hd__decap_12
X_6157_ _6157_/A _6157_/B vssd1 vssd1 vccd1 vccd1 _6159_/A sky130_fd_sc_hd__nand2_1
XANTENNA__4486__A2 _4551_/D vssd1 vssd1 vccd1 vccd1 sky130_fd_sc_hd__diode_2
XTAP_871 vssd1 vccd1 sky130_fd_sc_hd__tapvpwrvgnd_1
XTAP_860 vssd1 vccd1 sky130_fd_sc_hd__tapvpwrvgnd_1
X_3369_ _5049_/A _5286_/B _5296_/B _5292_/A vssd1 vssd1 vccd1 vccd1 _3370_/D sky130_fd_sc_hd__a22o_1
XANTENNA__3722__D _5276_/A vssd1 vssd1 vccd1 vccd1 sky130_fd_sc_hd__diode_2
XTAP_893 vssd1 vccd1 sky130_fd_sc_hd__tapvpwrvgnd_1
XTAP_882 vssd1 vccd1 sky130_fd_sc_hd__tapvpwrvgnd_1
X_5108_ _6643_/Q _5109_/B vssd1 vssd1 vccd1 vccd1 _5110_/A sky130_fd_sc_hd__and2_1
X_6088_ hold172/X _6726_/Q _6098_/S vssd1 vssd1 vccd1 vccd1 _6088_/X sky130_fd_sc_hd__mux2_1
XANTENNA__6094__S _6095_/S vssd1 vssd1 vccd1 vccd1 sky130_fd_sc_hd__diode_2
XFILLER_0_79_131 vssd1 vssd1 vccd1 vccd1 sky130_fd_sc_hd__decap_3
XANTENNA__6735__SET_B fanout140/X vssd1 vssd1 vccd1 vccd1 sky130_fd_sc_hd__diode_2
X_5039_ _5354_/A _5039_/B _5034_/A _5038_/X vssd1 vssd1 vccd1 vccd1 _5039_/X sky130_fd_sc_hd__or4bb_1
XANTENNA_hold152_A _6841_/Q vssd1 vssd1 vccd1 vccd1 sky130_fd_sc_hd__diode_2
XFILLER_0_82_307 vssd1 vssd1 vccd1 vccd1 sky130_fd_sc_hd__fill_1
XANTENNA__3431__A1_N _5299_/A vssd1 vssd1 vccd1 vccd1 sky130_fd_sc_hd__diode_2
XANTENNA__3747__A _5290_/A vssd1 vssd1 vccd1 vccd1 sky130_fd_sc_hd__diode_2
XANTENNA__3466__B _5296_/B vssd1 vssd1 vccd1 vccd1 sky130_fd_sc_hd__diode_2
XFILLER_0_50_215 vssd1 vssd1 vccd1 vccd1 sky130_fd_sc_hd__fill_2
XFILLER_0_105_166 vssd1 vssd1 vccd1 vccd1 sky130_fd_sc_hd__fill_2
XFILLER_0_105_144 vssd1 vssd1 vccd1 vccd1 sky130_fd_sc_hd__decap_4
XFILLER_0_101_350 vssd1 vssd1 vccd1 vccd1 sky130_fd_sc_hd__fill_2
XFILLER_0_85_145 vssd1 vssd1 vccd1 vccd1 sky130_fd_sc_hd__decap_3
XPHY_170 vssd1 vssd1 vccd1 vccd1 sky130_fd_sc_hd__decap_3
XANTENNA__4937__B1 _5273_/B vssd1 vssd1 vccd1 vccd1 sky130_fd_sc_hd__diode_2
XPHY_192 vssd1 vssd1 vccd1 vccd1 sky130_fd_sc_hd__decap_3
XPHY_181 vssd1 vssd1 vccd1 vccd1 sky130_fd_sc_hd__decap_3
XFILLER_0_81_362 vssd1 vssd1 vccd1 vccd1 sky130_ef_sc_hd__decap_12
XANTENNA_clkbuf_leaf_10_clk_i_A clkbuf_leaf_9_clk_i/A vssd1 vssd1 vccd1 vccd1 sky130_fd_sc_hd__diode_2
X_4410_ _4410_/A _4410_/B vssd1 vssd1 vccd1 vccd1 _4412_/B sky130_fd_sc_hd__xnor2_2
XFILLER_0_111_103 vssd1 vssd1 vccd1 vccd1 sky130_fd_sc_hd__fill_2
X_5390_ _6730_/Q _5574_/B vssd1 vssd1 vccd1 vccd1 _5390_/Y sky130_fd_sc_hd__xnor2_1
XFILLER_0_1_334 vssd1 vssd1 vccd1 vccd1 sky130_fd_sc_hd__fill_2
XFILLER_0_111_169 vssd1 vssd1 vccd1 vccd1 sky130_fd_sc_hd__fill_2
XANTENNA__4488__A _4488_/A vssd1 vssd1 vccd1 vccd1 sky130_fd_sc_hd__diode_2
X_4341_ _4340_/A _4340_/C _4340_/B vssd1 vssd1 vccd1 vccd1 _4342_/C sky130_fd_sc_hd__a21o_1
X_4272_ _4816_/A _4736_/B _4736_/D _4776_/A vssd1 vssd1 vccd1 vccd1 _4274_/A sky130_fd_sc_hd__a22oi_1
X_6011_ _5115_/D _6010_/X _6037_/S vssd1 vssd1 vccd1 vccd1 _6671_/D sky130_fd_sc_hd__mux2_1
X_6913_ vssd1 vssd1 vccd1 vccd1 _6913_/HI pix_mport_o[14] sky130_fd_sc_hd__conb_1
XFILLER_0_49_337 vssd1 vssd1 vccd1 vccd1 sky130_fd_sc_hd__decap_6
XFILLER_0_119_225 vssd1 vssd1 vccd1 vccd1 sky130_fd_sc_hd__fill_2
X_6844_ _6862_/CLK _6844_/D vssd1 vssd1 vccd1 vccd1 _6844_/Q sky130_fd_sc_hd__dfxtp_1
XFILLER_0_76_145 vssd1 vssd1 vccd1 vccd1 sky130_fd_sc_hd__fill_1
X_6775_ _6832_/CLK _6775_/D fanout152/X vssd1 vssd1 vccd1 vccd1 pix_mport_o[47] sky130_fd_sc_hd__dfrtp_4
XFILLER_0_91_126 vssd1 vssd1 vccd1 vccd1 sky130_fd_sc_hd__decap_4
XANTENNA__3567__A _5081_/A vssd1 vssd1 vccd1 vccd1 sky130_fd_sc_hd__diode_2
X_3987_ _3881_/B _3975_/X _3976_/X _3979_/X vssd1 vssd1 vccd1 vccd1 _3989_/C sky130_fd_sc_hd__a211o_1
X_5726_ _5713_/B _5715_/B _5727_/A _5711_/Y vssd1 vssd1 vccd1 vccd1 _5739_/B sky130_fd_sc_hd__a211o_1
XFILLER_0_17_223 vssd1 vssd1 vccd1 vccd1 sky130_fd_sc_hd__fill_1
XFILLER_0_130_401 vssd1 vssd1 vccd1 vccd1 sky130_fd_sc_hd__decap_6
X_5657_ _5666_/B _5657_/B vssd1 vssd1 vccd1 vccd1 _5657_/Y sky130_fd_sc_hd__nand2_1
X_5588_ _5599_/A _5588_/B _5588_/C vssd1 vssd1 vccd1 vccd1 _5588_/X sky130_fd_sc_hd__and3_1
XFILLER_0_102_114 vssd1 vssd1 vccd1 vccd1 sky130_fd_sc_hd__fill_2
X_4608_ _4607_/A _4607_/B _4580_/A _4580_/B vssd1 vssd1 vccd1 vccd1 _4608_/Y sky130_fd_sc_hd__o211ai_1
XANTENNA__6089__S _6098_/S vssd1 vssd1 vccd1 vccd1 sky130_fd_sc_hd__diode_2
X_4539_ _4528_/A _4528_/B _4528_/C vssd1 vssd1 vccd1 vccd1 _4541_/C sky130_fd_sc_hd__o21ai_1
XFILLER_0_7_93 vssd1 vssd1 vccd1 vccd1 sky130_ef_sc_hd__decap_12
X_6209_ _6791_/Q hold49/A _6792_/Q vssd1 vssd1 vccd1 vccd1 _6209_/Y sky130_fd_sc_hd__a21oi_1
XFILLER_0_110_191 vssd1 vssd1 vccd1 vccd1 sky130_fd_sc_hd__decap_3
XTAP_690 vssd1 vccd1 sky130_fd_sc_hd__tapvpwrvgnd_1
XANTENNA__3828__A2_N _5296_/B vssd1 vssd1 vccd1 vccd1 sky130_fd_sc_hd__diode_2
XFILLER_0_67_167 vssd1 vssd1 vccd1 vccd1 sky130_fd_sc_hd__fill_1
XFILLER_0_55_329 vssd1 vssd1 vccd1 vccd1 sky130_fd_sc_hd__fill_2
XFILLER_0_125_217 vssd1 vssd1 vccd1 vccd1 sky130_fd_sc_hd__fill_2
XANTENNA__5592__B1 _5591_/X vssd1 vssd1 vccd1 vccd1 sky130_fd_sc_hd__diode_2
XFILLER_0_82_148 vssd1 vssd1 vccd1 vccd1 sky130_fd_sc_hd__decap_4
XFILLER_0_118_291 vssd1 vssd1 vccd1 vccd1 sky130_fd_sc_hd__fill_2
XFILLER_0_2_109 vssd1 vssd1 vccd1 vccd1 sky130_ef_sc_hd__decap_12
XANTENNA__3643__C _5296_/A vssd1 vssd1 vccd1 vccd1 sky130_fd_sc_hd__diode_2
XFILLER_0_31_281 vssd1 vssd1 vccd1 vccd1 sky130_fd_sc_hd__decap_8
XFILLER_0_48_27 vssd1 vssd1 vccd1 vccd1 sky130_fd_sc_hd__fill_1
XANTENNA__6072__A1 _6555_/Q vssd1 vssd1 vccd1 vccd1 sky130_fd_sc_hd__diode_2
XANTENNA__4193__D _4841_/C vssd1 vssd1 vccd1 vccd1 sky130_fd_sc_hd__diode_2
XFILLER_0_58_112 vssd1 vssd1 vccd1 vccd1 sky130_fd_sc_hd__decap_4
X_3910_ _5300_/A _5115_/C vssd1 vssd1 vccd1 vccd1 _3912_/B sky130_fd_sc_hd__and2_1
X_4890_ _4890_/A _4890_/B _4890_/C vssd1 vssd1 vccd1 vccd1 _4890_/Y sky130_fd_sc_hd__nand3_1
X_3841_ _3827_/X _3830_/B _3999_/A _6684_/Q vssd1 vssd1 vccd1 vccd1 _3845_/A sky130_fd_sc_hd__o211ai_1
XFILLER_0_46_318 vssd1 vssd1 vccd1 vccd1 sky130_fd_sc_hd__fill_2
X_6560_ _6853_/CLK _6560_/D _5468_/A vssd1 vssd1 vccd1 vccd1 depth_mport_o[4] sky130_fd_sc_hd__dfrtp_4
XFILLER_0_73_137 vssd1 vssd1 vccd1 vccd1 sky130_fd_sc_hd__fill_2
XFILLER_0_6_404 vssd1 vssd1 vccd1 vccd1 sky130_fd_sc_hd__decap_3
XANTENNA__3387__A _5290_/A vssd1 vssd1 vccd1 vccd1 sky130_fd_sc_hd__diode_2
X_3772_ _3771_/A _3772_/B vssd1 vssd1 vccd1 vccd1 _3774_/B sky130_fd_sc_hd__and2b_1
X_5511_ hold7/X sstream_i[102] _6472_/S vssd1 vssd1 vccd1 vccd1 _6544_/D sky130_fd_sc_hd__mux2_1
XANTENNA__4138__A1 _4966_/A vssd1 vssd1 vccd1 vccd1 sky130_fd_sc_hd__diode_2
X_6491_ hold74/X sstream_i[49] _6493_/S vssd1 vssd1 vccd1 vccd1 _6882_/D sky130_fd_sc_hd__mux2_1
XFILLER_0_124_272 vssd1 vssd1 vccd1 vccd1 sky130_fd_sc_hd__fill_2
XFILLER_0_120_53 vssd1 vssd1 vccd1 vccd1 sky130_fd_sc_hd__fill_2
XANTENNA__4138__B2 _5754_/A vssd1 vssd1 vccd1 vccd1 sky130_fd_sc_hd__diode_2
X_5442_ _5442_/A _5442_/B vssd1 vssd1 vccd1 vccd1 _5444_/B sky130_fd_sc_hd__nor2_1
X_5373_ _5375_/B _5373_/B vssd1 vssd1 vccd1 vccd1 _5561_/B sky130_fd_sc_hd__and2_1
X_4324_ _4269_/A _4269_/C _4269_/B vssd1 vssd1 vccd1 vccd1 _4330_/B sky130_fd_sc_hd__a21o_1
XANTENNA__3361__A2 _5296_/B vssd1 vssd1 vccd1 vccd1 sky130_fd_sc_hd__diode_2
XFILLER_0_22_281 vssd1 vssd1 vccd1 vccd1 sky130_fd_sc_hd__fill_2
XFILLER_0_129_51 vssd1 vssd1 vccd1 vccd1 sky130_fd_sc_hd__fill_2
Xfanout117 _5801_/A vssd1 vssd1 vccd1 vccd1 _5308_/B sky130_fd_sc_hd__buf_4
Xfanout106 tex_width_i[3] vssd1 vssd1 vccd1 vccd1 _5106_/A sky130_fd_sc_hd__clkbuf_4
Xfanout128 _5754_/A vssd1 vssd1 vccd1 vccd1 _5115_/B sky130_fd_sc_hd__buf_2
X_4255_ _5732_/A _5718_/A _4658_/D _4637_/D vssd1 vssd1 vccd1 vccd1 _4255_/X sky130_fd_sc_hd__and4_1
Xfanout139 fanout140/X vssd1 vssd1 vccd1 vccd1 fanout139/X sky130_fd_sc_hd__clkbuf_8
X_4186_ _4183_/X _4186_/B _4971_/D _5754_/B vssd1 vssd1 vccd1 vccd1 _4186_/X sky130_fd_sc_hd__and4b_1
XANTENNA__6063__A1 _6546_/Q vssd1 vssd1 vccd1 vccd1 sky130_fd_sc_hd__diode_2
XTAP_1119 vssd1 vccd1 sky130_fd_sc_hd__tapvpwrvgnd_1
XTAP_1108 vssd1 vccd1 sky130_fd_sc_hd__tapvpwrvgnd_1
XFILLER_0_96_229 vssd1 vssd1 vccd1 vccd1 sky130_fd_sc_hd__fill_2
XFILLER_0_89_281 vssd1 vssd1 vccd1 vccd1 sky130_fd_sc_hd__fill_1
XANTENNA__5777__A _5787_/B vssd1 vssd1 vccd1 vccd1 sky130_fd_sc_hd__diode_2
XFILLER_0_54_92 vssd1 vssd1 vccd1 vccd1 sky130_fd_sc_hd__decap_3
X_6827_ _6827_/CLK _6827_/D fanout152/X vssd1 vssd1 vccd1 vccd1 depth_mport_o[49]
+ sky130_fd_sc_hd__dfrtp_4
XFILLER_0_9_220 vssd1 vssd1 vccd1 vccd1 sky130_fd_sc_hd__fill_2
XFILLER_0_107_217 vssd1 vssd1 vccd1 vccd1 sky130_fd_sc_hd__decap_4
XFILLER_0_64_137 vssd1 vssd1 vccd1 vccd1 sky130_fd_sc_hd__decap_3
X_6758_ _6853_/CLK _6758_/D fanout149/X vssd1 vssd1 vccd1 vccd1 pix_mport_o[6] sky130_fd_sc_hd__dfrtp_4
XANTENNA__5716__S _5784_/S vssd1 vssd1 vccd1 vccd1 sky130_fd_sc_hd__diode_2
X_5709_ _5718_/B _5718_/C vssd1 vssd1 vccd1 vccd1 _5709_/Y sky130_fd_sc_hd__xnor2_1
X_6689_ _6693_/CLK _6689_/D vssd1 vssd1 vccd1 vccd1 _6689_/Q sky130_fd_sc_hd__dfxtp_2
XFILLER_0_20_229 vssd1 vssd1 vccd1 vccd1 sky130_fd_sc_hd__decap_6
Xhold171 _6521_/Q vssd1 vssd1 vccd1 vccd1 hold171/X sky130_fd_sc_hd__dlygate4sd3_1
Xhold160 _6512_/Q vssd1 vssd1 vccd1 vccd1 hold160/X sky130_fd_sc_hd__dlygate4sd3_1
Xhold182 _6854_/Q vssd1 vssd1 vccd1 vccd1 hold182/X sky130_fd_sc_hd__dlygate4sd3_1
Xhold193 _6092_/X vssd1 vssd1 vccd1 vccd1 _6730_/D sky130_fd_sc_hd__dlygate4sd3_1
XANTENNA__5687__A _5687_/A vssd1 vssd1 vccd1 vccd1 sky130_fd_sc_hd__diode_2
XFILLER_0_34_29 vssd1 vssd1 vccd1 vccd1 sky130_fd_sc_hd__fill_2
XFILLER_0_95_240 vssd1 vssd1 vccd1 vccd1 sky130_fd_sc_hd__fill_1
XFILLER_0_138_320 vssd1 vssd1 vccd1 vccd1 sky130_fd_sc_hd__fill_1
XFILLER_0_95_284 vssd1 vssd1 vccd1 vccd1 sky130_fd_sc_hd__decap_4
XFILLER_0_95_295 vssd1 vssd1 vccd1 vccd1 sky130_fd_sc_hd__fill_1
XFILLER_0_55_148 vssd1 vssd1 vccd1 vccd1 sky130_fd_sc_hd__fill_2
XANTENNA__4741__D _4942_/B vssd1 vssd1 vccd1 vccd1 sky130_fd_sc_hd__diode_2
XFILLER_0_121_242 vssd1 vssd1 vccd1 vccd1 sky130_fd_sc_hd__decap_3
XFILLER_0_11_218 vssd1 vssd1 vccd1 vccd1 sky130_fd_sc_hd__fill_2
XFILLER_0_121_286 vssd1 vssd1 vccd1 vccd1 sky130_fd_sc_hd__fill_1
XANTENNA__3879__B1 _5051_/B vssd1 vssd1 vccd1 vccd1 sky130_fd_sc_hd__diode_2
XFILLER_0_75_69 vssd1 vssd1 vccd1 vccd1 sky130_fd_sc_hd__fill_2
X_4040_ _4794_/B _5083_/A _4736_/B _4736_/D vssd1 vssd1 vccd1 vccd1 _4041_/B sky130_fd_sc_hd__and4_1
XANTENNA__3646__A3 _5296_/A vssd1 vssd1 vccd1 vccd1 sky130_fd_sc_hd__diode_2
XANTENNA__4843__A2 _4841_/C vssd1 vssd1 vccd1 vccd1 sky130_fd_sc_hd__diode_2
XFILLER_0_78_218 vssd1 vssd1 vccd1 vccd1 sky130_fd_sc_hd__fill_2
XANTENNA__6045__A1 _5296_/B vssd1 vssd1 vccd1 vccd1 sky130_fd_sc_hd__diode_2
XFILLER_0_115_31 vssd1 vssd1 vccd1 vccd1 sky130_fd_sc_hd__fill_2
X_5991_ tex_height_i[5] _5994_/C vssd1 vssd1 vccd1 vccd1 _5991_/Y sky130_fd_sc_hd__xnor2_1
XFILLER_0_24_40 vssd1 vssd1 vccd1 vccd1 sky130_fd_sc_hd__fill_2
X_4942_ _4942_/A _4942_/B _5083_/A _5049_/D vssd1 vssd1 vccd1 vccd1 _5053_/A sky130_fd_sc_hd__nand4_1
XFILLER_0_86_284 vssd1 vssd1 vccd1 vccd1 sky130_fd_sc_hd__fill_2
XFILLER_0_19_318 vssd1 vssd1 vccd1 vccd1 sky130_fd_sc_hd__decap_4
XFILLER_0_19_329 vssd1 vssd1 vccd1 vccd1 sky130_fd_sc_hd__fill_2
XANTENNA__3829__B _5296_/B vssd1 vssd1 vccd1 vccd1 sky130_fd_sc_hd__diode_2
X_6612_ _6633_/CLK _6612_/D fanout142/X vssd1 vssd1 vccd1 vccd1 tex_mport_o[55] sky130_fd_sc_hd__dfrtp_4
XFILLER_0_86_295 vssd1 vssd1 vccd1 vccd1 sky130_fd_sc_hd__fill_1
X_4873_ _4926_/B _4872_/B _4872_/C _4872_/D vssd1 vssd1 vccd1 vccd1 _4873_/X sky130_fd_sc_hd__a22o_1
X_3824_ _3831_/A _3831_/B vssd1 vssd1 vccd1 vccd1 _3824_/X sky130_fd_sc_hd__and2b_1
XANTENNA__6639__SET_B fanout140/X vssd1 vssd1 vccd1 vccd1 sky130_fd_sc_hd__diode_2
X_6543_ _6864_/CLK _6543_/D vssd1 vssd1 vccd1 vccd1 _6543_/Q sky130_fd_sc_hd__dfxtp_2
XFILLER_0_6_245 vssd1 vssd1 vccd1 vccd1 sky130_fd_sc_hd__fill_2
X_3755_ _3755_/A _3755_/B _3755_/C vssd1 vssd1 vccd1 vccd1 _3756_/B sky130_fd_sc_hd__nor3_1
XFILLER_0_42_321 vssd1 vssd1 vccd1 vccd1 sky130_fd_sc_hd__fill_1
XFILLER_0_54_181 vssd1 vssd1 vccd1 vccd1 sky130_fd_sc_hd__fill_2
XFILLER_0_6_278 vssd1 vssd1 vccd1 vccd1 sky130_fd_sc_hd__fill_2
X_3686_ _3686_/A _3768_/A vssd1 vssd1 vccd1 vccd1 _3693_/A sky130_fd_sc_hd__nand2_1
XFILLER_0_40_94 vssd1 vssd1 vccd1 vccd1 sky130_fd_sc_hd__fill_2
X_6474_ hold113/X sstream_i[32] _6493_/S vssd1 vssd1 vccd1 vccd1 _6865_/D sky130_fd_sc_hd__mux2_1
XFILLER_0_54_192 vssd1 vssd1 vccd1 vccd1 sky130_fd_sc_hd__fill_2
X_5425_ _5425_/A _5425_/B _5425_/C vssd1 vssd1 vccd1 vccd1 _5428_/C sky130_fd_sc_hd__nand3_1
XFILLER_0_64_3 vssd1 vssd1 vccd1 vccd1 sky130_fd_sc_hd__decap_3
X_5356_ _5421_/A _5421_/C _5041_/X _5039_/B vssd1 vssd1 vccd1 vccd1 _5357_/B sky130_fd_sc_hd__o211ai_1
XFILLER_0_10_240 vssd1 vssd1 vccd1 vccd1 sky130_fd_sc_hd__fill_2
X_4307_ _4248_/Y _4249_/X _4303_/Y _4306_/Y vssd1 vssd1 vccd1 vccd1 _4713_/A sky130_fd_sc_hd__o211a_1
X_5287_ _5287_/A _5287_/B vssd1 vssd1 vccd1 vccd1 _5288_/B sky130_fd_sc_hd__xnor2_1
X_4238_ _4058_/X _4073_/Y _4281_/A _4072_/A vssd1 vssd1 vccd1 vccd1 _4240_/C sky130_fd_sc_hd__o211ai_2
XFILLER_0_4_83 vssd1 vssd1 vccd1 vccd1 sky130_fd_sc_hd__fill_1
XANTENNA__4834__A2 _4832_/C vssd1 vssd1 vccd1 vccd1 sky130_fd_sc_hd__diode_2
X_4169_ _5011_/B _4169_/B vssd1 vssd1 vccd1 vccd1 _4169_/X sky130_fd_sc_hd__and2_1
XANTENNA__6036__A1 hold217/X vssd1 vssd1 vccd1 vccd1 sky130_fd_sc_hd__diode_2
XFILLER_0_77_240 vssd1 vssd1 vccd1 vccd1 sky130_fd_sc_hd__fill_1
XANTENNA__5300__A _5300_/A vssd1 vssd1 vccd1 vccd1 sky130_fd_sc_hd__diode_2
XANTENNA__3739__B _5049_/B vssd1 vssd1 vccd1 vccd1 sky130_fd_sc_hd__diode_2
XFILLER_0_92_221 vssd1 vssd1 vccd1 vccd1 sky130_fd_sc_hd__fill_2
XFILLER_0_80_405 vssd1 vssd1 vccd1 vccd1 sky130_fd_sc_hd__fill_2
XANTENNA__3458__C _5273_/A vssd1 vssd1 vccd1 vccd1 sky130_fd_sc_hd__diode_2
XFILLER_0_135_367 vssd1 vssd1 vccd1 vccd1 sky130_ef_sc_hd__decap_12
XFILLER_0_18_384 vssd1 vssd1 vccd1 vccd1 sky130_fd_sc_hd__fill_1
XANTENNA__3474__B _5327_/A vssd1 vssd1 vccd1 vccd1 sky130_fd_sc_hd__diode_2
XANTENNA__4736__D _4736_/D vssd1 vssd1 vccd1 vccd1 sky130_fd_sc_hd__diode_2
XANTENNA__5786__B1 _5787_/A vssd1 vssd1 vccd1 vccd1 sky130_fd_sc_hd__diode_2
XFILLER_0_131_7 vssd1 vssd1 vccd1 vccd1 sky130_fd_sc_hd__fill_1
XFILLER_0_126_323 vssd1 vssd1 vccd1 vccd1 sky130_fd_sc_hd__fill_2
XFILLER_0_71_405 vssd1 vssd1 vccd1 vccd1 sky130_fd_sc_hd__fill_2
XFILLER_0_9_39 vssd1 vssd1 vccd1 vccd1 sky130_ef_sc_hd__decap_12
XFILLER_0_36_181 vssd1 vssd1 vccd1 vccd1 sky130_fd_sc_hd__decap_3
XANTENNA__5583__C _5588_/C vssd1 vssd1 vccd1 vccd1 sky130_fd_sc_hd__diode_2
X_3540_ _3540_/A _3540_/B _3540_/C vssd1 vssd1 vccd1 vccd1 _3541_/C sky130_fd_sc_hd__nand3_1
XFILLER_0_36_192 vssd1 vssd1 vccd1 vccd1 sky130_fd_sc_hd__fill_2
XFILLER_0_101_55 vssd1 vssd1 vccd1 vccd1 sky130_fd_sc_hd__fill_1
XFILLER_0_10_53 vssd1 vssd1 vccd1 vccd1 sky130_ef_sc_hd__decap_12
XFILLER_0_24_365 vssd1 vssd1 vccd1 vccd1 sky130_fd_sc_hd__decap_6
XFILLER_0_10_97 vssd1 vssd1 vccd1 vccd1 sky130_ef_sc_hd__decap_12
X_3471_ _3471_/A _3471_/B vssd1 vssd1 vccd1 vccd1 _3558_/B sky130_fd_sc_hd__xor2_1
X_5210_ _5210_/A _5210_/B vssd1 vssd1 vccd1 vccd1 _5215_/A sky130_fd_sc_hd__xnor2_1
XFILLER_0_51_184 vssd1 vssd1 vccd1 vccd1 sky130_fd_sc_hd__decap_4
X_6190_ _6190_/A _6190_/B _6190_/C vssd1 vssd1 vccd1 vccd1 _6191_/B sky130_fd_sc_hd__and3_1
X_5141_ _5141_/A _5141_/B _5141_/C vssd1 vssd1 vccd1 vccd1 _5145_/A sky130_fd_sc_hd__and3_2
X_5072_ _5073_/B _5073_/A vssd1 vssd1 vccd1 vccd1 _5075_/A sky130_fd_sc_hd__nand2b_1
X_4023_ _4024_/B _5264_/C vssd1 vssd1 vccd1 vccd1 _5433_/B sky130_fd_sc_hd__nor2_1
XANTENNA__6018__A1 _6876_/Q vssd1 vssd1 vccd1 vccd1 sky130_fd_sc_hd__diode_2
XFILLER_0_126_52 vssd1 vssd1 vccd1 vccd1 sky130_fd_sc_hd__fill_1
XFILLER_0_35_50 vssd1 vssd1 vccd1 vccd1 sky130_fd_sc_hd__decap_3
XFILLER_0_126_85 vssd1 vssd1 vccd1 vccd1 sky130_fd_sc_hd__fill_2
X_5974_ _5973_/Y hold121/X _6038_/C vssd1 vssd1 vccd1 vccd1 _5974_/X sky130_fd_sc_hd__mux2_1
XFILLER_0_59_273 vssd1 vssd1 vccd1 vccd1 sky130_fd_sc_hd__decap_6
XFILLER_0_74_232 vssd1 vssd1 vccd1 vccd1 sky130_fd_sc_hd__fill_2
X_4925_ _4944_/B _4488_/A _4766_/A _4769_/A vssd1 vssd1 vccd1 vccd1 _4935_/A sky130_fd_sc_hd__a31o_1
XFILLER_0_74_276 vssd1 vssd1 vccd1 vccd1 sky130_fd_sc_hd__fill_2
XFILLER_0_19_159 vssd1 vssd1 vccd1 vccd1 sky130_fd_sc_hd__fill_2
X_4856_ _4855_/B _4855_/C _4855_/A vssd1 vssd1 vccd1 vccd1 _4856_/Y sky130_fd_sc_hd__a21oi_2
XFILLER_0_117_345 vssd1 vssd1 vccd1 vccd1 sky130_fd_sc_hd__fill_2
XFILLER_0_74_287 vssd1 vssd1 vccd1 vccd1 sky130_fd_sc_hd__fill_2
XFILLER_0_15_310 vssd1 vssd1 vccd1 vccd1 sky130_fd_sc_hd__decap_3
X_3807_ _5277_/A _5320_/A _3725_/C _3725_/D vssd1 vssd1 vccd1 vccd1 _3807_/Y sky130_fd_sc_hd__a22oi_1
XFILLER_0_51_93 vssd1 vssd1 vccd1 vccd1 sky130_fd_sc_hd__fill_2
X_6526_ _6841_/CLK _6526_/D vssd1 vssd1 vccd1 vccd1 hold26/A sky130_fd_sc_hd__dfxtp_1
XFILLER_0_15_332 vssd1 vssd1 vccd1 vccd1 sky130_fd_sc_hd__fill_2
X_4787_ _4866_/A _4786_/B _4783_/X vssd1 vssd1 vccd1 vccd1 _4804_/A sky130_fd_sc_hd__a21oi_1
X_3738_ _3738_/A _3738_/B vssd1 vssd1 vccd1 vccd1 _3751_/A sky130_fd_sc_hd__xnor2_2
X_6457_ hold158/X sstream_i[15] _6464_/S vssd1 vssd1 vccd1 vccd1 _6848_/D sky130_fd_sc_hd__mux2_1
X_3669_ _3667_/X _6686_/Q _5299_/A _3669_/D vssd1 vssd1 vccd1 vccd1 _3670_/B sky130_fd_sc_hd__and4b_1
XFILLER_0_30_335 vssd1 vssd1 vccd1 vccd1 sky130_fd_sc_hd__fill_2
X_6388_ _6375_/A _6402_/A _6388_/C vssd1 vssd1 vccd1 vccd1 _6390_/A sky130_fd_sc_hd__and3b_1
XFILLER_0_100_201 vssd1 vssd1 vccd1 vccd1 sky130_fd_sc_hd__fill_1
X_5408_ _6735_/Q _5408_/B vssd1 vssd1 vccd1 vccd1 _5408_/Y sky130_fd_sc_hd__xnor2_1
XANTENNA__6097__S _6098_/S vssd1 vssd1 vccd1 vccd1 sky130_fd_sc_hd__diode_2
X_5339_ _5410_/A _5410_/B _5410_/C _5410_/D vssd1 vssd1 vccd1 vccd1 _5591_/B sky130_fd_sc_hd__a31o_1
XFILLER_0_100_278 vssd1 vssd1 vccd1 vccd1 sky130_fd_sc_hd__fill_1
XANTENNA__4268__B1 _4551_/D vssd1 vssd1 vccd1 vccd1 sky130_fd_sc_hd__diode_2
XFILLER_0_108_323 vssd1 vssd1 vccd1 vccd1 sky130_fd_sc_hd__fill_2
XFILLER_0_31_19 vssd1 vssd1 vccd1 vccd1 sky130_fd_sc_hd__fill_2
XFILLER_0_53_405 vssd1 vssd1 vccd1 vccd1 sky130_fd_sc_hd__fill_2
XFILLER_0_108_345 vssd1 vssd1 vccd1 vccd1 sky130_ef_sc_hd__decap_12
XFILLER_0_80_202 vssd1 vssd1 vccd1 vccd1 sky130_fd_sc_hd__fill_2
XFILLER_0_18_170 vssd1 vssd1 vccd1 vccd1 sky130_fd_sc_hd__decap_4
XFILLER_0_123_315 vssd1 vssd1 vccd1 vccd1 sky130_fd_sc_hd__fill_2
XFILLER_0_108_389 vssd1 vssd1 vccd1 vccd1 sky130_ef_sc_hd__decap_12
XANTENNA__6622__SET_B fanout145/X vssd1 vssd1 vccd1 vccd1 sky130_fd_sc_hd__diode_2
XFILLER_0_80_257 vssd1 vssd1 vccd1 vccd1 sky130_fd_sc_hd__decap_8
XFILLER_0_80_235 vssd1 vssd1 vccd1 vccd1 sky130_fd_sc_hd__decap_8
XFILLER_0_21_346 vssd1 vssd1 vccd1 vccd1 sky130_fd_sc_hd__fill_1
XANTENNA__5904__S _5923_/S vssd1 vssd1 vccd1 vccd1 sky130_fd_sc_hd__diode_2
XFILLER_0_131_370 vssd1 vssd1 vccd1 vccd1 sky130_ef_sc_hd__decap_12
XFILLER_0_21_357 vssd1 vssd1 vccd1 vccd1 sky130_fd_sc_hd__fill_2
XTAP_508 vssd1 vccd1 sky130_fd_sc_hd__tapvpwrvgnd_1
XTAP_519 vssd1 vccd1 sky130_fd_sc_hd__tapvpwrvgnd_1
XFILLER_0_56_38 vssd1 vssd1 vccd1 vccd1 sky130_fd_sc_hd__fill_2
XFILLER_0_56_49 vssd1 vssd1 vccd1 vccd1 sky130_fd_sc_hd__fill_1
XFILLER_0_88_313 vssd1 vssd1 vccd1 vccd1 sky130_fd_sc_hd__fill_2
XANTENNA__3379__B _5049_/B vssd1 vssd1 vccd1 vccd1 sky130_fd_sc_hd__diode_2
X_5690_ _5689_/Y _6511_/Q _5802_/B vssd1 vssd1 vccd1 vccd1 _5693_/B sky130_fd_sc_hd__mux2_1
X_4710_ _5392_/A _5392_/B _5400_/A _4714_/A vssd1 vssd1 vccd1 vccd1 _5396_/A sky130_fd_sc_hd__a31o_2
XFILLER_0_56_265 vssd1 vssd1 vccd1 vccd1 sky130_fd_sc_hd__fill_2
XFILLER_0_122_3 vssd1 vssd1 vccd1 vccd1 sky130_fd_sc_hd__decap_4
X_4641_ _4638_/A _4688_/C _4640_/B _4637_/X vssd1 vssd1 vccd1 vccd1 _4644_/A sky130_fd_sc_hd__a31o_1
X_4572_ _4571_/B _4571_/C _4571_/A vssd1 vssd1 vccd1 vccd1 _4573_/D sky130_fd_sc_hd__a21oi_1
X_6311_ hold48/X hold77/X _6315_/S vssd1 vssd1 vccd1 vccd1 _6794_/D sky130_fd_sc_hd__mux2_1
Xfanout8 _5768_/S vssd1 vssd1 vccd1 vccd1 _5802_/B sky130_fd_sc_hd__clkbuf_8
X_3523_ _3524_/A _3522_/Y _5308_/A _5300_/A vssd1 vssd1 vccd1 vccd1 _3534_/A sky130_fd_sc_hd__and4bb_1
X_6242_ _6236_/X _6240_/X _6241_/X vssd1 vssd1 vccd1 vccd1 _6243_/B sky130_fd_sc_hd__o21a_1
XFILLER_0_122_381 vssd1 vssd1 vccd1 vccd1 sky130_ef_sc_hd__decap_12
X_3454_ _6651_/Q _3454_/B vssd1 vssd1 vccd1 vccd1 _3455_/B sky130_fd_sc_hd__xnor2_1
XANTENNA__4938__B _5091_/B vssd1 vssd1 vccd1 vccd1 sky130_fd_sc_hd__diode_2
X_6173_ _6173_/A _6173_/B vssd1 vssd1 vccd1 vccd1 _6184_/B sky130_fd_sc_hd__nand2_1
X_3385_ _5327_/A _6688_/Q _6689_/Q _5290_/A vssd1 vssd1 vccd1 vccd1 _3389_/D sky130_fd_sc_hd__a22o_1
XANTENNA__5115__A _5273_/A vssd1 vssd1 vccd1 vccd1 sky130_fd_sc_hd__diode_2
X_5124_ _5121_/X _5124_/B vssd1 vssd1 vccd1 vccd1 _5142_/B sky130_fd_sc_hd__and2b_1
XANTENNA__5998__A0 _4970_/B vssd1 vssd1 vccd1 vccd1 sky130_fd_sc_hd__diode_2
X_5055_ _5054_/A _5054_/B _5054_/C vssd1 vssd1 vccd1 vccd1 _5056_/C sky130_fd_sc_hd__a21o_1
XFILLER_0_27_3 vssd1 vssd1 vccd1 vccd1 sky130_ef_sc_hd__decap_12
X_4006_ _4006_/A _4006_/B vssd1 vssd1 vccd1 vccd1 _4008_/B sky130_fd_sc_hd__nand2_1
XANTENNA__3473__A1 _5327_/A vssd1 vssd1 vccd1 vccd1 sky130_fd_sc_hd__diode_2
XANTENNA__3473__B2 _5290_/A vssd1 vssd1 vccd1 vccd1 sky130_fd_sc_hd__diode_2
XFILLER_0_1_51 vssd1 vssd1 vccd1 vccd1 sky130_fd_sc_hd__decap_4
XFILLER_0_87_390 vssd1 vssd1 vccd1 vccd1 sky130_fd_sc_hd__fill_2
X_5957_ _6870_/Q _3288_/Y _3289_/Y _6869_/Q _5956_/X vssd1 vssd1 vccd1 vccd1 _5957_/X
+ sky130_fd_sc_hd__o221a_1
X_4908_ _4909_/B _4909_/A vssd1 vssd1 vccd1 vccd1 _4911_/A sky130_fd_sc_hd__nand2b_1
XFILLER_0_35_405 vssd1 vssd1 vccd1 vccd1 sky130_fd_sc_hd__fill_2
X_5888_ _5922_/S _5886_/X _5887_/Y _5594_/Y vssd1 vssd1 vccd1 vccd1 _5888_/X sky130_fd_sc_hd__a31o_1
XFILLER_0_117_153 vssd1 vssd1 vccd1 vccd1 sky130_fd_sc_hd__fill_2
XFILLER_0_105_326 vssd1 vssd1 vccd1 vccd1 sky130_fd_sc_hd__fill_2
XFILLER_0_62_246 vssd1 vssd1 vccd1 vccd1 sky130_fd_sc_hd__decap_6
XFILLER_0_7_362 vssd1 vssd1 vccd1 vccd1 sky130_fd_sc_hd__fill_2
X_4839_ _4839_/A _4839_/B _4839_/C vssd1 vssd1 vccd1 vccd1 _4852_/A sky130_fd_sc_hd__nand3_2
XFILLER_0_105_337 vssd1 vssd1 vccd1 vccd1 sky130_fd_sc_hd__fill_2
XFILLER_0_120_307 vssd1 vssd1 vccd1 vccd1 sky130_fd_sc_hd__fill_1
X_6509_ _6834_/CLK _6509_/D vssd1 vssd1 vccd1 vccd1 _6509_/Q sky130_fd_sc_hd__dfxtp_1
XFILLER_0_120_329 vssd1 vssd1 vccd1 vccd1 sky130_fd_sc_hd__fill_2
XFILLER_0_30_154 vssd1 vssd1 vccd1 vccd1 sky130_fd_sc_hd__fill_2
XFILLER_0_30_187 vssd1 vssd1 vccd1 vccd1 sky130_fd_sc_hd__fill_2
XANTENNA_fanout98_A _5687_/A vssd1 vssd1 vccd1 vccd1 sky130_fd_sc_hd__diode_2
Xhold31 hold31/A vssd1 vssd1 vccd1 vccd1 hold31/X sky130_fd_sc_hd__dlygate4sd3_1
Xhold20 hold20/A vssd1 vssd1 vccd1 vccd1 hold20/X sky130_fd_sc_hd__dlygate4sd3_1
Xhold64 hold64/A vssd1 vssd1 vccd1 vccd1 hold64/X sky130_fd_sc_hd__dlygate4sd3_1
Xhold42 hold42/A vssd1 vssd1 vccd1 vccd1 hold42/X sky130_fd_sc_hd__dlygate4sd3_1
Xhold53 hold53/A vssd1 vssd1 vccd1 vccd1 hold53/X sky130_fd_sc_hd__dlygate4sd3_1
Xhold86 hold86/A vssd1 vssd1 vccd1 vccd1 hold86/X sky130_fd_sc_hd__dlygate4sd3_1
Xhold75 hold75/A vssd1 vssd1 vccd1 vccd1 hold75/X sky130_fd_sc_hd__dlygate4sd3_1
Xhold97 hold97/A vssd1 vssd1 vccd1 vccd1 hold97/X sky130_fd_sc_hd__dlygate4sd3_1
XFILLER_0_85_316 vssd1 vssd1 vccd1 vccd1 sky130_fd_sc_hd__decap_3
XFILLER_0_42_29 vssd1 vssd1 vccd1 vccd1 sky130_fd_sc_hd__decap_3
XFILLER_0_38_243 vssd1 vssd1 vccd1 vccd1 sky130_fd_sc_hd__decap_4
XFILLER_0_108_120 vssd1 vssd1 vccd1 vccd1 sky130_fd_sc_hd__decap_3
XFILLER_0_93_393 vssd1 vssd1 vccd1 vccd1 sky130_ef_sc_hd__decap_12
XFILLER_0_93_382 vssd1 vssd1 vccd1 vccd1 sky130_fd_sc_hd__decap_8
XFILLER_0_123_134 vssd1 vssd1 vccd1 vccd1 sky130_fd_sc_hd__fill_1
XFILLER_0_123_123 vssd1 vssd1 vccd1 vccd1 sky130_fd_sc_hd__fill_2
XFILLER_0_108_197 vssd1 vssd1 vccd1 vccd1 sky130_fd_sc_hd__fill_1
XANTENNA_6 sstream_i[10] vssd1 vssd1 vccd1 vccd1 sky130_fd_sc_hd__diode_2
XFILLER_0_6_29 vssd1 vssd1 vccd1 vccd1 sky130_ef_sc_hd__decap_12
XTAP_305 vssd1 vccd1 sky130_fd_sc_hd__tapvpwrvgnd_1
XANTENNA__3662__B _6683_/Q vssd1 vssd1 vccd1 vccd1 sky130_fd_sc_hd__diode_2
XTAP_349 vssd1 vccd1 sky130_fd_sc_hd__tapvpwrvgnd_1
XTAP_338 vssd1 vccd1 sky130_fd_sc_hd__tapvpwrvgnd_1
XTAP_327 vssd1 vccd1 sky130_fd_sc_hd__tapvpwrvgnd_1
XTAP_316 vssd1 vccd1 sky130_fd_sc_hd__tapvpwrvgnd_1
XANTENNA__4774__A _5115_/C vssd1 vssd1 vccd1 vccd1 sky130_fd_sc_hd__diode_2
XFILLER_0_16_41 vssd1 vssd1 vccd1 vccd1 sky130_fd_sc_hd__decap_6
X_6860_ _6863_/CLK _6860_/D vssd1 vssd1 vccd1 vccd1 _6860_/Q sky130_fd_sc_hd__dfxtp_1
XFILLER_0_16_85 vssd1 vssd1 vccd1 vccd1 sky130_fd_sc_hd__fill_1
X_6791_ _6792_/CLK hold6/X vssd1 vssd1 vccd1 vccd1 _6791_/Q sky130_fd_sc_hd__dfxtp_1
X_5811_ tex_addr_i[16] _5919_/B vssd1 vssd1 vccd1 vccd1 _5824_/A sky130_fd_sc_hd__xnor2_1
XFILLER_0_123_31 vssd1 vssd1 vccd1 vccd1 sky130_fd_sc_hd__fill_1
X_5742_ hold278/X _5741_/X _5844_/S vssd1 vssd1 vccd1 vccd1 _6630_/D sky130_fd_sc_hd__mux2_1
XANTENNA__5809__S _5922_/S vssd1 vssd1 vccd1 vccd1 sky130_fd_sc_hd__diode_2
XFILLER_0_17_405 vssd1 vssd1 vccd1 vccd1 sky130_fd_sc_hd__fill_2
XFILLER_0_123_64 vssd1 vssd1 vccd1 vccd1 sky130_fd_sc_hd__fill_2
XFILLER_0_8_159 vssd1 vssd1 vccd1 vccd1 sky130_fd_sc_hd__fill_1
XFILLER_0_8_148 vssd1 vssd1 vccd1 vccd1 sky130_fd_sc_hd__decap_3
XFILLER_0_29_265 vssd1 vssd1 vccd1 vccd1 sky130_fd_sc_hd__fill_2
XFILLER_0_32_62 vssd1 vssd1 vccd1 vccd1 sky130_fd_sc_hd__decap_4
XFILLER_0_32_73 vssd1 vssd1 vccd1 vccd1 sky130_fd_sc_hd__decap_4
XFILLER_0_44_202 vssd1 vssd1 vccd1 vccd1 sky130_fd_sc_hd__fill_2
X_5673_ _5673_/A _5673_/B vssd1 vssd1 vccd1 vccd1 _5673_/Y sky130_fd_sc_hd__xnor2_1
XFILLER_0_84_393 vssd1 vssd1 vccd1 vccd1 sky130_ef_sc_hd__decap_12
XFILLER_0_114_112 vssd1 vssd1 vccd1 vccd1 sky130_fd_sc_hd__fill_1
X_4624_ _4625_/B _4625_/C _4625_/A vssd1 vssd1 vccd1 vccd1 _4629_/A sky130_fd_sc_hd__a21o_1
XFILLER_0_102_318 vssd1 vssd1 vccd1 vccd1 sky130_fd_sc_hd__fill_2
X_4555_ _4554_/B _4554_/C _4554_/A vssd1 vssd1 vccd1 vccd1 _4558_/A sky130_fd_sc_hd__a21bo_1
XFILLER_0_114_178 vssd1 vssd1 vccd1 vccd1 sky130_fd_sc_hd__fill_1
XANTENNA_fanout100_A _5311_/A vssd1 vssd1 vccd1 vccd1 sky130_fd_sc_hd__diode_2
X_3506_ _3507_/A _3507_/B vssd1 vssd1 vccd1 vccd1 _3508_/A sky130_fd_sc_hd__and2_1
X_4486_ _4432_/A _4551_/D _4478_/B _4477_/B vssd1 vssd1 vccd1 vccd1 _4489_/A sky130_fd_sc_hd__a31o_1
X_6225_ _6225_/A _6231_/A vssd1 vssd1 vccd1 vccd1 _6441_/B sky130_fd_sc_hd__nor2_4
X_3437_ _3483_/A _6687_/Q _5311_/A _3437_/D vssd1 vssd1 vccd1 vccd1 _3483_/B sky130_fd_sc_hd__and4b_1
X_6156_ _6787_/Q _6789_/Q vssd1 vssd1 vccd1 vccd1 _6157_/B sky130_fd_sc_hd__nand2_1
XTAP_861 vssd1 vccd1 sky130_fd_sc_hd__tapvpwrvgnd_1
XTAP_850 vssd1 vccd1 sky130_fd_sc_hd__tapvpwrvgnd_1
X_3368_ _3371_/A vssd1 vssd1 vccd1 vccd1 _3370_/C sky130_fd_sc_hd__inv_2
XTAP_894 vssd1 vccd1 sky130_fd_sc_hd__tapvpwrvgnd_1
XTAP_883 vssd1 vccd1 sky130_fd_sc_hd__tapvpwrvgnd_1
XTAP_872 vssd1 vccd1 sky130_fd_sc_hd__tapvpwrvgnd_1
X_5107_ _5107_/A _5107_/B vssd1 vssd1 vccd1 vccd1 _5109_/B sky130_fd_sc_hd__xnor2_1
XFILLER_0_57_92 vssd1 vssd1 vccd1 vccd1 sky130_fd_sc_hd__decap_3
X_3299_ depth_mport_i[27] vssd1 vssd1 vccd1 vccd1 _3299_/Y sky130_fd_sc_hd__inv_2
X_6087_ _6626_/Q hold264/X _6098_/S vssd1 vssd1 vccd1 vccd1 _6087_/X sky130_fd_sc_hd__mux2_1
XFILLER_0_79_143 vssd1 vssd1 vccd1 vccd1 sky130_fd_sc_hd__fill_2
X_5038_ _5421_/B _5038_/B vssd1 vssd1 vccd1 vccd1 _5038_/X sky130_fd_sc_hd__and2_1
XFILLER_0_79_176 vssd1 vssd1 vccd1 vccd1 sky130_fd_sc_hd__decap_4
XFILLER_0_79_187 vssd1 vssd1 vccd1 vccd1 sky130_fd_sc_hd__fill_2
XFILLER_0_137_237 vssd1 vssd1 vccd1 vccd1 sky130_fd_sc_hd__fill_2
XFILLER_0_137_215 vssd1 vssd1 vccd1 vccd1 sky130_fd_sc_hd__fill_2
XANTENNA__3747__B _5327_/A vssd1 vssd1 vccd1 vccd1 sky130_fd_sc_hd__diode_2
XFILLER_0_35_202 vssd1 vssd1 vccd1 vccd1 sky130_fd_sc_hd__decap_8
XANTENNA_fanout13_A _5468_/X vssd1 vssd1 vccd1 vccd1 sky130_fd_sc_hd__diode_2
XFILLER_0_75_393 vssd1 vssd1 vccd1 vccd1 sky130_ef_sc_hd__decap_12
XFILLER_0_90_363 vssd1 vssd1 vccd1 vccd1 sky130_fd_sc_hd__fill_1
XFILLER_0_7_192 vssd1 vssd1 vccd1 vccd1 sky130_fd_sc_hd__decap_4
XFILLER_0_7_181 vssd1 vssd1 vccd1 vccd1 sky130_fd_sc_hd__decap_4
XFILLER_0_35_279 vssd1 vssd1 vccd1 vccd1 sky130_fd_sc_hd__fill_1
XFILLER_0_50_249 vssd1 vssd1 vccd1 vccd1 sky130_fd_sc_hd__decap_3
XFILLER_0_58_305 vssd1 vssd1 vccd1 vccd1 sky130_fd_sc_hd__decap_3
XFILLER_0_58_316 vssd1 vssd1 vccd1 vccd1 sky130_fd_sc_hd__decap_6
XFILLER_0_85_135 vssd1 vssd1 vccd1 vccd1 sky130_fd_sc_hd__fill_1
XFILLER_0_85_113 vssd1 vssd1 vccd1 vccd1 sky130_fd_sc_hd__decap_4
XFILLER_0_58_338 vssd1 vssd1 vccd1 vccd1 sky130_fd_sc_hd__fill_2
XFILLER_0_58_349 vssd1 vssd1 vccd1 vccd1 sky130_fd_sc_hd__decap_3
XANTENNA__4937__A1 _5091_/B vssd1 vssd1 vccd1 vccd1 sky130_fd_sc_hd__diode_2
XPHY_160 vssd1 vssd1 vccd1 vccd1 sky130_fd_sc_hd__decap_3
XANTENNA__4937__B2 _5091_/A vssd1 vssd1 vccd1 vccd1 sky130_fd_sc_hd__diode_2
XPHY_193 vssd1 vssd1 vccd1 vccd1 sky130_fd_sc_hd__decap_3
XPHY_182 vssd1 vssd1 vccd1 vccd1 sky130_fd_sc_hd__decap_3
XPHY_171 vssd1 vssd1 vccd1 vccd1 sky130_fd_sc_hd__decap_3
XFILLER_0_81_374 vssd1 vssd1 vccd1 vccd1 sky130_ef_sc_hd__decap_12
XFILLER_0_26_279 vssd1 vssd1 vccd1 vccd1 sky130_fd_sc_hd__fill_2
XFILLER_0_41_249 vssd1 vssd1 vccd1 vccd1 sky130_fd_sc_hd__decap_6
XFILLER_0_78_47 vssd1 vssd1 vccd1 vccd1 sky130_fd_sc_hd__decap_6
XANTENNA__4488__B _4551_/D vssd1 vssd1 vccd1 vccd1 sky130_fd_sc_hd__diode_2
X_4340_ _4340_/A _4340_/B _4340_/C vssd1 vssd1 vccd1 vccd1 _4342_/B sky130_fd_sc_hd__nand3_1
X_4271_ _4271_/A _4271_/B _4271_/C vssd1 vssd1 vccd1 vccd1 _4279_/A sky130_fd_sc_hd__nand3_1
XFILLER_0_94_35 vssd1 vssd1 vccd1 vccd1 sky130_fd_sc_hd__fill_1
X_6010_ _6009_/Y hold190/X _6038_/C vssd1 vssd1 vccd1 vccd1 _6010_/X sky130_fd_sc_hd__mux2_1
XFILLER_0_118_42 vssd1 vssd1 vccd1 vccd1 sky130_fd_sc_hd__fill_2
XFILLER_0_27_40 vssd1 vssd1 vccd1 vccd1 sky130_fd_sc_hd__fill_2
XANTENNA__3428__A1 _5327_/A vssd1 vssd1 vccd1 vccd1 sky130_fd_sc_hd__diode_2
XANTENNA__3428__B2 _5290_/A vssd1 vssd1 vccd1 vccd1 sky130_fd_sc_hd__diode_2
XFILLER_0_27_73 vssd1 vssd1 vccd1 vccd1 sky130_fd_sc_hd__fill_2
X_6912_ vssd1 vssd1 vccd1 vccd1 _6912_/HI pix_mport_o[13] sky130_fd_sc_hd__conb_1
XFILLER_0_49_305 vssd1 vssd1 vccd1 vccd1 sky130_fd_sc_hd__decap_3
X_6843_ _6862_/CLK _6843_/D vssd1 vssd1 vccd1 vccd1 _6843_/Q sky130_fd_sc_hd__dfxtp_1
XFILLER_0_76_102 vssd1 vssd1 vccd1 vccd1 sky130_fd_sc_hd__fill_2
XFILLER_0_49_316 vssd1 vssd1 vccd1 vccd1 sky130_fd_sc_hd__fill_2
XFILLER_0_134_85 vssd1 vssd1 vccd1 vccd1 sky130_fd_sc_hd__fill_1
X_6774_ _6832_/CLK _6774_/D fanout152/X vssd1 vssd1 vccd1 vccd1 pix_mport_o[46] sky130_fd_sc_hd__dfrtp_4
XANTENNA_fanout148_A fanout149/X vssd1 vssd1 vccd1 vccd1 sky130_fd_sc_hd__diode_2
X_3986_ _3986_/A _3986_/B vssd1 vssd1 vccd1 vccd1 _3989_/B sky130_fd_sc_hd__xnor2_1
XFILLER_0_57_371 vssd1 vssd1 vccd1 vccd1 sky130_ef_sc_hd__decap_12
XFILLER_0_91_149 vssd1 vssd1 vccd1 vccd1 sky130_fd_sc_hd__fill_1
X_5725_ _5713_/B _5715_/B _5711_/Y vssd1 vssd1 vccd1 vccd1 _5727_/B sky130_fd_sc_hd__a21o_1
XANTENNA__3567__B _5081_/B vssd1 vssd1 vccd1 vccd1 sky130_fd_sc_hd__diode_2
XFILLER_0_57_393 vssd1 vssd1 vccd1 vccd1 sky130_ef_sc_hd__decap_12
XFILLER_0_94_3 vssd1 vssd1 vccd1 vccd1 sky130_fd_sc_hd__fill_2
X_5656_ _5656_/A _5656_/B vssd1 vssd1 vccd1 vccd1 _5657_/B sky130_fd_sc_hd__nand2_1
X_4607_ _4607_/A _4607_/B vssd1 vssd1 vccd1 vccd1 _4609_/B sky130_fd_sc_hd__nor2_1
X_5587_ _5417_/X tex_mport_o[53] _5601_/S vssd1 vssd1 vccd1 vccd1 _6610_/D sky130_fd_sc_hd__mux2_1
XFILLER_0_25_290 vssd1 vssd1 vccd1 vccd1 sky130_fd_sc_hd__fill_2
XFILLER_0_102_137 vssd1 vssd1 vccd1 vccd1 sky130_fd_sc_hd__decap_3
X_4538_ _4538_/A _4538_/B vssd1 vssd1 vccd1 vccd1 _4541_/B sky130_fd_sc_hd__xor2_1
X_4469_ _5687_/B _4637_/D vssd1 vssd1 vccd1 vccd1 _4471_/B sky130_fd_sc_hd__and2_1
XFILLER_0_68_80 vssd1 vssd1 vccd1 vccd1 sky130_fd_sc_hd__fill_2
XANTENNA__5105__A1 _5093_/A vssd1 vssd1 vccd1 vccd1 sky130_fd_sc_hd__diode_2
X_6208_ _6208_/A _6208_/B vssd1 vssd1 vccd1 vccd1 _6212_/B sky130_fd_sc_hd__nor2_1
XFILLER_0_68_91 vssd1 vssd1 vccd1 vccd1 sky130_fd_sc_hd__decap_3
X_6139_ _6785_/Q _6787_/Q vssd1 vssd1 vccd1 vccd1 _6150_/A sky130_fd_sc_hd__nand2_2
XTAP_680 vssd1 vccd1 sky130_fd_sc_hd__tapvpwrvgnd_1
XTAP_691 vssd1 vccd1 sky130_fd_sc_hd__tapvpwrvgnd_1
XFILLER_0_67_113 vssd1 vssd1 vccd1 vccd1 sky130_fd_sc_hd__fill_2
XFILLER_0_67_102 vssd1 vssd1 vccd1 vccd1 sky130_fd_sc_hd__fill_2
XFILLER_0_67_135 vssd1 vssd1 vccd1 vccd1 sky130_fd_sc_hd__fill_2
XANTENNA__5592__B2 _5588_/C vssd1 vssd1 vccd1 vccd1 sky130_fd_sc_hd__diode_2
XFILLER_0_82_138 vssd1 vssd1 vccd1 vccd1 sky130_fd_sc_hd__fill_2
XFILLER_0_31_271 vssd1 vssd1 vccd1 vccd1 sky130_fd_sc_hd__fill_1
XANTENNA__3643__D _5276_/A vssd1 vssd1 vccd1 vccd1 sky130_fd_sc_hd__diode_2
XFILLER_0_31_293 vssd1 vssd1 vccd1 vccd1 sky130_fd_sc_hd__decap_4
XANTENNA__4083__A1 _4432_/A vssd1 vssd1 vccd1 vccd1 sky130_fd_sc_hd__diode_2
XFILLER_0_73_105 vssd1 vssd1 vccd1 vccd1 sky130_fd_sc_hd__fill_2
X_3840_ _3758_/Y _3781_/X _3838_/A _3838_/Y vssd1 vssd1 vccd1 vccd1 _3854_/B sky130_fd_sc_hd__o211a_1
XFILLER_0_104_66 vssd1 vssd1 vccd1 vccd1 sky130_fd_sc_hd__decap_3
XANTENNA__3387__B _5327_/A vssd1 vssd1 vccd1 vccd1 sky130_fd_sc_hd__diode_2
X_3771_ _3771_/A _3771_/B _3771_/C vssd1 vssd1 vccd1 vccd1 _3772_/B sky130_fd_sc_hd__or3_1
XFILLER_0_39_393 vssd1 vssd1 vccd1 vccd1 sky130_ef_sc_hd__decap_12
X_5510_ hold215/X sstream_i[101] _6464_/S vssd1 vssd1 vccd1 vccd1 _6543_/D sky130_fd_sc_hd__mux2_1
XFILLER_0_13_86 vssd1 vssd1 vccd1 vccd1 sky130_fd_sc_hd__fill_2
XFILLER_0_54_385 vssd1 vssd1 vccd1 vccd1 sky130_ef_sc_hd__decap_12
X_6490_ hold97/X sstream_i[48] _6493_/S vssd1 vssd1 vccd1 vccd1 _6881_/D sky130_fd_sc_hd__mux2_1
XFILLER_0_81_193 vssd1 vssd1 vccd1 vccd1 sky130_fd_sc_hd__fill_1
XANTENNA__4138__A2 _4841_/C vssd1 vssd1 vccd1 vccd1 sky130_fd_sc_hd__diode_2
X_5441_ _5441_/A _5441_/B _5441_/C _5441_/D vssd1 vssd1 vccd1 vccd1 _5442_/B sky130_fd_sc_hd__and4_1
X_5372_ _4689_/A _4689_/B _5370_/A vssd1 vssd1 vccd1 vccd1 _5373_/B sky130_fd_sc_hd__o21bai_1
XFILLER_0_10_400 vssd1 vssd1 vccd1 vccd1 sky130_fd_sc_hd__decap_6
XFILLER_0_1_143 vssd1 vssd1 vccd1 vccd1 sky130_fd_sc_hd__fill_2
XANTENNA__3897__A1 _5106_/A vssd1 vssd1 vccd1 vccd1 sky130_fd_sc_hd__diode_2
X_4323_ _4344_/A _4344_/B vssd1 vssd1 vccd1 vccd1 _4323_/X sky130_fd_sc_hd__or2_1
Xfanout118 tex_width_i[15] vssd1 vssd1 vccd1 vccd1 _5801_/A sky130_fd_sc_hd__buf_6
Xfanout107 _5093_/A vssd1 vssd1 vccd1 vccd1 _5299_/A sky130_fd_sc_hd__clkbuf_4
Xfanout129 _5754_/A vssd1 vssd1 vccd1 vccd1 _4966_/C sky130_fd_sc_hd__buf_4
XANTENNA__5822__S _5923_/S vssd1 vssd1 vccd1 vccd1 sky130_fd_sc_hd__diode_2
X_4254_ _4254_/A _4254_/B vssd1 vssd1 vccd1 vccd1 _4261_/A sky130_fd_sc_hd__xor2_1
XFILLER_0_38_83 vssd1 vssd1 vccd1 vccd1 sky130_fd_sc_hd__fill_1
X_4185_ _4183_/X _4186_/B vssd1 vssd1 vccd1 vccd1 _4187_/B sky130_fd_sc_hd__and2b_1
XTAP_1109 vssd1 vccd1 sky130_fd_sc_hd__tapvpwrvgnd_1
XFILLER_0_54_60 vssd1 vssd1 vccd1 vccd1 sky130_fd_sc_hd__fill_1
XFILLER_0_54_82 vssd1 vssd1 vccd1 vccd1 sky130_fd_sc_hd__fill_2
X_6826_ _6832_/CLK _6826_/D fanout152/X vssd1 vssd1 vccd1 vccd1 depth_mport_o[48]
+ sky130_fd_sc_hd__dfrtp_4
X_6757_ _6853_/CLK _6757_/D fanout149/X vssd1 vssd1 vccd1 vccd1 pix_mport_o[5] sky130_fd_sc_hd__dfrtp_4
XFILLER_0_9_254 vssd1 vssd1 vccd1 vccd1 sky130_fd_sc_hd__decap_3
XFILLER_0_45_330 vssd1 vssd1 vccd1 vccd1 sky130_fd_sc_hd__decap_4
X_5708_ hold172/X _5707_/X _5844_/S vssd1 vssd1 vccd1 vccd1 _6627_/D sky130_fd_sc_hd__mux2_1
X_3969_ _3970_/A _3970_/B vssd1 vssd1 vccd1 vccd1 _3992_/B sky130_fd_sc_hd__and2_1
X_6688_ _6693_/CLK _6688_/D vssd1 vssd1 vccd1 vccd1 _6688_/Q sky130_fd_sc_hd__dfxtp_2
XFILLER_0_60_300 vssd1 vssd1 vccd1 vccd1 sky130_fd_sc_hd__decap_8
X_5639_ _3250_/Y _6506_/Q _5802_/B vssd1 vssd1 vccd1 vccd1 _5640_/B sky130_fd_sc_hd__mux2_1
XFILLER_0_60_333 vssd1 vssd1 vccd1 vccd1 sky130_fd_sc_hd__fill_2
XFILLER_0_130_232 vssd1 vssd1 vccd1 vccd1 sky130_fd_sc_hd__decap_3
XFILLER_0_79_90 vssd1 vssd1 vccd1 vccd1 sky130_fd_sc_hd__fill_2
XANTENNA__5877__A2 _5882_/B vssd1 vssd1 vccd1 vccd1 sky130_fd_sc_hd__diode_2
Xhold150 _6621_/Q vssd1 vssd1 vccd1 vccd1 hold150/X sky130_fd_sc_hd__dlygate4sd3_1
Xhold161 _6510_/Q vssd1 vssd1 vccd1 vccd1 hold161/X sky130_fd_sc_hd__dlygate4sd3_1
XFILLER_0_13_271 vssd1 vssd1 vccd1 vccd1 sky130_fd_sc_hd__fill_2
Xhold194 _6834_/Q vssd1 vssd1 vccd1 vccd1 hold194/X sky130_fd_sc_hd__dlygate4sd3_1
Xhold172 _6627_/Q vssd1 vssd1 vccd1 vccd1 hold172/X sky130_fd_sc_hd__dlygate4sd3_1
Xhold183 _6873_/Q vssd1 vssd1 vccd1 vccd1 hold183/X sky130_fd_sc_hd__dlygate4sd3_1
XFILLER_0_34_19 vssd1 vssd1 vccd1 vccd1 sky130_fd_sc_hd__decap_3
XANTENNA__5687__B _5687_/B vssd1 vssd1 vccd1 vccd1 sky130_fd_sc_hd__diode_2
XFILLER_0_95_252 vssd1 vssd1 vccd1 vccd1 sky130_ef_sc_hd__decap_12
XFILLER_0_138_365 vssd1 vssd1 vccd1 vccd1 sky130_ef_sc_hd__decap_12
XFILLER_0_50_29 vssd1 vssd1 vccd1 vccd1 sky130_fd_sc_hd__fill_2
XFILLER_0_51_311 vssd1 vssd1 vccd1 vccd1 sky130_fd_sc_hd__fill_2
XFILLER_0_106_251 vssd1 vssd1 vccd1 vccd1 sky130_fd_sc_hd__fill_1
XANTENNA__4112__A _5701_/A vssd1 vssd1 vccd1 vccd1 sky130_fd_sc_hd__diode_2
XANTENNA__3879__A1 _5049_/B vssd1 vssd1 vccd1 vccd1 sky130_fd_sc_hd__diode_2
XANTENNA__3879__B2 _5049_/A vssd1 vssd1 vccd1 vccd1 sky130_fd_sc_hd__diode_2
XANTENNA__3500__B1 _5296_/B vssd1 vssd1 vccd1 vccd1 sky130_fd_sc_hd__diode_2
XANTENNA__3646__A4 _5276_/A vssd1 vssd1 vccd1 vccd1 sky130_fd_sc_hd__diode_2
XFILLER_0_91_14 vssd1 vssd1 vccd1 vccd1 sky130_fd_sc_hd__decap_3
XANTENNA__6045__A2 _6038_/B vssd1 vssd1 vccd1 vccd1 sky130_fd_sc_hd__diode_2
X_5990_ _4971_/B _5989_/X _6037_/S vssd1 vssd1 vccd1 vccd1 _6666_/D sky130_fd_sc_hd__mux2_1
XFILLER_0_115_54 vssd1 vssd1 vccd1 vccd1 sky130_fd_sc_hd__fill_2
X_4941_ _4941_/A _4941_/B vssd1 vssd1 vccd1 vccd1 _4941_/X sky130_fd_sc_hd__xor2_1
XANTENNA__3398__A _3999_/A vssd1 vssd1 vccd1 vccd1 sky130_fd_sc_hd__diode_2
XANTENNA__3829__C _5299_/A vssd1 vssd1 vccd1 vccd1 sky130_fd_sc_hd__diode_2
X_4872_ _4926_/B _4872_/B _4872_/C _4872_/D vssd1 vssd1 vccd1 vccd1 _4872_/Y sky130_fd_sc_hd__nand4_4
X_6611_ _6792_/CLK _6611_/D fanout150/X vssd1 vssd1 vccd1 vccd1 tex_mport_o[54] sky130_fd_sc_hd__dfrtp_4
X_3823_ _5051_/A _5106_/B _3821_/B _3819_/X vssd1 vssd1 vccd1 vccd1 _3831_/B sky130_fd_sc_hd__a31o_1
XANTENNA__5817__S _5923_/S vssd1 vssd1 vccd1 vccd1 sky130_fd_sc_hd__diode_2
XFILLER_0_6_202 vssd1 vssd1 vccd1 vccd1 sky130_fd_sc_hd__decap_3
X_6542_ _6862_/CLK _6542_/D vssd1 vssd1 vccd1 vccd1 hold53/A sky130_fd_sc_hd__dfxtp_2
X_3754_ _3755_/A _3755_/B _3755_/C vssd1 vssd1 vccd1 vccd1 _3756_/A sky130_fd_sc_hd__o21a_1
X_6473_ hold225/X sstream_i[31] _6473_/S vssd1 vssd1 vccd1 vccd1 _6864_/D sky130_fd_sc_hd__mux2_1
X_3685_ _6648_/Q _3767_/B vssd1 vssd1 vccd1 vccd1 _3768_/A sky130_fd_sc_hd__nand2_2
XANTENNA__5118__A _5754_/B vssd1 vssd1 vccd1 vccd1 sky130_fd_sc_hd__diode_2
XFILLER_0_42_388 vssd1 vssd1 vccd1 vccd1 sky130_ef_sc_hd__decap_12
X_5424_ _5424_/A _5424_/B _5424_/C vssd1 vssd1 vccd1 vccd1 _5424_/X sky130_fd_sc_hd__and3_1
XFILLER_0_49_71 vssd1 vssd1 vccd1 vccd1 sky130_fd_sc_hd__decap_3
X_5355_ _5355_/A _5355_/B vssd1 vssd1 vccd1 vccd1 _5355_/Y sky130_fd_sc_hd__nor2_1
X_4306_ _4309_/A _4309_/B vssd1 vssd1 vccd1 vccd1 _4306_/Y sky130_fd_sc_hd__nand2_1
X_5286_ _5286_/A _5286_/B vssd1 vssd1 vccd1 vccd1 _5287_/B sky130_fd_sc_hd__nand2_1
X_4237_ _4237_/A _4237_/B _4264_/A vssd1 vssd1 vccd1 vccd1 _4241_/A sky130_fd_sc_hd__or3_1
X_4168_ _4165_/X _4166_/Y _4119_/B _4121_/B vssd1 vssd1 vccd1 vccd1 _4169_/B sky130_fd_sc_hd__o211ai_1
X_4099_ _4970_/B _5718_/B _4146_/A _4099_/D vssd1 vssd1 vccd1 vccd1 _4146_/B sky130_fd_sc_hd__nand4_2
XFILLER_0_77_230 vssd1 vssd1 vccd1 vccd1 sky130_fd_sc_hd__decap_3
X_6809_ _6818_/CLK _6809_/D fanout150/X vssd1 vssd1 vccd1 vccd1 _6809_/Q sky130_fd_sc_hd__dfrtp_1
XFILLER_0_135_324 vssd1 vssd1 vccd1 vccd1 sky130_fd_sc_hd__fill_2
XFILLER_0_92_299 vssd1 vssd1 vccd1 vccd1 sky130_fd_sc_hd__fill_2
XFILLER_0_135_379 vssd1 vssd1 vccd1 vccd1 sky130_ef_sc_hd__decap_12
XFILLER_0_33_333 vssd1 vssd1 vccd1 vccd1 sky130_fd_sc_hd__decap_3
XFILLER_0_33_344 vssd1 vssd1 vccd1 vccd1 sky130_fd_sc_hd__fill_2
XFILLER_0_45_182 vssd1 vssd1 vccd1 vccd1 sky130_fd_sc_hd__fill_1
XFILLER_0_103_210 vssd1 vssd1 vccd1 vccd1 sky130_fd_sc_hd__fill_2
XFILLER_0_33_377 vssd1 vssd1 vccd1 vccd1 sky130_fd_sc_hd__fill_2
XFILLER_0_103_254 vssd1 vssd1 vccd1 vccd1 sky130_fd_sc_hd__fill_2
XFILLER_0_29_19 vssd1 vssd1 vccd1 vccd1 sky130_fd_sc_hd__fill_2
XANTENNA__5786__A1 _5787_/B vssd1 vssd1 vccd1 vccd1 sky130_fd_sc_hd__diode_2
XANTENNA__4107__A _5083_/A vssd1 vssd1 vccd1 vccd1 sky130_fd_sc_hd__diode_2
XFILLER_0_83_211 vssd1 vssd1 vccd1 vccd1 sky130_fd_sc_hd__decap_4
XFILLER_0_68_296 vssd1 vssd1 vccd1 vccd1 sky130_ef_sc_hd__decap_12
XFILLER_0_138_195 vssd1 vssd1 vccd1 vccd1 sky130_fd_sc_hd__fill_1
XFILLER_0_24_300 vssd1 vssd1 vccd1 vccd1 sky130_fd_sc_hd__fill_1
XFILLER_0_36_160 vssd1 vssd1 vccd1 vccd1 sky130_fd_sc_hd__fill_2
XFILLER_0_24_322 vssd1 vssd1 vccd1 vccd1 sky130_fd_sc_hd__fill_2
XFILLER_0_24_355 vssd1 vssd1 vccd1 vccd1 sky130_fd_sc_hd__decap_8
XFILLER_0_51_141 vssd1 vssd1 vccd1 vccd1 sky130_fd_sc_hd__fill_2
XFILLER_0_10_65 vssd1 vssd1 vccd1 vccd1 sky130_ef_sc_hd__decap_12
X_3470_ _3470_/A _3470_/B vssd1 vssd1 vccd1 vccd1 _3558_/A sky130_fd_sc_hd__or2_1
X_5140_ _5139_/B _5139_/C _5139_/A vssd1 vssd1 vccd1 vccd1 _5141_/C sky130_fd_sc_hd__a21bo_1
X_5071_ _5071_/A _5106_/A vssd1 vssd1 vccd1 vccd1 _5073_/B sky130_fd_sc_hd__nand2_1
XFILLER_0_19_85 vssd1 vssd1 vccd1 vccd1 sky130_fd_sc_hd__decap_4
X_4022_ _3858_/B _4020_/X _3938_/A _3934_/Y vssd1 vssd1 vccd1 vccd1 _5264_/C sky130_fd_sc_hd__o211a_1
XANTENNA__4029__A1 _4971_/D vssd1 vssd1 vccd1 vccd1 sky130_fd_sc_hd__diode_2
X_5973_ tex_height_i[0] tex_height_i[1] vssd1 vssd1 vccd1 vccd1 _5973_/Y sky130_fd_sc_hd__xnor2_1
XFILLER_0_59_230 vssd1 vssd1 vccd1 vccd1 sky130_fd_sc_hd__fill_2
X_4924_ _4924_/A _4924_/B _4924_/C vssd1 vssd1 vccd1 vccd1 _4924_/X sky130_fd_sc_hd__or3_2
XFILLER_0_117_335 vssd1 vssd1 vccd1 vccd1 sky130_fd_sc_hd__fill_1
XFILLER_0_62_406 vssd1 vssd1 vccd1 vccd1 sky130_fd_sc_hd__fill_1
X_4855_ _4855_/A _4855_/B _4855_/C vssd1 vssd1 vccd1 vccd1 _4855_/Y sky130_fd_sc_hd__nand3_2
X_3806_ _3959_/B _5754_/B _3793_/X _3794_/X _5115_/B vssd1 vssd1 vccd1 vccd1 _3809_/B
+ sky130_fd_sc_hd__a32o_1
XFILLER_0_27_160 vssd1 vssd1 vccd1 vccd1 sky130_fd_sc_hd__decap_3
X_4786_ _4783_/X _4786_/B vssd1 vssd1 vccd1 vccd1 _4866_/B sky130_fd_sc_hd__nand2b_1
X_6525_ _6834_/CLK _6525_/D vssd1 vssd1 vccd1 vccd1 hold31/A sky130_fd_sc_hd__dfxtp_1
X_3737_ _3655_/X _3705_/Y _3735_/A _3735_/Y vssd1 vssd1 vccd1 vccd1 _3758_/B sky130_fd_sc_hd__a211oi_2
XANTENNA__3960__B1 _5081_/D vssd1 vssd1 vccd1 vccd1 sky130_fd_sc_hd__diode_2
XFILLER_0_42_141 vssd1 vssd1 vccd1 vccd1 sky130_fd_sc_hd__fill_2
X_6456_ hold155/X sstream_i[14] _6473_/S vssd1 vssd1 vccd1 vccd1 _6847_/D sky130_fd_sc_hd__mux2_1
X_3668_ _5299_/A _6686_/Q _3666_/Y _3667_/X vssd1 vssd1 vccd1 vccd1 _3670_/A sky130_fd_sc_hd__o2bb2a_1
X_6387_ hold53/A hold7/A vssd1 vssd1 vccd1 vccd1 _6388_/C sky130_fd_sc_hd__or2_1
X_5407_ _6736_/Q _5407_/B vssd1 vssd1 vccd1 vccd1 _5407_/Y sky130_fd_sc_hd__xnor2_1
X_3599_ _5081_/B _5787_/B _3597_/B _3595_/X vssd1 vssd1 vccd1 vccd1 _3601_/B sky130_fd_sc_hd__a31o_1
X_5338_ _5594_/B _5594_/C _6746_/Q vssd1 vssd1 vccd1 vccd1 _5338_/Y sky130_fd_sc_hd__o21ai_1
XANTENNA__4268__B2 _5687_/A vssd1 vssd1 vccd1 vccd1 sky130_fd_sc_hd__diode_2
XANTENNA__4268__A1 _5701_/A vssd1 vssd1 vccd1 vccd1 sky130_fd_sc_hd__diode_2
X_5269_ _3773_/X _3776_/X _3698_/B _3701_/X vssd1 vssd1 vccd1 vccd1 _5437_/B sky130_fd_sc_hd__a211oi_2
XANTENNA__6407__A hold7/A vssd1 vssd1 vccd1 vccd1 sky130_fd_sc_hd__diode_2
XFILLER_0_97_358 vssd1 vssd1 vccd1 vccd1 sky130_fd_sc_hd__fill_2
XFILLER_0_92_90 vssd1 vssd1 vccd1 vccd1 sky130_fd_sc_hd__fill_1
XANTENNA_fanout43_A _5071_/A vssd1 vssd1 vccd1 vccd1 sky130_fd_sc_hd__diode_2
XANTENNA__5311__A _5311_/A vssd1 vssd1 vccd1 vccd1 sky130_fd_sc_hd__diode_2
XFILLER_0_65_233 vssd1 vssd1 vccd1 vccd1 sky130_fd_sc_hd__fill_2
XFILLER_0_135_143 vssd1 vssd1 vccd1 vccd1 sky130_fd_sc_hd__fill_2
XFILLER_0_108_357 vssd1 vssd1 vccd1 vccd1 sky130_fd_sc_hd__decap_6
XFILLER_0_65_277 vssd1 vssd1 vccd1 vccd1 sky130_fd_sc_hd__decap_3
XANTENNA__3951__B1 _5118_/B vssd1 vssd1 vccd1 vccd1 sky130_fd_sc_hd__diode_2
XFILLER_0_131_393 vssd1 vssd1 vccd1 vccd1 sky130_ef_sc_hd__decap_12
XFILLER_0_131_382 vssd1 vssd1 vccd1 vccd1 sky130_fd_sc_hd__decap_8
XFILLER_0_21_369 vssd1 vssd1 vccd1 vccd1 sky130_fd_sc_hd__decap_3
XTAP_509 vssd1 vccd1 sky130_fd_sc_hd__tapvpwrvgnd_1
XANTENNA__4259__A1 _4842_/A vssd1 vssd1 vccd1 vccd1 sky130_fd_sc_hd__diode_2
XFILLER_0_88_303 vssd1 vssd1 vccd1 vccd1 sky130_fd_sc_hd__fill_2
XFILLER_0_72_49 vssd1 vssd1 vccd1 vccd1 sky130_fd_sc_hd__fill_2
XFILLER_0_72_38 vssd1 vssd1 vccd1 vccd1 sky130_fd_sc_hd__fill_2
XFILLER_0_72_27 vssd1 vssd1 vccd1 vccd1 sky130_fd_sc_hd__fill_1
XANTENNA__3379__C _5272_/B vssd1 vssd1 vccd1 vccd1 sky130_fd_sc_hd__diode_2
XFILLER_0_44_406 vssd1 vssd1 vccd1 vccd1 sky130_fd_sc_hd__fill_1
XFILLER_0_126_121 vssd1 vssd1 vccd1 vccd1 sky130_fd_sc_hd__fill_1
X_4640_ _4637_/X _4640_/B vssd1 vssd1 vccd1 vccd1 _4675_/B sky130_fd_sc_hd__and2b_1
XFILLER_0_71_225 vssd1 vssd1 vccd1 vccd1 sky130_fd_sc_hd__fill_2
XFILLER_0_71_203 vssd1 vssd1 vccd1 vccd1 sky130_fd_sc_hd__fill_2
XFILLER_0_115_3 vssd1 vssd1 vccd1 vccd1 sky130_fd_sc_hd__fill_2
X_6310_ hold49/X hold11/X _6319_/S vssd1 vssd1 vccd1 vccd1 _6793_/D sky130_fd_sc_hd__mux2_1
X_4571_ _4571_/A _4571_/B _4571_/C vssd1 vssd1 vccd1 vccd1 _4571_/Y sky130_fd_sc_hd__nand3_1
XFILLER_0_21_97 vssd1 vssd1 vccd1 vccd1 sky130_fd_sc_hd__fill_2
XFILLER_0_24_141 vssd1 vssd1 vccd1 vccd1 sky130_fd_sc_hd__decap_4
XFILLER_0_24_163 vssd1 vssd1 vccd1 vccd1 sky130_fd_sc_hd__fill_2
XFILLER_0_97_46 vssd1 vssd1 vccd1 vccd1 sky130_fd_sc_hd__fill_1
XFILLER_0_12_336 vssd1 vssd1 vccd1 vccd1 sky130_fd_sc_hd__fill_2
X_3522_ _3961_/A _5308_/B _5277_/B _3870_/A vssd1 vssd1 vccd1 vccd1 _3522_/Y sky130_fd_sc_hd__a22oi_1
Xfanout9 _6486_/S vssd1 vssd1 vccd1 vccd1 _6493_/S sky130_fd_sc_hd__clkbuf_8
X_6241_ _3304_/Y _6855_/Q _3305_/Y _6854_/Q vssd1 vssd1 vccd1 vccd1 _6241_/X sky130_fd_sc_hd__o22a_1
XFILLER_0_122_393 vssd1 vssd1 vccd1 vccd1 sky130_ef_sc_hd__decap_12
XFILLER_0_122_360 vssd1 vssd1 vccd1 vccd1 sky130_fd_sc_hd__fill_2
X_3453_ _3453_/A _3453_/B vssd1 vssd1 vccd1 vccd1 _3454_/B sky130_fd_sc_hd__nor2_1
X_6172_ fb_i _6172_/B vssd1 vssd1 vccd1 vccd1 _6173_/B sky130_fd_sc_hd__or2_1
Xclkbuf_2_0__f_clk_i clkbuf_0_clk_i/X vssd1 vssd1 vccd1 vccd1 clkbuf_leaf_1_clk_i/A
+ sky130_fd_sc_hd__clkbuf_16
XANTENNA__4657__D _4658_/D vssd1 vssd1 vccd1 vccd1 sky130_fd_sc_hd__diode_2
X_3384_ _3384_/A _3384_/B _3391_/B vssd1 vssd1 vccd1 vccd1 _3384_/X sky130_fd_sc_hd__or3b_1
X_5123_ _5121_/A _5121_/C _5121_/B vssd1 vssd1 vccd1 vccd1 _5124_/B sky130_fd_sc_hd__a21o_1
XANTENNA__5830__S _5923_/S vssd1 vssd1 vccd1 vccd1 sky130_fd_sc_hd__diode_2
X_5054_ _5054_/A _5054_/B _5054_/C vssd1 vssd1 vccd1 vccd1 _5101_/A sky130_fd_sc_hd__nand3_2
XFILLER_0_79_325 vssd1 vssd1 vccd1 vccd1 sky130_fd_sc_hd__decap_8
X_4005_ _6645_/Q _4005_/B vssd1 vssd1 vccd1 vccd1 _4006_/B sky130_fd_sc_hd__or2_1
XFILLER_0_94_339 vssd1 vssd1 vccd1 vccd1 sky130_fd_sc_hd__decap_6
XANTENNA__4970__A _5787_/B vssd1 vssd1 vccd1 vccd1 sky130_fd_sc_hd__diode_2
X_5956_ _3289_/Y _6869_/Q _6868_/Q _3290_/Y _5955_/X vssd1 vssd1 vccd1 vccd1 _5956_/X
+ sky130_fd_sc_hd__a221o_1
X_4907_ _5083_/A _5666_/A vssd1 vssd1 vccd1 vccd1 _4909_/B sky130_fd_sc_hd__nand2_1
X_5887_ _5887_/A _5887_/B vssd1 vssd1 vccd1 vccd1 _5887_/Y sky130_fd_sc_hd__nand2_1
XFILLER_0_47_255 vssd1 vssd1 vccd1 vccd1 sky130_fd_sc_hd__fill_1
XFILLER_0_117_121 vssd1 vssd1 vccd1 vccd1 sky130_fd_sc_hd__decap_3
XFILLER_0_47_277 vssd1 vssd1 vccd1 vccd1 sky130_fd_sc_hd__decap_3
XFILLER_0_47_288 vssd1 vssd1 vccd1 vccd1 sky130_ef_sc_hd__decap_12
X_4838_ _4837_/A _4837_/B _4837_/C vssd1 vssd1 vccd1 vccd1 _4839_/C sky130_fd_sc_hd__a21o_1
XFILLER_0_7_352 vssd1 vssd1 vccd1 vccd1 sky130_fd_sc_hd__decap_3
XFILLER_0_117_198 vssd1 vssd1 vccd1 vccd1 sky130_fd_sc_hd__fill_2
X_4769_ _4769_/A _4769_/B vssd1 vssd1 vccd1 vccd1 _4771_/B sky130_fd_sc_hd__or2_1
X_6508_ _6834_/CLK _6508_/D vssd1 vssd1 vccd1 vccd1 _6508_/Q sky130_fd_sc_hd__dfxtp_1
X_6439_ depth_mport_o[52] _6440_/B vssd1 vssd1 vccd1 vccd1 _6830_/D sky130_fd_sc_hd__and2_1
XFILLER_0_113_393 vssd1 vssd1 vccd1 vccd1 sky130_ef_sc_hd__decap_12
XFILLER_0_11_391 vssd1 vssd1 vccd1 vccd1 sky130_fd_sc_hd__fill_1
Xhold32 hold32/A vssd1 vssd1 vccd1 vccd1 hold32/X sky130_fd_sc_hd__dlygate4sd3_1
Xhold10 hold10/A vssd1 vssd1 vccd1 vccd1 hold10/X sky130_fd_sc_hd__dlygate4sd3_1
Xhold21 hold21/A vssd1 vssd1 vccd1 vccd1 hold21/X sky130_fd_sc_hd__dlygate4sd3_1
Xhold54 hold54/A vssd1 vssd1 vccd1 vccd1 hold54/X sky130_fd_sc_hd__dlygate4sd3_1
Xhold65 hold65/A vssd1 vssd1 vccd1 vccd1 hold65/X sky130_fd_sc_hd__dlygate4sd3_1
Xhold43 hold43/A vssd1 vssd1 vccd1 vccd1 hold43/X sky130_fd_sc_hd__dlygate4sd3_1
Xhold87 hold87/A vssd1 vssd1 vccd1 vccd1 hold87/X sky130_fd_sc_hd__dlygate4sd3_1
Xhold98 hold98/A vssd1 vssd1 vccd1 vccd1 hold98/X sky130_fd_sc_hd__dlygate4sd3_1
Xhold76 hold76/A vssd1 vssd1 vccd1 vccd1 hold76/X sky130_fd_sc_hd__dlygate4sd3_1
XFILLER_0_38_233 vssd1 vssd1 vccd1 vccd1 sky130_fd_sc_hd__decap_4
XFILLER_0_26_406 vssd1 vssd1 vccd1 vccd1 sky130_fd_sc_hd__fill_1
XFILLER_0_53_225 vssd1 vssd1 vccd1 vccd1 sky130_fd_sc_hd__decap_3
XANTENNA_7 sstream_i[10] vssd1 vssd1 vccd1 vccd1 sky130_fd_sc_hd__diode_2
XFILLER_0_21_111 vssd1 vssd1 vccd1 vccd1 sky130_fd_sc_hd__fill_1
XTAP_306 vssd1 vccd1 sky130_fd_sc_hd__tapvpwrvgnd_1
XTAP_339 vssd1 vccd1 sky130_fd_sc_hd__tapvpwrvgnd_1
XTAP_328 vssd1 vccd1 sky130_fd_sc_hd__tapvpwrvgnd_1
XTAP_317 vssd1 vccd1 sky130_fd_sc_hd__tapvpwrvgnd_1
XANTENNA__4774__B _4774_/B vssd1 vssd1 vccd1 vccd1 sky130_fd_sc_hd__diode_2
XFILLER_0_88_166 vssd1 vssd1 vccd1 vccd1 sky130_fd_sc_hd__decap_3
XFILLER_0_76_306 vssd1 vssd1 vccd1 vccd1 sky130_fd_sc_hd__fill_2
X_6790_ _6792_/CLK _6790_/D vssd1 vssd1 vccd1 vccd1 hold22/A sky130_fd_sc_hd__dfxtp_1
XFILLER_0_88_188 vssd1 vssd1 vccd1 vccd1 sky130_fd_sc_hd__decap_4
X_5810_ hold274/X _5809_/X _5923_/S vssd1 vssd1 vccd1 vccd1 _6636_/D sky130_fd_sc_hd__mux2_1
XFILLER_0_29_211 vssd1 vssd1 vccd1 vccd1 sky130_fd_sc_hd__decap_3
X_5741_ _5388_/B _5740_/X _5784_/S vssd1 vssd1 vccd1 vccd1 _5741_/X sky130_fd_sc_hd__mux2_1
XFILLER_0_29_233 vssd1 vssd1 vccd1 vccd1 sky130_fd_sc_hd__decap_6
XFILLER_0_29_255 vssd1 vssd1 vccd1 vccd1 sky130_fd_sc_hd__fill_2
X_5672_ _5662_/A _5662_/B _5659_/Y vssd1 vssd1 vccd1 vccd1 _5673_/B sky130_fd_sc_hd__o21ai_1
XFILLER_0_32_85 vssd1 vssd1 vccd1 vccd1 sky130_fd_sc_hd__fill_1
XFILLER_0_44_236 vssd1 vssd1 vccd1 vccd1 sky130_fd_sc_hd__decap_3
X_4623_ _4625_/B _4625_/C _4625_/A vssd1 vssd1 vccd1 vccd1 _4626_/A sky130_fd_sc_hd__a21oi_1
XFILLER_0_44_269 vssd1 vssd1 vccd1 vccd1 sky130_fd_sc_hd__decap_3
X_4554_ _4554_/A _4554_/B _4554_/C vssd1 vssd1 vccd1 vccd1 _4566_/A sky130_fd_sc_hd__nand3_1
X_3505_ _3505_/A _3505_/B vssd1 vssd1 vccd1 vccd1 _3507_/B sky130_fd_sc_hd__xor2_1
X_6224_ pix_mport_o[68] _6224_/B vssd1 vssd1 vccd1 vccd1 _6779_/D sky130_fd_sc_hd__or2_1
X_4485_ _4485_/A _4485_/B _4528_/A vssd1 vssd1 vccd1 vccd1 _4498_/A sky130_fd_sc_hd__and3_1
X_3436_ _5049_/A _5292_/A _5276_/B _6686_/Q vssd1 vssd1 vccd1 vccd1 _3483_/A sky130_fd_sc_hd__and4_1
X_6155_ _6787_/Q _6789_/Q vssd1 vssd1 vccd1 vccd1 _6157_/A sky130_fd_sc_hd__or2_1
XTAP_862 vssd1 vccd1 sky130_fd_sc_hd__tapvpwrvgnd_1
XTAP_851 vssd1 vccd1 sky130_fd_sc_hd__tapvpwrvgnd_1
XTAP_840 vssd1 vccd1 sky130_fd_sc_hd__tapvpwrvgnd_1
X_3367_ _5306_/A _5049_/B _5286_/B _5296_/B vssd1 vssd1 vccd1 vccd1 _3371_/A sky130_fd_sc_hd__and4_1
XANTENNA__4965__A _5286_/A vssd1 vssd1 vccd1 vccd1 sky130_fd_sc_hd__diode_2
X_6086_ hold210/X _6724_/Q _6098_/S vssd1 vssd1 vccd1 vccd1 _6086_/X sky130_fd_sc_hd__mux2_1
XTAP_895 vssd1 vccd1 sky130_fd_sc_hd__tapvpwrvgnd_1
XTAP_884 vssd1 vccd1 sky130_fd_sc_hd__tapvpwrvgnd_1
XTAP_873 vssd1 vccd1 sky130_fd_sc_hd__tapvpwrvgnd_1
X_5106_ _5106_/A _5106_/B vssd1 vssd1 vccd1 vccd1 _5107_/B sky130_fd_sc_hd__nand2_1
XFILLER_0_57_82 vssd1 vssd1 vccd1 vccd1 sky130_fd_sc_hd__fill_2
X_3298_ _6861_/Q vssd1 vssd1 vccd1 vccd1 _3298_/Y sky130_fd_sc_hd__inv_2
X_5037_ _5030_/Y _5035_/X _4246_/X _4248_/Y vssd1 vssd1 vccd1 vccd1 _5038_/B sky130_fd_sc_hd__a211o_1
XFILLER_0_73_92 vssd1 vssd1 vccd1 vccd1 sky130_fd_sc_hd__fill_2
XANTENNA__5796__A _5796_/A vssd1 vssd1 vccd1 vccd1 sky130_fd_sc_hd__diode_2
XFILLER_0_67_328 vssd1 vssd1 vccd1 vccd1 sky130_fd_sc_hd__fill_2
XFILLER_0_94_169 vssd1 vssd1 vccd1 vccd1 sky130_fd_sc_hd__fill_1
XFILLER_0_82_309 vssd1 vssd1 vccd1 vccd1 sky130_fd_sc_hd__fill_2
XFILLER_0_75_383 vssd1 vssd1 vccd1 vccd1 sky130_fd_sc_hd__decap_8
X_5939_ _5947_/A tex_height_i[13] tex_height_i[12] _5945_/B vssd1 vssd1 vccd1 vccd1
+ _5963_/A sky130_fd_sc_hd__a22o_1
XFILLER_0_35_225 vssd1 vssd1 vccd1 vccd1 sky130_fd_sc_hd__decap_6
XANTENNA__6420__A hold7/A vssd1 vssd1 vccd1 vccd1 sky130_fd_sc_hd__diode_2
XFILLER_0_120_138 vssd1 vssd1 vccd1 vccd1 sky130_fd_sc_hd__fill_2
XFILLER_0_9_3 vssd1 vssd1 vccd1 vccd1 sky130_ef_sc_hd__decap_12
XFILLER_0_85_158 vssd1 vssd1 vccd1 vccd1 sky130_fd_sc_hd__decap_4
XFILLER_0_85_169 vssd1 vssd1 vccd1 vccd1 sky130_fd_sc_hd__fill_1
XPHY_161 vssd1 vssd1 vccd1 vccd1 sky130_fd_sc_hd__decap_3
XPHY_150 vssd1 vssd1 vccd1 vccd1 sky130_fd_sc_hd__decap_3
XANTENNA__4937__A2 _5064_/B vssd1 vssd1 vccd1 vccd1 sky130_fd_sc_hd__diode_2
XPHY_194 vssd1 vssd1 vccd1 vccd1 sky130_fd_sc_hd__decap_3
XFILLER_0_93_180 vssd1 vssd1 vccd1 vccd1 sky130_fd_sc_hd__fill_2
XPHY_183 vssd1 vssd1 vccd1 vccd1 sky130_fd_sc_hd__decap_3
XPHY_172 vssd1 vssd1 vccd1 vccd1 sky130_fd_sc_hd__decap_3
XFILLER_0_26_214 vssd1 vssd1 vccd1 vccd1 sky130_fd_sc_hd__fill_2
XFILLER_0_81_386 vssd1 vssd1 vccd1 vccd1 sky130_fd_sc_hd__decap_6
XANTENNA__5898__B1 _5919_/B vssd1 vssd1 vccd1 vccd1 sky130_fd_sc_hd__diode_2
XFILLER_0_1_358 vssd1 vssd1 vccd1 vccd1 sky130_fd_sc_hd__fill_2
X_4270_ _4269_/B _4269_/C _4269_/A vssd1 vssd1 vccd1 vccd1 _4271_/C sky130_fd_sc_hd__a21bo_1
XFILLER_0_27_30 vssd1 vssd1 vccd1 vccd1 sky130_fd_sc_hd__fill_2
XFILLER_0_27_52 vssd1 vssd1 vccd1 vccd1 sky130_fd_sc_hd__fill_2
X_6911_ vssd1 vssd1 vccd1 vccd1 _6911_/HI pix_mport_o[12] sky130_fd_sc_hd__conb_1
X_6842_ _6855_/CLK _6842_/D vssd1 vssd1 vccd1 vccd1 _6842_/Q sky130_fd_sc_hd__dfxtp_1
XFILLER_0_43_62 vssd1 vssd1 vccd1 vccd1 sky130_fd_sc_hd__fill_1
XANTENNA__6224__B _6224_/B vssd1 vssd1 vccd1 vccd1 sky130_fd_sc_hd__diode_2
X_6773_ _6832_/CLK _6773_/D fanout152/X vssd1 vssd1 vccd1 vccd1 pix_mport_o[45] sky130_fd_sc_hd__dfrtp_4
XFILLER_0_64_309 vssd1 vssd1 vccd1 vccd1 sky130_fd_sc_hd__decap_4
X_3985_ _5093_/A _6682_/Q vssd1 vssd1 vccd1 vccd1 _3986_/B sky130_fd_sc_hd__nand2_1
XANTENNA__5050__B2 _5049_/A vssd1 vssd1 vccd1 vccd1 sky130_fd_sc_hd__diode_2
XANTENNA__5050__A1 _5049_/B vssd1 vssd1 vccd1 vccd1 sky130_fd_sc_hd__diode_2
X_5724_ _5739_/A _5724_/B vssd1 vssd1 vccd1 vccd1 _5727_/A sky130_fd_sc_hd__nand2_1
XANTENNA__4025__A _4966_/C vssd1 vssd1 vccd1 vccd1 sky130_fd_sc_hd__diode_2
XFILLER_0_57_383 vssd1 vssd1 vccd1 vccd1 sky130_fd_sc_hd__decap_8
X_5655_ _5656_/A _5656_/B vssd1 vssd1 vccd1 vccd1 _5666_/B sky130_fd_sc_hd__or2_1
X_4606_ _4597_/X _4599_/Y _4607_/A _4604_/Y vssd1 vssd1 vccd1 vccd1 _4631_/A sky130_fd_sc_hd__a211o_1
XFILLER_0_87_3 vssd1 vssd1 vccd1 vccd1 sky130_fd_sc_hd__decap_3
XFILLER_0_32_228 vssd1 vssd1 vccd1 vccd1 sky130_fd_sc_hd__fill_2
X_5586_ _5426_/X tex_mport_o[52] _5598_/S vssd1 vssd1 vccd1 vccd1 _6609_/D sky130_fd_sc_hd__mux2_1
X_4537_ _4538_/A _4538_/B vssd1 vssd1 vccd1 vccd1 _4537_/Y sky130_fd_sc_hd__nand2_1
XFILLER_0_7_51 vssd1 vssd1 vccd1 vccd1 sky130_fd_sc_hd__decap_4
X_4468_ _4942_/A _4942_/B _4688_/C _4658_/D vssd1 vssd1 vccd1 vccd1 _4471_/A sky130_fd_sc_hd__nand4_1
XFILLER_0_40_294 vssd1 vssd1 vccd1 vccd1 sky130_fd_sc_hd__fill_2
X_6207_ pix_mport_o[47] _6207_/B vssd1 vssd1 vccd1 vccd1 _6207_/X sky130_fd_sc_hd__and2_1
X_3419_ _3421_/D vssd1 vssd1 vccd1 vccd1 _3419_/Y sky130_fd_sc_hd__inv_2
XFILLER_0_0_391 vssd1 vssd1 vccd1 vccd1 sky130_fd_sc_hd__fill_1
X_6138_ _6224_/B _6135_/X hold202/X _6137_/X vssd1 vssd1 vccd1 vccd1 _6138_/X sky130_fd_sc_hd__a31o_1
X_4399_ _4399_/A _4443_/A _4399_/C vssd1 vssd1 vccd1 vccd1 _4414_/A sky130_fd_sc_hd__and3_2
XTAP_670 vssd1 vccd1 sky130_fd_sc_hd__tapvpwrvgnd_1
XTAP_681 vssd1 vccd1 sky130_fd_sc_hd__tapvpwrvgnd_1
XTAP_692 vssd1 vccd1 sky130_fd_sc_hd__tapvpwrvgnd_1
X_6069_ hold93/X _6552_/Q _6072_/S vssd1 vssd1 vccd1 vccd1 hold94/A sky130_fd_sc_hd__mux2_1
XFILLER_0_67_147 vssd1 vssd1 vccd1 vccd1 sky130_fd_sc_hd__fill_2
XFILLER_0_118_271 vssd1 vssd1 vccd1 vccd1 sky130_fd_sc_hd__fill_2
XFILLER_0_90_183 vssd1 vssd1 vccd1 vccd1 sky130_fd_sc_hd__fill_1
XFILLER_0_23_239 vssd1 vssd1 vccd1 vccd1 sky130_fd_sc_hd__fill_2
XFILLER_0_90_194 vssd1 vssd1 vccd1 vccd1 sky130_fd_sc_hd__fill_2
XANTENNA__3355__A1 _5327_/A vssd1 vssd1 vccd1 vccd1 sky130_fd_sc_hd__diode_2
XANTENNA__3355__B2 _5290_/A vssd1 vssd1 vccd1 vccd1 sky130_fd_sc_hd__diode_2
XFILLER_0_48_29 vssd1 vssd1 vccd1 vccd1 sky130_fd_sc_hd__fill_1
XFILLER_0_101_182 vssd1 vssd1 vccd1 vccd1 sky130_fd_sc_hd__fill_2
XFILLER_0_86_401 vssd1 vssd1 vccd1 vccd1 sky130_fd_sc_hd__decap_6
XANTENNA__4083__A2 _4776_/A vssd1 vssd1 vccd1 vccd1 sky130_fd_sc_hd__diode_2
XFILLER_0_58_103 vssd1 vssd1 vccd1 vccd1 sky130_fd_sc_hd__decap_3
XFILLER_0_80_27 vssd1 vssd1 vccd1 vccd1 sky130_fd_sc_hd__fill_1
XFILLER_0_46_309 vssd1 vssd1 vccd1 vccd1 sky130_fd_sc_hd__fill_1
X_3770_ _3770_/A _3770_/B vssd1 vssd1 vccd1 vccd1 _3771_/C sky130_fd_sc_hd__xnor2_1
XFILLER_0_81_183 vssd1 vssd1 vccd1 vccd1 sky130_fd_sc_hd__decap_3
XFILLER_0_14_206 vssd1 vssd1 vccd1 vccd1 sky130_fd_sc_hd__fill_2
X_5440_ _5451_/B _5451_/C vssd1 vssd1 vccd1 vccd1 _5440_/X sky130_fd_sc_hd__and2_2
XFILLER_0_54_397 vssd1 vssd1 vccd1 vccd1 sky130_fd_sc_hd__decap_8
XFILLER_0_124_263 vssd1 vssd1 vccd1 vccd1 sky130_fd_sc_hd__fill_2
X_5371_ _6720_/Q _5559_/B vssd1 vssd1 vccd1 vccd1 _5380_/A sky130_fd_sc_hd__xnor2_1
XFILLER_0_1_111 vssd1 vssd1 vccd1 vccd1 sky130_fd_sc_hd__fill_1
X_4322_ _4322_/A _4322_/B vssd1 vssd1 vccd1 vccd1 _4344_/B sky130_fd_sc_hd__xnor2_1
XFILLER_0_66_8 vssd1 vssd1 vccd1 vccd1 sky130_fd_sc_hd__fill_2
XANTENNA__3897__A2 _6683_/Q vssd1 vssd1 vccd1 vccd1 sky130_fd_sc_hd__diode_2
X_4253_ _4253_/A _4253_/B vssd1 vssd1 vccd1 vccd1 _4322_/A sky130_fd_sc_hd__nor2_1
Xfanout108 tex_width_i[2] vssd1 vssd1 vccd1 vccd1 _5093_/A sky130_fd_sc_hd__clkbuf_4
Xfanout119 _4832_/C vssd1 vssd1 vccd1 vccd1 _5277_/B sky130_fd_sc_hd__buf_4
X_4184_ _4842_/A _4966_/A _4966_/C _4971_/B vssd1 vssd1 vccd1 vccd1 _4186_/B sky130_fd_sc_hd__a22o_1
XFILLER_0_89_294 vssd1 vssd1 vccd1 vccd1 sky130_fd_sc_hd__fill_2
X_6825_ _6832_/CLK _6825_/D fanout152/X vssd1 vssd1 vccd1 vccd1 depth_mport_o[47]
+ sky130_fd_sc_hd__dfrtp_4
XFILLER_0_37_309 vssd1 vssd1 vccd1 vccd1 sky130_fd_sc_hd__fill_1
XFILLER_0_49_158 vssd1 vssd1 vccd1 vccd1 sky130_fd_sc_hd__decap_4
XFILLER_0_49_169 vssd1 vssd1 vccd1 vccd1 sky130_fd_sc_hd__decap_4
X_6756_ _6853_/CLK _6756_/D fanout149/X vssd1 vssd1 vccd1 vccd1 pix_mport_o[4] sky130_fd_sc_hd__dfrtp_4
XFILLER_0_9_244 vssd1 vssd1 vccd1 vccd1 sky130_fd_sc_hd__fill_2
X_3968_ _3992_/A _3968_/B vssd1 vssd1 vccd1 vccd1 _3970_/B sky130_fd_sc_hd__nor2_1
X_5707_ _5705_/Y _5706_/X _5796_/A _5384_/B vssd1 vssd1 vccd1 vccd1 _5707_/X sky130_fd_sc_hd__a2bb2o_1
XFILLER_0_70_93 vssd1 vssd1 vccd1 vccd1 sky130_fd_sc_hd__fill_1
XFILLER_0_115_241 vssd1 vssd1 vccd1 vccd1 sky130_fd_sc_hd__fill_1
XFILLER_0_72_172 vssd1 vssd1 vccd1 vccd1 sky130_fd_sc_hd__fill_2
X_6687_ _6693_/CLK _6687_/D vssd1 vssd1 vccd1 vccd1 _6687_/Q sky130_fd_sc_hd__dfxtp_4
X_3899_ _6645_/Q _4005_/B vssd1 vssd1 vccd1 vccd1 _4006_/A sky130_fd_sc_hd__nand2_1
X_5638_ _5647_/A _5647_/B vssd1 vssd1 vccd1 vccd1 _5768_/S sky130_fd_sc_hd__nor2_1
XANTENNA__3337__A1 _3961_/A vssd1 vssd1 vccd1 vccd1 sky130_fd_sc_hd__diode_2
XFILLER_0_60_345 vssd1 vssd1 vccd1 vccd1 sky130_fd_sc_hd__fill_1
X_5569_ _5382_/B tex_mport_o[37] _5576_/S vssd1 vssd1 vccd1 vccd1 _6594_/D sky130_fd_sc_hd__mux2_1
Xhold151 _6082_/X vssd1 vssd1 vccd1 vccd1 _6720_/D sky130_fd_sc_hd__dlygate4sd3_1
Xhold140 _6511_/Q vssd1 vssd1 vccd1 vccd1 hold140/X sky130_fd_sc_hd__dlygate4sd3_1
Xhold162 _6645_/Q vssd1 vssd1 vccd1 vccd1 hold162/X sky130_fd_sc_hd__dlygate4sd3_1
Xhold184 _6855_/Q vssd1 vssd1 vccd1 vccd1 hold184/X sky130_fd_sc_hd__dlygate4sd3_1
Xhold195 _6539_/Q vssd1 vssd1 vccd1 vccd1 hold195/X sky130_fd_sc_hd__dlygate4sd3_1
Xhold173 _6088_/X vssd1 vssd1 vccd1 vccd1 _6726_/D sky130_fd_sc_hd__dlygate4sd3_1
XANTENNA_fanout73_A _4841_/D vssd1 vssd1 vccd1 vccd1 sky130_fd_sc_hd__diode_2
XFILLER_0_28_309 vssd1 vssd1 vccd1 vccd1 sky130_fd_sc_hd__fill_1
XFILLER_0_138_377 vssd1 vssd1 vccd1 vccd1 sky130_ef_sc_hd__decap_12
XFILLER_0_48_180 vssd1 vssd1 vccd1 vccd1 sky130_fd_sc_hd__fill_2
XFILLER_0_55_117 vssd1 vssd1 vccd1 vccd1 sky130_fd_sc_hd__fill_1
XFILLER_0_36_331 vssd1 vssd1 vccd1 vccd1 sky130_fd_sc_hd__fill_1
XFILLER_0_36_353 vssd1 vssd1 vccd1 vccd1 sky130_fd_sc_hd__fill_2
XFILLER_0_106_230 vssd1 vssd1 vccd1 vccd1 sky130_fd_sc_hd__decap_4
XFILLER_0_36_386 vssd1 vssd1 vccd1 vccd1 sky130_ef_sc_hd__decap_12
XFILLER_0_106_263 vssd1 vssd1 vccd1 vccd1 sky130_fd_sc_hd__fill_2
XANTENNA__4112__B _5687_/A vssd1 vssd1 vccd1 vccd1 sky130_fd_sc_hd__diode_2
XANTENNA__3879__A2 _5071_/A vssd1 vssd1 vccd1 vccd1 sky130_fd_sc_hd__diode_2
XANTENNA__5923__S _5923_/S vssd1 vssd1 vccd1 vccd1 sky130_fd_sc_hd__diode_2
XFILLER_0_75_16 vssd1 vssd1 vccd1 vccd1 sky130_fd_sc_hd__decap_8
XANTENNA__3500__A1 _5296_/A vssd1 vssd1 vccd1 vccd1 sky130_fd_sc_hd__diode_2
XANTENNA__3500__B2 _5276_/A vssd1 vssd1 vccd1 vccd1 sky130_fd_sc_hd__diode_2
XANTENNA__6450__A0 hold152/X vssd1 vssd1 vccd1 vccd1 sky130_fd_sc_hd__diode_2
X_4940_ _5071_/A _5656_/A vssd1 vssd1 vccd1 vccd1 _4941_/B sky130_fd_sc_hd__nand2_1
XFILLER_0_86_253 vssd1 vssd1 vccd1 vccd1 sky130_ef_sc_hd__decap_12
X_4871_ _4854_/X _4856_/Y _4869_/A _4869_/Y vssd1 vssd1 vccd1 vccd1 _4872_/D sky130_fd_sc_hd__o211ai_4
XFILLER_0_115_99 vssd1 vssd1 vccd1 vccd1 sky130_fd_sc_hd__fill_1
X_6610_ _6745_/CLK _6610_/D fanout140/X vssd1 vssd1 vccd1 vccd1 tex_mport_o[53] sky130_fd_sc_hd__dfrtp_4
X_3822_ _5051_/A _5106_/B vssd1 vssd1 vccd1 vccd1 _3877_/B sky130_fd_sc_hd__nand2_1
X_6541_ _6855_/CLK _6541_/D vssd1 vssd1 vccd1 vccd1 hold60/A sky130_fd_sc_hd__dfxtp_2
XFILLER_0_61_109 vssd1 vssd1 vccd1 vccd1 sky130_fd_sc_hd__decap_3
X_3753_ _3753_/A _3753_/B vssd1 vssd1 vccd1 vccd1 _3755_/C sky130_fd_sc_hd__xor2_1
XFILLER_0_40_52 vssd1 vssd1 vccd1 vccd1 sky130_fd_sc_hd__fill_2
XFILLER_0_40_63 vssd1 vssd1 vccd1 vccd1 sky130_fd_sc_hd__fill_1
XFILLER_0_54_161 vssd1 vssd1 vccd1 vccd1 sky130_fd_sc_hd__fill_1
XFILLER_0_131_87 vssd1 vssd1 vccd1 vccd1 sky130_fd_sc_hd__fill_2
X_6472_ hold141/X sstream_i[30] _6472_/S vssd1 vssd1 vccd1 vccd1 _6863_/D sky130_fd_sc_hd__mux2_1
XFILLER_0_6_269 vssd1 vssd1 vccd1 vccd1 sky130_fd_sc_hd__fill_2
X_3684_ _3686_/A _3684_/B vssd1 vssd1 vccd1 vccd1 _3767_/B sky130_fd_sc_hd__and2_1
XFILLER_0_40_85 vssd1 vssd1 vccd1 vccd1 sky130_fd_sc_hd__fill_1
XFILLER_0_42_356 vssd1 vssd1 vccd1 vccd1 sky130_fd_sc_hd__fill_2
XANTENNA__5118__B _5118_/B vssd1 vssd1 vccd1 vccd1 sky130_fd_sc_hd__diode_2
X_5423_ _5424_/B _5424_/C _5424_/A vssd1 vssd1 vccd1 vccd1 _5423_/Y sky130_fd_sc_hd__a21oi_1
X_5354_ _5354_/A _5354_/B _5357_/A vssd1 vssd1 vccd1 vccd1 _5355_/B sky130_fd_sc_hd__and3_1
X_4305_ _4305_/A _4305_/B vssd1 vssd1 vccd1 vccd1 _4309_/B sky130_fd_sc_hd__xnor2_4
XFILLER_0_10_231 vssd1 vssd1 vccd1 vccd1 sky130_fd_sc_hd__fill_1
X_5285_ _3520_/A _3520_/B _3518_/B vssd1 vssd1 vccd1 vccd1 _5287_/A sky130_fd_sc_hd__o21ai_1
X_4236_ _4236_/A _4236_/B _4236_/C vssd1 vssd1 vccd1 vccd1 _4264_/A sky130_fd_sc_hd__nand3_2
XFILLER_0_4_41 vssd1 vssd1 vccd1 vccd1 sky130_ef_sc_hd__decap_12
X_4167_ _4119_/B _4121_/B _4165_/X _4166_/Y vssd1 vssd1 vccd1 vccd1 _5011_/B sky130_fd_sc_hd__a211o_1
XFILLER_0_4_85 vssd1 vssd1 vccd1 vccd1 sky130_ef_sc_hd__decap_12
XFILLER_0_69_209 vssd1 vssd1 vccd1 vccd1 sky130_fd_sc_hd__decap_3
X_4098_ _4971_/B _5732_/A _5718_/A _4551_/D vssd1 vssd1 vccd1 vccd1 _4099_/D sky130_fd_sc_hd__a22o_1
XFILLER_0_77_264 vssd1 vssd1 vccd1 vccd1 sky130_fd_sc_hd__fill_1
XFILLER_0_77_253 vssd1 vssd1 vccd1 vccd1 sky130_fd_sc_hd__fill_1
X_6808_ _6863_/CLK _6808_/D _6073_/A vssd1 vssd1 vccd1 vccd1 _6808_/Q sky130_fd_sc_hd__dfrtp_1
XFILLER_0_92_234 vssd1 vssd1 vccd1 vccd1 sky130_fd_sc_hd__fill_2
XFILLER_0_18_353 vssd1 vssd1 vccd1 vccd1 sky130_fd_sc_hd__fill_2
X_6739_ _6751_/CLK _6739_/D _5937_/A vssd1 vssd1 vccd1 vccd1 _6739_/Q sky130_fd_sc_hd__dfstp_1
XFILLER_0_18_397 vssd1 vssd1 vccd1 vccd1 sky130_fd_sc_hd__decap_8
XFILLER_0_5_291 vssd1 vssd1 vccd1 vccd1 sky130_fd_sc_hd__decap_3
XFILLER_0_33_389 vssd1 vssd1 vccd1 vccd1 sky130_fd_sc_hd__decap_3
XFILLER_0_60_197 vssd1 vssd1 vccd1 vccd1 sky130_fd_sc_hd__decap_4
XANTENNA__3499__A _5320_/A vssd1 vssd1 vccd1 vccd1 sky130_fd_sc_hd__diode_2
XFILLER_0_28_106 vssd1 vssd1 vccd1 vccd1 sky130_fd_sc_hd__fill_2
XFILLER_0_138_141 vssd1 vssd1 vccd1 vccd1 sky130_fd_sc_hd__decap_3
XFILLER_0_68_286 vssd1 vssd1 vccd1 vccd1 sky130_fd_sc_hd__fill_2
XANTENNA__4107__B _4736_/B vssd1 vssd1 vccd1 vccd1 sky130_fd_sc_hd__diode_2
XANTENNA__5918__S _5923_/S vssd1 vssd1 vccd1 vccd1 sky130_fd_sc_hd__diode_2
XFILLER_0_83_245 vssd1 vssd1 vccd1 vccd1 sky130_fd_sc_hd__fill_1
Xfanout90 _4816_/B vssd1 vssd1 vccd1 vccd1 _5718_/B sky130_fd_sc_hd__buf_4
XFILLER_0_83_289 vssd1 vssd1 vccd1 vccd1 sky130_fd_sc_hd__fill_2
XFILLER_0_83_278 vssd1 vssd1 vccd1 vccd1 sky130_fd_sc_hd__fill_2
XFILLER_0_36_150 vssd1 vssd1 vccd1 vccd1 sky130_fd_sc_hd__fill_1
XFILLER_0_24_334 vssd1 vssd1 vccd1 vccd1 sky130_fd_sc_hd__fill_1
XFILLER_0_10_77 vssd1 vssd1 vccd1 vccd1 sky130_fd_sc_hd__decap_6
X_5070_ _5071_/A _5656_/A _4937_/X _4938_/X _5064_/B vssd1 vssd1 vccd1 vccd1 _5073_/A
+ sky130_fd_sc_hd__a32o_1
X_4021_ _3934_/Y _3938_/A _4020_/X _3858_/B vssd1 vssd1 vccd1 vccd1 _4024_/B sky130_fd_sc_hd__a211oi_2
XANTENNA__4793__A _5687_/B vssd1 vssd1 vccd1 vccd1 sky130_fd_sc_hd__diode_2
XFILLER_0_126_21 vssd1 vssd1 vccd1 vccd1 sky130_fd_sc_hd__decap_4
XANTENNA__4029__A2 _4816_/B vssd1 vssd1 vccd1 vccd1 sky130_fd_sc_hd__diode_2
XFILLER_0_35_30 vssd1 vssd1 vccd1 vccd1 sky130_fd_sc_hd__fill_2
X_5972_ _4527_/B _5971_/X _6037_/S vssd1 vssd1 vccd1 vccd1 _6662_/D sky130_fd_sc_hd__mux2_1
X_4923_ _4889_/X _4891_/Y _4919_/A _4919_/Y vssd1 vssd1 vccd1 vccd1 _4924_/C sky130_fd_sc_hd__o211a_1
XFILLER_0_59_242 vssd1 vssd1 vccd1 vccd1 sky130_fd_sc_hd__decap_8
XFILLER_0_74_245 vssd1 vssd1 vccd1 vccd1 sky130_fd_sc_hd__fill_2
X_4854_ _4855_/A _4855_/B _4855_/C vssd1 vssd1 vccd1 vccd1 _4854_/X sky130_fd_sc_hd__and3_1
XFILLER_0_117_358 vssd1 vssd1 vccd1 vccd1 sky130_fd_sc_hd__fill_2
X_3805_ _5051_/B _5083_/B _3805_/C _3805_/D vssd1 vssd1 vccd1 vccd1 _3813_/B sky130_fd_sc_hd__and4_1
XFILLER_0_51_84 vssd1 vssd1 vccd1 vccd1 sky130_fd_sc_hd__decap_3
X_4785_ _4808_/B _4777_/X _4778_/X _4782_/X vssd1 vssd1 vccd1 vccd1 _4786_/B sky130_fd_sc_hd__a211o_1
XFILLER_0_132_306 vssd1 vssd1 vccd1 vccd1 sky130_fd_sc_hd__fill_2
X_6524_ _6834_/CLK _6524_/D vssd1 vssd1 vccd1 vccd1 _6524_/Q sky130_fd_sc_hd__dfxtp_1
X_3736_ _3735_/A _3735_/Y _3655_/X _3705_/Y vssd1 vssd1 vccd1 vccd1 _3758_/A sky130_fd_sc_hd__o211a_2
XFILLER_0_27_183 vssd1 vssd1 vccd1 vccd1 sky130_fd_sc_hd__fill_1
XFILLER_0_125_391 vssd1 vssd1 vccd1 vccd1 sky130_fd_sc_hd__fill_1
XANTENNA__3960__A1 _5081_/B vssd1 vssd1 vccd1 vccd1 sky130_fd_sc_hd__diode_2
XFILLER_0_30_304 vssd1 vssd1 vccd1 vccd1 sky130_fd_sc_hd__decap_4
XFILLER_0_42_153 vssd1 vssd1 vccd1 vccd1 sky130_fd_sc_hd__fill_1
X_6455_ hold147/X sstream_i[13] _6472_/S vssd1 vssd1 vccd1 vccd1 _6846_/D sky130_fd_sc_hd__mux2_1
X_3667_ _5290_/A _5327_/A _6687_/Q _6688_/Q vssd1 vssd1 vccd1 vccd1 _3667_/X sky130_fd_sc_hd__and4_1
XANTENNA__3960__B2 _5083_/A vssd1 vssd1 vccd1 vccd1 sky130_fd_sc_hd__diode_2
XFILLER_0_42_197 vssd1 vssd1 vccd1 vccd1 sky130_fd_sc_hd__fill_2
X_6386_ hold53/A hold7/A vssd1 vssd1 vccd1 vccd1 _6402_/A sky130_fd_sc_hd__nand2_1
X_5406_ _5406_/A _5406_/B vssd1 vssd1 vccd1 vccd1 _5408_/B sky130_fd_sc_hd__xnor2_2
X_3598_ _5081_/B _5300_/A vssd1 vssd1 vccd1 vccd1 _3627_/B sky130_fd_sc_hd__nand2_1
XANTENNA__6651__SET_B _5937_/A vssd1 vssd1 vccd1 vccd1 sky130_fd_sc_hd__diode_2
X_5337_ _6746_/Q _5594_/B _5594_/C vssd1 vssd1 vccd1 vccd1 _5337_/X sky130_fd_sc_hd__or3_1
X_5268_ _5441_/A _5441_/B _5441_/C _5441_/D vssd1 vssd1 vccd1 vccd1 _5442_/A sky130_fd_sc_hd__a31oi_4
X_4219_ _4219_/A _4219_/B vssd1 vssd1 vccd1 vccd1 _4225_/A sky130_fd_sc_hd__xor2_4
X_5199_ _5177_/Y _5184_/X _5197_/A _5197_/Y vssd1 vssd1 vccd1 vccd1 _5199_/X sky130_fd_sc_hd__o211a_1
XANTENNA__6407__B _6546_/Q vssd1 vssd1 vccd1 vccd1 sky130_fd_sc_hd__diode_2
XANTENNA__4208__A _5787_/B vssd1 vssd1 vccd1 vccd1 sky130_fd_sc_hd__diode_2
XFILLER_0_38_404 vssd1 vssd1 vccd1 vccd1 sky130_fd_sc_hd__decap_3
XFILLER_0_135_111 vssd1 vssd1 vccd1 vccd1 sky130_fd_sc_hd__fill_1
XANTENNA_fanout2_A _5601_/S vssd1 vssd1 vccd1 vccd1 sky130_fd_sc_hd__diode_2
XANTENNA__3951__A1 _5766_/A vssd1 vssd1 vccd1 vccd1 sky130_fd_sc_hd__diode_2
XFILLER_0_21_337 vssd1 vssd1 vccd1 vccd1 sky130_fd_sc_hd__fill_1
XFILLER_0_33_186 vssd1 vssd1 vccd1 vccd1 sky130_fd_sc_hd__fill_1
XANTENNA__4259__A2 _5718_/B vssd1 vssd1 vccd1 vccd1 sky130_fd_sc_hd__diode_2
XANTENNA__6405__B1 _6440_/B vssd1 vssd1 vccd1 vccd1 sky130_fd_sc_hd__diode_2
XFILLER_0_88_348 vssd1 vssd1 vccd1 vccd1 sky130_ef_sc_hd__decap_12
XFILLER_0_8_309 vssd1 vssd1 vccd1 vccd1 sky130_fd_sc_hd__fill_2
XANTENNA__3379__D _5286_/B vssd1 vssd1 vccd1 vccd1 sky130_fd_sc_hd__diode_2
XANTENNA__4967__B1 _4966_/C vssd1 vssd1 vccd1 vccd1 sky130_fd_sc_hd__diode_2
XTAP_1260 vssd1 vccd1 sky130_fd_sc_hd__tapvpwrvgnd_1
XFILLER_0_112_45 vssd1 vssd1 vccd1 vccd1 sky130_fd_sc_hd__decap_3
X_4570_ _4571_/A _4571_/B _4571_/C vssd1 vssd1 vccd1 vccd1 _4573_/C sky130_fd_sc_hd__and3_1
XFILLER_0_21_54 vssd1 vssd1 vccd1 vccd1 sky130_fd_sc_hd__fill_2
XFILLER_0_112_89 vssd1 vssd1 vccd1 vccd1 sky130_fd_sc_hd__decap_4
X_3521_ _3870_/A _3961_/A _5308_/B _5277_/B vssd1 vssd1 vccd1 vccd1 _3524_/A sky130_fd_sc_hd__and4_1
XFILLER_0_21_65 vssd1 vssd1 vccd1 vccd1 sky130_fd_sc_hd__decap_3
XFILLER_0_122_350 vssd1 vssd1 vccd1 vccd1 sky130_fd_sc_hd__fill_2
XFILLER_0_12_304 vssd1 vssd1 vccd1 vccd1 sky130_fd_sc_hd__decap_4
X_6240_ _6853_/Q _3306_/Y _3307_/Y _6852_/Q _6239_/X vssd1 vssd1 vccd1 vccd1 _6240_/X
+ sky130_fd_sc_hd__o221a_1
X_3452_ _3999_/A _6689_/Q _3451_/C vssd1 vssd1 vccd1 vccd1 _3453_/B sky130_fd_sc_hd__a21oi_1
X_6171_ fb_i _6172_/B vssd1 vssd1 vccd1 vccd1 _6173_/A sky130_fd_sc_hd__nand2_1
X_3383_ _5311_/A _5296_/B _3381_/B _3379_/X vssd1 vssd1 vccd1 vccd1 _3391_/B sky130_fd_sc_hd__a31o_1
XFILLER_0_20_381 vssd1 vssd1 vccd1 vccd1 sky130_ef_sc_hd__decap_12
XANTENNA__5115__C _5115_/C vssd1 vssd1 vccd1 vccd1 sky130_fd_sc_hd__diode_2
X_5122_ _5122_/A _5122_/B vssd1 vssd1 vccd1 vccd1 _5142_/A sky130_fd_sc_hd__nand2_1
X_5053_ _5053_/A _5053_/B vssd1 vssd1 vccd1 vccd1 _5054_/C sky130_fd_sc_hd__nand2_1
X_4004_ _4004_/A _4004_/B vssd1 vssd1 vccd1 vccd1 _4008_/A sky130_fd_sc_hd__nand2_1
XFILLER_0_46_73 vssd1 vssd1 vccd1 vccd1 sky130_fd_sc_hd__decap_3
XFILLER_0_79_337 vssd1 vssd1 vccd1 vccd1 sky130_fd_sc_hd__decap_8
XANTENNA__4028__A _4971_/D vssd1 vssd1 vccd1 vccd1 sky130_fd_sc_hd__diode_2
XANTENNA__4970__B _4970_/B vssd1 vssd1 vccd1 vccd1 sky130_fd_sc_hd__diode_2
X_5955_ _6868_/Q _3290_/Y _6867_/Q _3291_/Y _5954_/X vssd1 vssd1 vccd1 vccd1 _5955_/X
+ sky130_fd_sc_hd__o221a_1
X_4906_ _5083_/A _4432_/A _4154_/A _4152_/B vssd1 vssd1 vccd1 vccd1 _4909_/A sky130_fd_sc_hd__a31o_1
X_5886_ _5887_/A _5887_/B vssd1 vssd1 vccd1 vccd1 _5886_/X sky130_fd_sc_hd__or2_1
XFILLER_0_62_215 vssd1 vssd1 vccd1 vccd1 sky130_fd_sc_hd__fill_2
XFILLER_0_62_204 vssd1 vssd1 vccd1 vccd1 sky130_fd_sc_hd__fill_2
XFILLER_0_7_342 vssd1 vssd1 vccd1 vccd1 sky130_fd_sc_hd__fill_2
X_4837_ _4837_/A _4837_/B _4837_/C vssd1 vssd1 vccd1 vccd1 _4839_/B sky130_fd_sc_hd__nand3_2
XFILLER_0_132_103 vssd1 vssd1 vccd1 vccd1 sky130_fd_sc_hd__decap_3
X_4768_ _6639_/Q _4768_/B vssd1 vssd1 vccd1 vccd1 _4769_/B sky130_fd_sc_hd__nor2_1
X_4699_ _5366_/A _5366_/B _5365_/B _4698_/X vssd1 vssd1 vccd1 vccd1 _5364_/B sky130_fd_sc_hd__a31o_1
X_6507_ _6834_/CLK _6507_/D vssd1 vssd1 vccd1 vccd1 _6507_/Q sky130_fd_sc_hd__dfxtp_1
XFILLER_0_70_281 vssd1 vssd1 vccd1 vccd1 sky130_fd_sc_hd__fill_2
XFILLER_0_15_164 vssd1 vssd1 vccd1 vccd1 sky130_fd_sc_hd__fill_2
X_3719_ _3783_/A _3783_/B vssd1 vssd1 vccd1 vccd1 _3721_/C sky130_fd_sc_hd__nor2_1
X_6438_ depth_mport_o[51] _6437_/Y _6441_/B vssd1 vssd1 vccd1 vccd1 _6829_/D sky130_fd_sc_hd__mux2_1
XFILLER_0_70_292 vssd1 vssd1 vccd1 vccd1 sky130_fd_sc_hd__decap_8
X_6369_ _6369_/A _6381_/B vssd1 vssd1 vccd1 vccd1 _6378_/A sky130_fd_sc_hd__or2_1
XFILLER_0_11_370 vssd1 vssd1 vccd1 vccd1 sky130_fd_sc_hd__decap_6
Xhold11 hold11/A vssd1 vssd1 vccd1 vccd1 hold11/X sky130_fd_sc_hd__dlygate4sd3_1
Xhold22 hold22/A vssd1 vssd1 vccd1 vccd1 hold22/X sky130_fd_sc_hd__dlygate4sd3_1
Xhold33 hold33/A vssd1 vssd1 vccd1 vccd1 hold33/X sky130_fd_sc_hd__dlygate4sd3_1
Xhold44 hold44/A vssd1 vssd1 vccd1 vccd1 hold44/X sky130_fd_sc_hd__dlygate4sd3_1
Xhold55 hold55/A vssd1 vssd1 vccd1 vccd1 hold55/X sky130_fd_sc_hd__dlygate4sd3_1
Xhold66 hold66/A vssd1 vssd1 vccd1 vccd1 hold66/X sky130_fd_sc_hd__dlygate4sd3_1
Xhold88 hold88/A vssd1 vssd1 vccd1 vccd1 hold88/X sky130_fd_sc_hd__dlygate4sd3_1
Xhold77 hold77/A vssd1 vssd1 vccd1 vccd1 hold77/X sky130_fd_sc_hd__dlygate4sd3_1
Xhold99 hold99/A vssd1 vssd1 vccd1 vccd1 hold99/X sky130_fd_sc_hd__dlygate4sd3_1
XANTENNA__6153__A _6224_/B vssd1 vssd1 vccd1 vccd1 sky130_fd_sc_hd__diode_2
XANTENNA__4177__A1 _4433_/D vssd1 vssd1 vccd1 vccd1 sky130_fd_sc_hd__diode_2
XANTENNA_8 sstream_i[10] vssd1 vssd1 vccd1 vccd1 sky130_fd_sc_hd__diode_2
XANTENNA__4401__A _4488_/A vssd1 vssd1 vccd1 vccd1 sky130_fd_sc_hd__diode_2
XFILLER_0_21_134 vssd1 vssd1 vccd1 vccd1 sky130_fd_sc_hd__decap_4
XFILLER_0_21_145 vssd1 vssd1 vccd1 vccd1 sky130_fd_sc_hd__decap_3
XFILLER_0_21_178 vssd1 vssd1 vccd1 vccd1 sky130_fd_sc_hd__fill_2
XANTENNA__5931__S _5932_/S vssd1 vssd1 vccd1 vccd1 sky130_fd_sc_hd__diode_2
XTAP_329 vssd1 vccd1 sky130_fd_sc_hd__tapvpwrvgnd_1
XTAP_318 vssd1 vccd1 sky130_fd_sc_hd__tapvpwrvgnd_1
XTAP_307 vssd1 vccd1 sky130_fd_sc_hd__tapvpwrvgnd_1
XANTENNA__4774__C _4958_/B vssd1 vssd1 vccd1 vccd1 sky130_fd_sc_hd__diode_2
XFILLER_0_107_34 vssd1 vssd1 vccd1 vccd1 sky130_fd_sc_hd__fill_2
XFILLER_0_88_145 vssd1 vssd1 vccd1 vccd1 sky130_fd_sc_hd__fill_2
XFILLER_0_69_381 vssd1 vssd1 vccd1 vccd1 sky130_fd_sc_hd__decap_8
X_5740_ _5740_/A _5740_/B vssd1 vssd1 vccd1 vccd1 _5740_/X sky130_fd_sc_hd__xor2_1
XFILLER_0_29_223 vssd1 vssd1 vccd1 vccd1 sky130_fd_sc_hd__fill_1
XFILLER_0_32_20 vssd1 vssd1 vccd1 vccd1 sky130_fd_sc_hd__fill_2
XTAP_1090 vssd1 vccd1 sky130_fd_sc_hd__tapvpwrvgnd_1
XFILLER_0_29_289 vssd1 vssd1 vccd1 vccd1 sky130_fd_sc_hd__decap_6
X_5671_ _5671_/A _5671_/B vssd1 vssd1 vccd1 vccd1 _5673_/A sky130_fd_sc_hd__nand2_1
X_4622_ _6625_/Q _4636_/B vssd1 vssd1 vccd1 vccd1 _4625_/C sky130_fd_sc_hd__nand2_1
XFILLER_0_44_259 vssd1 vssd1 vccd1 vccd1 sky130_fd_sc_hd__decap_3
X_4553_ _5645_/B _4582_/D _4551_/D _4789_/B vssd1 vssd1 vccd1 vccd1 _4554_/C sky130_fd_sc_hd__a22o_1
XFILLER_0_12_101 vssd1 vssd1 vccd1 vccd1 sky130_fd_sc_hd__fill_1
X_4484_ _4484_/A _4484_/B _4494_/A _4484_/D vssd1 vssd1 vccd1 vccd1 _4528_/A sky130_fd_sc_hd__and4_1
XFILLER_0_4_378 vssd1 vssd1 vccd1 vccd1 sky130_ef_sc_hd__decap_12
X_3504_ _5298_/S _3504_/B vssd1 vssd1 vccd1 vccd1 _3505_/B sky130_fd_sc_hd__and2_1
X_6223_ pix_mport_o[50] _6223_/B vssd1 vssd1 vccd1 vccd1 _6778_/D sky130_fd_sc_hd__and2_1
X_3435_ _3437_/D vssd1 vssd1 vccd1 vccd1 _3435_/Y sky130_fd_sc_hd__inv_2
X_6154_ _6152_/X _6153_/Y pix_mport_o[41] _6207_/B vssd1 vssd1 vccd1 vccd1 _6769_/D
+ sky130_fd_sc_hd__a2bb2o_1
XTAP_852 vssd1 vccd1 sky130_fd_sc_hd__tapvpwrvgnd_1
XTAP_841 vssd1 vccd1 sky130_fd_sc_hd__tapvpwrvgnd_1
XTAP_830 vssd1 vccd1 sky130_fd_sc_hd__tapvpwrvgnd_1
X_3366_ _3366_/A _3440_/B vssd1 vssd1 vccd1 vccd1 _3373_/A sky130_fd_sc_hd__or2_1
XANTENNA__4965__B _5115_/D vssd1 vssd1 vccd1 vccd1 sky130_fd_sc_hd__diode_2
X_3297_ _6862_/Q vssd1 vssd1 vccd1 vccd1 _3297_/Y sky130_fd_sc_hd__inv_2
X_6085_ _6624_/Q hold266/X _6098_/S vssd1 vssd1 vccd1 vccd1 _6085_/X sky130_fd_sc_hd__mux2_1
XTAP_885 vssd1 vccd1 sky130_fd_sc_hd__tapvpwrvgnd_1
XTAP_874 vssd1 vccd1 sky130_fd_sc_hd__tapvpwrvgnd_1
XTAP_863 vssd1 vccd1 sky130_fd_sc_hd__tapvpwrvgnd_1
X_5105_ _5093_/A _5106_/B _5094_/A _5092_/B vssd1 vssd1 vccd1 vccd1 _5107_/A sky130_fd_sc_hd__a31o_1
XTAP_896 vssd1 vccd1 sky130_fd_sc_hd__tapvpwrvgnd_1
X_5036_ _4246_/X _4248_/Y _5030_/Y _5035_/X vssd1 vssd1 vccd1 vccd1 _5421_/B sky130_fd_sc_hd__o211ai_4
XFILLER_0_32_3 vssd1 vssd1 vccd1 vccd1 sky130_fd_sc_hd__decap_3
XFILLER_0_73_82 vssd1 vssd1 vccd1 vccd1 sky130_fd_sc_hd__decap_4
XANTENNA__5796__B _5807_/B vssd1 vssd1 vccd1 vccd1 sky130_fd_sc_hd__diode_2
X_5938_ _6880_/Q _3278_/Y _5948_/A tex_height_i[14] vssd1 vssd1 vccd1 vccd1 _5938_/X
+ sky130_fd_sc_hd__a2bb2o_1
X_5869_ _5869_/A vssd1 vssd1 vccd1 vccd1 _5869_/Y sky130_fd_sc_hd__inv_2
XFILLER_0_90_365 vssd1 vssd1 vccd1 vccd1 sky130_ef_sc_hd__decap_12
XANTENNA_hold200_A _6552_/Q vssd1 vssd1 vccd1 vccd1 sky130_fd_sc_hd__diode_2
XANTENNA__6420__B hold70/A vssd1 vssd1 vccd1 vccd1 sky130_fd_sc_hd__diode_2
XFILLER_0_43_281 vssd1 vssd1 vccd1 vccd1 sky130_fd_sc_hd__decap_4
XANTENNA__5595__B1 _5594_/Y vssd1 vssd1 vccd1 vccd1 sky130_fd_sc_hd__diode_2
XPHY_151 vssd1 vssd1 vccd1 vccd1 sky130_fd_sc_hd__decap_3
XPHY_140 vssd1 vssd1 vccd1 vccd1 sky130_fd_sc_hd__decap_3
XANTENNA__5926__S _5932_/S vssd1 vssd1 vccd1 vccd1 sky130_fd_sc_hd__diode_2
XFILLER_0_93_192 vssd1 vssd1 vccd1 vccd1 sky130_fd_sc_hd__decap_8
XPHY_184 vssd1 vssd1 vccd1 vccd1 sky130_fd_sc_hd__decap_3
XPHY_173 vssd1 vssd1 vccd1 vccd1 sky130_fd_sc_hd__decap_3
XFILLER_0_81_321 vssd1 vssd1 vccd1 vccd1 sky130_fd_sc_hd__decap_8
XPHY_162 vssd1 vssd1 vccd1 vccd1 sky130_fd_sc_hd__decap_3
XPHY_195 vssd1 vssd1 vccd1 vccd1 sky130_fd_sc_hd__decap_3
XFILLER_0_111_117 vssd1 vssd1 vccd1 vccd1 sky130_fd_sc_hd__fill_2
XFILLER_0_78_27 vssd1 vssd1 vccd1 vccd1 sky130_fd_sc_hd__fill_1
XFILLER_0_118_22 vssd1 vssd1 vccd1 vccd1 sky130_fd_sc_hd__fill_2
XFILLER_0_118_55 vssd1 vssd1 vccd1 vccd1 sky130_fd_sc_hd__decap_3
XFILLER_0_27_86 vssd1 vssd1 vccd1 vccd1 sky130_fd_sc_hd__fill_2
X_6910_ vssd1 vssd1 vccd1 vccd1 _6910_/HI pix_mport_o[11] sky130_fd_sc_hd__conb_1
X_6841_ _6841_/CLK _6841_/D vssd1 vssd1 vccd1 vccd1 _6841_/Q sky130_fd_sc_hd__dfxtp_1
XFILLER_0_134_76 vssd1 vssd1 vccd1 vccd1 sky130_fd_sc_hd__fill_2
XANTENNA__5586__A0 _5426_/X vssd1 vssd1 vccd1 vccd1 sky130_fd_sc_hd__diode_2
XFILLER_0_76_137 vssd1 vssd1 vccd1 vccd1 sky130_fd_sc_hd__fill_1
X_6772_ _6832_/CLK _6772_/D fanout153/X vssd1 vssd1 vccd1 vccd1 pix_mport_o[44] sky130_fd_sc_hd__dfrtp_4
XFILLER_0_17_204 vssd1 vssd1 vccd1 vccd1 sky130_fd_sc_hd__decap_4
X_3984_ _3984_/A _3984_/B vssd1 vssd1 vccd1 vccd1 _3986_/A sky130_fd_sc_hd__nor2_1
XFILLER_0_43_85 vssd1 vssd1 vccd1 vccd1 sky130_fd_sc_hd__fill_2
X_5723_ tex_addr_i[8] _5723_/B vssd1 vssd1 vccd1 vccd1 _5724_/B sky130_fd_sc_hd__or2_1
XANTENNA__4025__B _4822_/B vssd1 vssd1 vccd1 vccd1 sky130_fd_sc_hd__diode_2
XANTENNA__3567__D _5277_/B vssd1 vssd1 vccd1 vccd1 sky130_fd_sc_hd__diode_2
X_5654_ hold237/X _5653_/X _5654_/S vssd1 vssd1 vccd1 vccd1 _6622_/D sky130_fd_sc_hd__mux2_1
XFILLER_0_84_192 vssd1 vssd1 vccd1 vccd1 sky130_fd_sc_hd__fill_2
X_4605_ _4597_/X _4599_/Y _4607_/A _4604_/Y vssd1 vssd1 vccd1 vccd1 _4607_/B sky130_fd_sc_hd__a211oi_1
XFILLER_0_72_376 vssd1 vssd1 vccd1 vccd1 sky130_ef_sc_hd__decap_12
Xhold300 _6553_/Q vssd1 vssd1 vccd1 vccd1 _6340_/B sky130_fd_sc_hd__dlygate4sd3_1
XFILLER_0_25_281 vssd1 vssd1 vccd1 vccd1 sky130_fd_sc_hd__fill_2
X_5585_ _5355_/Y tex_mport_o[51] _5601_/S vssd1 vssd1 vccd1 vccd1 _6608_/D sky130_fd_sc_hd__mux2_1
X_4536_ _4536_/A _4536_/B vssd1 vssd1 vccd1 vccd1 _4538_/B sky130_fd_sc_hd__xor2_1
X_4467_ _4429_/A _4429_/C _4429_/B vssd1 vssd1 vccd1 vccd1 _4473_/B sky130_fd_sc_hd__a21o_1
XANTENNA__3880__A _5051_/A vssd1 vssd1 vccd1 vccd1 sky130_fd_sc_hd__diode_2
XFILLER_0_40_284 vssd1 vssd1 vccd1 vccd1 sky130_fd_sc_hd__decap_3
X_6206_ pix_mport_o[46] _6207_/B _6212_/A _6205_/Y vssd1 vssd1 vccd1 vccd1 _6774_/D
+ sky130_fd_sc_hd__a22o_1
X_4398_ _4345_/A _4345_/B _4345_/C vssd1 vssd1 vccd1 vccd1 _4399_/C sky130_fd_sc_hd__a21o_1
X_3418_ _5296_/A _5273_/B _5272_/B _5276_/A vssd1 vssd1 vccd1 vccd1 _3421_/D sky130_fd_sc_hd__a22o_1
XFILLER_0_0_381 vssd1 vssd1 vccd1 vccd1 sky130_fd_sc_hd__fill_2
X_6137_ pix_mport_o[39] _6207_/B vssd1 vssd1 vccd1 vccd1 _6137_/X sky130_fd_sc_hd__and2_1
X_3349_ _5277_/A _5296_/A _5276_/A _5300_/B vssd1 vssd1 vccd1 vccd1 _3351_/B sky130_fd_sc_hd__a22o_1
XTAP_660 vssd1 vccd1 sky130_fd_sc_hd__tapvpwrvgnd_1
XTAP_671 vssd1 vccd1 sky130_fd_sc_hd__tapvpwrvgnd_1
XTAP_682 vssd1 vccd1 sky130_fd_sc_hd__tapvpwrvgnd_1
XTAP_693 vssd1 vccd1 sky130_fd_sc_hd__tapvpwrvgnd_1
X_6068_ hold67/X _6551_/Q _6072_/S vssd1 vssd1 vccd1 vccd1 hold68/A sky130_fd_sc_hd__mux2_1
XFILLER_0_84_81 vssd1 vssd1 vccd1 vccd1 sky130_fd_sc_hd__decap_3
XANTENNA__5813__A1 _5807_/B vssd1 vssd1 vccd1 vccd1 sky130_fd_sc_hd__diode_2
X_5019_ _5007_/Y _5017_/X _4919_/Y _5004_/X vssd1 vssd1 vccd1 vccd1 _5020_/A sky130_fd_sc_hd__o211ai_2
XFILLER_0_82_118 vssd1 vssd1 vccd1 vccd1 sky130_fd_sc_hd__fill_2
XFILLER_0_48_362 vssd1 vssd1 vccd1 vccd1 sky130_fd_sc_hd__fill_2
XFILLER_0_118_283 vssd1 vssd1 vccd1 vccd1 sky130_fd_sc_hd__fill_2
XFILLER_0_106_401 vssd1 vssd1 vccd1 vccd1 sky130_fd_sc_hd__decap_6
XANTENNA__5047__A _5093_/A vssd1 vssd1 vccd1 vccd1 sky130_fd_sc_hd__diode_2
XANTENNA__6057__A1 hold98/X vssd1 vssd1 vccd1 vccd1 sky130_fd_sc_hd__diode_2
XANTENNA__6628__SET_B fanout145/X vssd1 vssd1 vccd1 vccd1 sky130_fd_sc_hd__diode_2
XFILLER_0_98_295 vssd1 vssd1 vccd1 vccd1 sky130_fd_sc_hd__fill_1
XFILLER_0_13_55 vssd1 vssd1 vccd1 vccd1 sky130_fd_sc_hd__fill_1
XFILLER_0_13_99 vssd1 vssd1 vccd1 vccd1 sky130_fd_sc_hd__decap_4
XFILLER_0_13_77 vssd1 vssd1 vccd1 vccd1 sky130_fd_sc_hd__fill_1
XFILLER_0_14_229 vssd1 vssd1 vccd1 vccd1 sky130_fd_sc_hd__fill_2
XFILLER_0_112_404 vssd1 vssd1 vccd1 vccd1 sky130_fd_sc_hd__decap_3
XFILLER_0_120_78 vssd1 vssd1 vccd1 vccd1 sky130_fd_sc_hd__decap_4
X_5370_ _5370_/A _5370_/B vssd1 vssd1 vccd1 vccd1 _5559_/B sky130_fd_sc_hd__nor2_2
X_4321_ _4396_/A _4396_/B vssd1 vssd1 vccd1 vccd1 _4344_/A sky130_fd_sc_hd__nand2b_1
XFILLER_0_22_273 vssd1 vssd1 vccd1 vccd1 sky130_fd_sc_hd__fill_2
X_4252_ _5754_/A _4527_/B _4658_/D _4822_/B vssd1 vssd1 vccd1 vccd1 _4253_/B sky130_fd_sc_hd__a22oi_1
Xfanout109 _4638_/A vssd1 vssd1 vccd1 vccd1 _5656_/A sky130_fd_sc_hd__buf_4
XFILLER_0_129_65 vssd1 vssd1 vccd1 vccd1 sky130_fd_sc_hd__fill_1
XFILLER_0_38_74 vssd1 vssd1 vccd1 vccd1 sky130_fd_sc_hd__fill_1
XFILLER_0_38_85 vssd1 vssd1 vccd1 vccd1 sky130_fd_sc_hd__fill_2
XFILLER_0_38_96 vssd1 vssd1 vccd1 vccd1 sky130_fd_sc_hd__fill_2
X_4183_ _4842_/A _4971_/B _4966_/A _4966_/C vssd1 vssd1 vccd1 vccd1 _4183_/X sky130_fd_sc_hd__and4_1
X_6824_ _6827_/CLK _6824_/D fanout152/X vssd1 vssd1 vccd1 vccd1 depth_mport_o[46]
+ sky130_fd_sc_hd__dfrtp_4
XFILLER_0_9_234 vssd1 vssd1 vccd1 vccd1 sky130_fd_sc_hd__fill_2
XANTENNA__6220__B2 _6223_/B vssd1 vssd1 vccd1 vccd1 sky130_fd_sc_hd__diode_2
X_6755_ _6853_/CLK _6755_/D _6073_/A vssd1 vssd1 vccd1 vccd1 pix_mport_o[3] sky130_fd_sc_hd__dfrtp_4
X_3967_ _3870_/X _3964_/Y _3966_/B vssd1 vssd1 vccd1 vccd1 _3968_/B sky130_fd_sc_hd__o21ba_1
X_5706_ _5692_/A _5699_/X _5704_/X _5796_/A vssd1 vssd1 vccd1 vccd1 _5706_/X sky130_fd_sc_hd__a31o_1
XFILLER_0_70_83 vssd1 vssd1 vccd1 vccd1 sky130_fd_sc_hd__fill_1
XFILLER_0_115_220 vssd1 vssd1 vccd1 vccd1 sky130_fd_sc_hd__fill_2
X_6686_ _6693_/CLK _6686_/D vssd1 vssd1 vccd1 vccd1 _6686_/Q sky130_fd_sc_hd__dfxtp_4
X_3898_ _3900_/A _3898_/B vssd1 vssd1 vccd1 vccd1 _4005_/B sky130_fd_sc_hd__and2_1
X_5637_ _5800_/C vssd1 vssd1 vccd1 vccd1 _5647_/B sky130_fd_sc_hd__inv_2
XFILLER_0_60_357 vssd1 vssd1 vccd1 vccd1 sky130_fd_sc_hd__fill_1
X_5568_ tex_mport_o[36] _5576_/S _5567_/X vssd1 vssd1 vccd1 vccd1 _6593_/D sky130_fd_sc_hd__a21o_1
XANTENNA__3337__A2 _5273_/A vssd1 vssd1 vccd1 vccd1 sky130_fd_sc_hd__diode_2
Xhold141 _6863_/Q vssd1 vssd1 vccd1 vccd1 hold141/X sky130_fd_sc_hd__dlygate4sd3_1
Xhold130 _6837_/Q vssd1 vssd1 vccd1 vccd1 hold130/X sky130_fd_sc_hd__dlygate4sd3_1
Xhold152 _6841_/Q vssd1 vssd1 vccd1 vccd1 hold152/X sky130_fd_sc_hd__dlygate4sd3_1
X_4519_ _4519_/A _4519_/B vssd1 vssd1 vccd1 vccd1 _4520_/B sky130_fd_sc_hd__nor2_1
Xhold185 _6551_/Q vssd1 vssd1 vccd1 vccd1 hold185/X sky130_fd_sc_hd__dlygate4sd3_1
Xhold174 _6860_/Q vssd1 vssd1 vccd1 vccd1 hold174/X sky130_fd_sc_hd__dlygate4sd3_1
X_5499_ hold59/X sstream_i[90] _5502_/S vssd1 vssd1 vccd1 vccd1 _6532_/D sky130_fd_sc_hd__mux2_1
Xhold163 _6106_/X vssd1 vssd1 vccd1 vccd1 _6744_/D sky130_fd_sc_hd__dlygate4sd3_1
Xhold196 _6633_/Q vssd1 vssd1 vccd1 vccd1 hold196/X sky130_fd_sc_hd__dlygate4sd3_1
XFILLER_0_95_91 vssd1 vssd1 vccd1 vccd1 sky130_fd_sc_hd__decap_4
XTAP_490 vssd1 vccd1 sky130_fd_sc_hd__tapvpwrvgnd_1
XFILLER_0_138_301 vssd1 vssd1 vccd1 vccd1 sky130_fd_sc_hd__fill_1
XFILLER_0_95_232 vssd1 vssd1 vccd1 vccd1 sky130_fd_sc_hd__fill_2
XANTENNA__4470__B1 _4841_/C vssd1 vssd1 vccd1 vccd1 sky130_fd_sc_hd__diode_2
XFILLER_0_83_405 vssd1 vssd1 vccd1 vccd1 sky130_fd_sc_hd__fill_2
XFILLER_0_138_389 vssd1 vssd1 vccd1 vccd1 sky130_fd_sc_hd__decap_3
XFILLER_0_63_173 vssd1 vssd1 vccd1 vccd1 sky130_fd_sc_hd__fill_2
XFILLER_0_63_151 vssd1 vssd1 vccd1 vccd1 sky130_fd_sc_hd__decap_4
XANTENNA__5970__B1 _5969_/X vssd1 vssd1 vccd1 vccd1 sky130_fd_sc_hd__diode_2
XFILLER_0_36_365 vssd1 vssd1 vccd1 vccd1 sky130_fd_sc_hd__fill_2
XFILLER_0_106_253 vssd1 vssd1 vccd1 vccd1 sky130_fd_sc_hd__fill_1
XFILLER_0_36_398 vssd1 vssd1 vccd1 vccd1 sky130_fd_sc_hd__decap_8
XANTENNA__4112__C _4433_/D vssd1 vssd1 vccd1 vccd1 sky130_fd_sc_hd__diode_2
XANTENNA__3500__A2 _5286_/B vssd1 vssd1 vccd1 vccd1 sky130_fd_sc_hd__diode_2
XANTENNA__4782__C _4970_/B vssd1 vssd1 vccd1 vccd1 sky130_fd_sc_hd__diode_2
XFILLER_0_115_78 vssd1 vssd1 vccd1 vccd1 sky130_fd_sc_hd__fill_1
X_4870_ _4869_/A _4869_/Y _4854_/X _4856_/Y vssd1 vssd1 vccd1 vccd1 _4872_/C sky130_fd_sc_hd__a211o_2
XFILLER_0_138_3 vssd1 vssd1 vccd1 vccd1 sky130_fd_sc_hd__fill_2
XFILLER_0_129_345 vssd1 vssd1 vccd1 vccd1 sky130_fd_sc_hd__fill_1
XFILLER_0_86_276 vssd1 vssd1 vccd1 vccd1 sky130_fd_sc_hd__fill_1
X_3821_ _3819_/X _3821_/B vssd1 vssd1 vccd1 vccd1 _3877_/A sky130_fd_sc_hd__nand2b_1
X_6540_ _6855_/CLK _6540_/D vssd1 vssd1 vccd1 vccd1 hold98/A sky130_fd_sc_hd__dfxtp_2
XANTENNA__4764__A1 _4944_/B vssd1 vssd1 vccd1 vccd1 sky130_fd_sc_hd__diode_2
XFILLER_0_131_66 vssd1 vssd1 vccd1 vccd1 sky130_fd_sc_hd__decap_3
X_3752_ _3833_/A _3833_/B _3744_/Y vssd1 vssd1 vccd1 vccd1 _3757_/A sky130_fd_sc_hd__o21ai_1
XFILLER_0_27_365 vssd1 vssd1 vccd1 vccd1 sky130_fd_sc_hd__decap_6
XFILLER_0_27_376 vssd1 vssd1 vccd1 vccd1 sky130_fd_sc_hd__fill_1
XFILLER_0_42_313 vssd1 vssd1 vccd1 vccd1 sky130_fd_sc_hd__fill_1
XFILLER_0_54_151 vssd1 vssd1 vccd1 vccd1 sky130_fd_sc_hd__fill_2
X_6471_ hold212/X sstream_i[29] _6472_/S vssd1 vssd1 vccd1 vccd1 _6862_/D sky130_fd_sc_hd__mux2_1
X_3683_ _3999_/A _6686_/Q _3667_/X _3670_/B vssd1 vssd1 vccd1 vccd1 _3684_/B sky130_fd_sc_hd__a211o_1
X_5422_ _5424_/B _5424_/C vssd1 vssd1 vccd1 vccd1 _5422_/X sky130_fd_sc_hd__and2_1
X_5353_ _5354_/B _5357_/A _5354_/A vssd1 vssd1 vccd1 vccd1 _5355_/A sky130_fd_sc_hd__a21oi_1
XANTENNA__6269__A1 _6841_/Q vssd1 vssd1 vccd1 vccd1 sky130_fd_sc_hd__diode_2
XFILLER_0_112_278 vssd1 vssd1 vccd1 vccd1 sky130_fd_sc_hd__decap_3
X_4304_ _4297_/A _4298_/A _4297_/B _4299_/B _4299_/A vssd1 vssd1 vccd1 vccd1 _4309_/A
+ sky130_fd_sc_hd__a32o_2
XANTENNA__6010__S _6038_/C vssd1 vssd1 vccd1 vccd1 sky130_fd_sc_hd__diode_2
X_5284_ _5284_/A _5284_/B vssd1 vssd1 vccd1 vccd1 _5288_/A sky130_fd_sc_hd__xnor2_2
X_4235_ _4037_/A _4037_/C _4037_/B vssd1 vssd1 vccd1 vccd1 _4236_/C sky130_fd_sc_hd__a21o_1
XFILLER_0_10_298 vssd1 vssd1 vccd1 vccd1 sky130_fd_sc_hd__decap_8
X_4166_ _4895_/B _4165_/C _4165_/A vssd1 vssd1 vccd1 vccd1 _4166_/Y sky130_fd_sc_hd__a21oi_1
XFILLER_0_4_53 vssd1 vssd1 vccd1 vccd1 sky130_ef_sc_hd__decap_12
XFILLER_0_4_97 vssd1 vssd1 vccd1 vccd1 sky130_ef_sc_hd__decap_12
X_4097_ _4582_/D _4551_/D _5732_/A _5718_/A vssd1 vssd1 vccd1 vccd1 _4146_/A sky130_fd_sc_hd__nand4_2
XFILLER_0_81_71 vssd1 vssd1 vccd1 vccd1 sky130_fd_sc_hd__fill_2
XFILLER_0_65_405 vssd1 vssd1 vccd1 vccd1 sky130_fd_sc_hd__fill_2
X_6807_ _6863_/CLK _6807_/D nrst_i vssd1 vssd1 vccd1 vccd1 _6807_/Q sky130_fd_sc_hd__dfstp_1
XFILLER_0_92_257 vssd1 vssd1 vccd1 vccd1 sky130_fd_sc_hd__fill_2
X_4999_ _4921_/X _4924_/X _5235_/B _4998_/X vssd1 vssd1 vccd1 vccd1 _5000_/A sky130_fd_sc_hd__a211oi_1
XFILLER_0_135_337 vssd1 vssd1 vccd1 vccd1 sky130_ef_sc_hd__decap_12
XFILLER_0_33_302 vssd1 vssd1 vccd1 vccd1 sky130_fd_sc_hd__fill_2
X_6738_ _6751_/CLK _6738_/D fanout140/X vssd1 vssd1 vccd1 vccd1 _6738_/Q sky130_fd_sc_hd__dfstp_1
X_6669_ _6880_/CLK _6669_/D vssd1 vssd1 vccd1 vccd1 _6669_/Q sky130_fd_sc_hd__dfxtp_1
XFILLER_0_60_132 vssd1 vssd1 vccd1 vccd1 sky130_fd_sc_hd__decap_4
XFILLER_0_60_176 vssd1 vssd1 vccd1 vccd1 sky130_fd_sc_hd__decap_3
XFILLER_0_103_278 vssd1 vssd1 vccd1 vccd1 sky130_fd_sc_hd__fill_2
XFILLER_0_41_390 vssd1 vssd1 vccd1 vccd1 sky130_fd_sc_hd__fill_2
XANTENNA__3499__B _5276_/B vssd1 vssd1 vccd1 vccd1 sky130_fd_sc_hd__diode_2
XFILLER_0_56_405 vssd1 vssd1 vccd1 vccd1 sky130_fd_sc_hd__fill_2
XANTENNA__6196__B1 _6224_/B vssd1 vssd1 vccd1 vccd1 sky130_fd_sc_hd__diode_2
XFILLER_0_83_202 vssd1 vssd1 vccd1 vccd1 sky130_fd_sc_hd__fill_2
XANTENNA__4107__C _4736_/D vssd1 vssd1 vccd1 vccd1 sky130_fd_sc_hd__diode_2
XFILLER_0_28_118 vssd1 vssd1 vccd1 vccd1 sky130_fd_sc_hd__decap_3
XFILLER_0_138_153 vssd1 vssd1 vccd1 vccd1 sky130_fd_sc_hd__fill_1
XFILLER_0_138_197 vssd1 vssd1 vccd1 vccd1 sky130_fd_sc_hd__fill_1
Xfanout80 tex_width_i[9] vssd1 vssd1 vccd1 vccd1 _5296_/A sky130_fd_sc_hd__buf_4
Xfanout91 tex_width_i[7] vssd1 vssd1 vccd1 vccd1 _4816_/B sky130_fd_sc_hd__buf_4
XFILLER_0_24_313 vssd1 vssd1 vccd1 vccd1 sky130_fd_sc_hd__fill_1
XFILLER_0_24_346 vssd1 vssd1 vccd1 vccd1 sky130_fd_sc_hd__fill_1
XFILLER_0_51_132 vssd1 vssd1 vccd1 vccd1 sky130_fd_sc_hd__fill_2
XFILLER_0_51_165 vssd1 vssd1 vccd1 vccd1 sky130_fd_sc_hd__decap_3
XFILLER_0_86_27 vssd1 vssd1 vccd1 vccd1 sky130_fd_sc_hd__fill_1
X_4020_ _3858_/A _3856_/Y _3849_/X _3851_/Y vssd1 vssd1 vccd1 vccd1 _4020_/X sky130_fd_sc_hd__o211a_1
XANTENNA__4793__B _5049_/D vssd1 vssd1 vccd1 vccd1 sky130_fd_sc_hd__diode_2
XANTENNA__6423__A1 _6543_/Q vssd1 vssd1 vccd1 vccd1 sky130_fd_sc_hd__diode_2
XFILLER_0_29_9 vssd1 vssd1 vccd1 vccd1 sky130_fd_sc_hd__fill_1
XFILLER_0_35_20 vssd1 vssd1 vccd1 vccd1 sky130_fd_sc_hd__decap_4
XANTENNA__4434__B1 _4433_/D vssd1 vssd1 vccd1 vccd1 sky130_fd_sc_hd__diode_2
X_5971_ _3277_/Y hold113/X _6038_/C vssd1 vssd1 vccd1 vccd1 _5971_/X sky130_fd_sc_hd__mux2_1
XFILLER_0_59_210 vssd1 vssd1 vccd1 vccd1 sky130_fd_sc_hd__fill_1
XFILLER_0_59_221 vssd1 vssd1 vccd1 vccd1 sky130_fd_sc_hd__decap_3
XFILLER_0_47_405 vssd1 vssd1 vccd1 vccd1 sky130_fd_sc_hd__fill_2
X_4922_ _4914_/A _4915_/A _4914_/B _4916_/X vssd1 vssd1 vccd1 vccd1 _4924_/B sky130_fd_sc_hd__a31oi_1
XFILLER_0_74_224 vssd1 vssd1 vccd1 vccd1 sky130_fd_sc_hd__fill_2
XFILLER_0_117_315 vssd1 vssd1 vccd1 vccd1 sky130_fd_sc_hd__fill_2
XANTENNA__6747__SET_B fanout140/X vssd1 vssd1 vccd1 vccd1 sky130_fd_sc_hd__diode_2
XFILLER_0_51_41 vssd1 vssd1 vccd1 vccd1 sky130_fd_sc_hd__fill_1
X_4853_ _4852_/A _4852_/B _4852_/C vssd1 vssd1 vccd1 vccd1 _4855_/C sky130_fd_sc_hd__a21o_1
XFILLER_0_117_337 vssd1 vssd1 vccd1 vccd1 sky130_fd_sc_hd__fill_1
XANTENNA__4314__A _4958_/B vssd1 vssd1 vccd1 vccd1 sky130_fd_sc_hd__diode_2
XFILLER_0_74_268 vssd1 vssd1 vccd1 vccd1 sky130_fd_sc_hd__decap_3
XANTENNA__6005__S _6038_/C vssd1 vssd1 vccd1 vccd1 sky130_fd_sc_hd__diode_2
X_3804_ _5049_/D _5081_/C _5081_/D _3870_/A vssd1 vssd1 vccd1 vccd1 _3805_/D sky130_fd_sc_hd__a22o_1
X_4784_ _4784_/A _4784_/B vssd1 vssd1 vccd1 vccd1 _4866_/A sky130_fd_sc_hd__nand2_1
X_6523_ _6841_/CLK _6523_/D vssd1 vssd1 vccd1 vccd1 hold25/A sky130_fd_sc_hd__dfxtp_1
X_3735_ _3735_/A _3735_/B _3735_/C vssd1 vssd1 vccd1 vccd1 _3735_/Y sky130_fd_sc_hd__nor3_2
XFILLER_0_27_173 vssd1 vssd1 vccd1 vccd1 sky130_fd_sc_hd__fill_2
X_6454_ hold144/X sstream_i[12] _6472_/S vssd1 vssd1 vccd1 vccd1 _6845_/D sky130_fd_sc_hd__mux2_1
XFILLER_0_15_368 vssd1 vssd1 vccd1 vccd1 sky130_ef_sc_hd__decap_12
XFILLER_0_15_357 vssd1 vssd1 vccd1 vccd1 sky130_fd_sc_hd__decap_8
XANTENNA__5844__S _5844_/S vssd1 vssd1 vccd1 vccd1 sky130_fd_sc_hd__diode_2
X_5405_ _5396_/A _5396_/B _4367_/X vssd1 vssd1 vccd1 vccd1 _5406_/B sky130_fd_sc_hd__a21oi_1
X_3666_ _3669_/D vssd1 vssd1 vccd1 vccd1 _3666_/Y sky130_fd_sc_hd__inv_2
X_6385_ _6368_/S _6416_/B _6382_/X vssd1 vssd1 vccd1 vccd1 _6391_/A sky130_fd_sc_hd__o21ai_2
XFILLER_0_100_204 vssd1 vssd1 vccd1 vccd1 sky130_fd_sc_hd__decap_3
XFILLER_0_2_251 vssd1 vssd1 vccd1 vccd1 sky130_fd_sc_hd__fill_1
X_3597_ _3595_/X _3597_/B vssd1 vssd1 vccd1 vccd1 _3627_/A sky130_fd_sc_hd__nand2b_1
X_5336_ _5336_/A _5336_/B _5336_/C vssd1 vssd1 vccd1 vccd1 _5594_/C sky130_fd_sc_hd__and3_1
X_5267_ _5438_/A _5267_/B vssd1 vssd1 vccd1 vccd1 _5441_/D sky130_fd_sc_hd__or2_1
X_4218_ _4217_/A _4217_/B _4169_/X vssd1 vssd1 vccd1 vccd1 _4218_/X sky130_fd_sc_hd__o21ba_1
X_5198_ _5197_/A _5197_/Y _5177_/Y _5184_/X vssd1 vssd1 vccd1 vccd1 _5201_/A sky130_fd_sc_hd__a211oi_2
X_4149_ _4212_/A _4148_/B _4145_/X vssd1 vssd1 vccd1 vccd1 _4165_/A sky130_fd_sc_hd__a21o_1
XANTENNA__4208__B _4527_/B vssd1 vssd1 vccd1 vccd1 sky130_fd_sc_hd__diode_2
XFILLER_0_80_216 vssd1 vssd1 vccd1 vccd1 sky130_ef_sc_hd__decap_12
XFILLER_0_80_249 vssd1 vssd1 vccd1 vccd1 sky130_fd_sc_hd__decap_3
XFILLER_0_33_154 vssd1 vssd1 vccd1 vccd1 sky130_fd_sc_hd__fill_2
XANTENNA__3951__A2 _5115_/D vssd1 vssd1 vccd1 vccd1 sky130_fd_sc_hd__diode_2
XANTENNA__3467__A1 _5320_/A vssd1 vssd1 vccd1 vccd1 sky130_fd_sc_hd__diode_2
XANTENNA__5929__S _5932_/S vssd1 vssd1 vccd1 vccd1 sky130_fd_sc_hd__diode_2
XANTENNA__4967__A1 _4966_/A vssd1 vssd1 vccd1 vccd1 sky130_fd_sc_hd__diode_2
XTAP_1250 vssd1 vccd1 sky130_fd_sc_hd__tapvpwrvgnd_1
XANTENNA__4967__B2 _5115_/C vssd1 vssd1 vccd1 vccd1 sky130_fd_sc_hd__diode_2
XFILLER_0_29_405 vssd1 vssd1 vccd1 vccd1 sky130_fd_sc_hd__fill_2
XTAP_1261 vssd1 vccd1 sky130_fd_sc_hd__tapvpwrvgnd_1
XFILLER_0_112_68 vssd1 vssd1 vccd1 vccd1 sky130_fd_sc_hd__fill_2
XFILLER_0_126_178 vssd1 vssd1 vccd1 vccd1 sky130_fd_sc_hd__fill_2
XANTENNA__5664__S _5844_/S vssd1 vssd1 vccd1 vccd1 sky130_fd_sc_hd__diode_2
X_3520_ _3520_/A _3520_/B vssd1 vssd1 vccd1 vccd1 _3525_/A sky130_fd_sc_hd__xor2_1
XFILLER_0_24_132 vssd1 vssd1 vccd1 vccd1 sky130_fd_sc_hd__fill_2
X_3451_ _3999_/A _6689_/Q _3451_/C vssd1 vssd1 vccd1 vccd1 _3453_/A sky130_fd_sc_hd__and3_1
X_6170_ _6170_/A _6170_/B vssd1 vssd1 vccd1 vccd1 _6172_/B sky130_fd_sc_hd__xnor2_1
X_3382_ _5051_/A _5296_/B vssd1 vssd1 vccd1 vccd1 _3658_/B sky130_fd_sc_hd__nand2_1
XFILLER_0_20_393 vssd1 vssd1 vccd1 vccd1 sky130_ef_sc_hd__decap_12
X_5121_ _5121_/A _5121_/B _5121_/C vssd1 vssd1 vccd1 vccd1 _5121_/X sky130_fd_sc_hd__and3_1
XANTENNA__5115__D _5115_/D vssd1 vssd1 vccd1 vccd1 sky130_fd_sc_hd__diode_2
XFILLER_0_34_7 vssd1 vssd1 vccd1 vccd1 sky130_fd_sc_hd__fill_2
X_5052_ _5051_/A _6678_/Q _5051_/C _5051_/D vssd1 vssd1 vccd1 vccd1 _5054_/B sky130_fd_sc_hd__a22o_1
XFILLER_0_79_305 vssd1 vssd1 vccd1 vccd1 sky130_fd_sc_hd__fill_2
X_4003_ _4003_/A _5207_/A vssd1 vssd1 vccd1 vccd1 _4010_/A sky130_fd_sc_hd__nand2_1
XANTENNA__4028__B _4816_/B vssd1 vssd1 vccd1 vccd1 sky130_fd_sc_hd__diode_2
X_5954_ _3277_/Y _6865_/Q _5952_/X _5953_/X vssd1 vssd1 vccd1 vccd1 _5954_/X sky130_fd_sc_hd__a31o_1
XFILLER_0_87_393 vssd1 vssd1 vccd1 vccd1 sky130_ef_sc_hd__decap_12
X_5885_ _5867_/Y _5876_/A _5884_/X vssd1 vssd1 vccd1 vccd1 _5887_/B sky130_fd_sc_hd__a21oi_1
X_4905_ _4904_/C _4904_/Y _4886_/Y _4892_/X vssd1 vssd1 vccd1 vccd1 _4919_/A sky130_fd_sc_hd__a211o_2
XFILLER_0_117_101 vssd1 vssd1 vccd1 vccd1 sky130_fd_sc_hd__fill_2
XANTENNA__4044__A _5311_/A vssd1 vssd1 vccd1 vccd1 sky130_fd_sc_hd__diode_2
X_4836_ _4835_/B _4835_/C _4835_/A vssd1 vssd1 vccd1 vccd1 _4837_/C sky130_fd_sc_hd__a21bo_1
XFILLER_0_117_145 vssd1 vssd1 vccd1 vccd1 sky130_fd_sc_hd__fill_2
XFILLER_0_62_238 vssd1 vssd1 vccd1 vccd1 sky130_fd_sc_hd__fill_2
XFILLER_0_62_227 vssd1 vssd1 vccd1 vccd1 sky130_fd_sc_hd__fill_2
XFILLER_0_117_178 vssd1 vssd1 vccd1 vccd1 sky130_fd_sc_hd__fill_2
X_6506_ _6834_/CLK _6506_/D vssd1 vssd1 vccd1 vccd1 _6506_/Q sky130_fd_sc_hd__dfxtp_1
XFILLER_0_15_154 vssd1 vssd1 vccd1 vccd1 sky130_fd_sc_hd__decap_3
XFILLER_0_15_143 vssd1 vssd1 vccd1 vccd1 sky130_fd_sc_hd__fill_2
X_4767_ _6639_/Q _4768_/B vssd1 vssd1 vccd1 vccd1 _4769_/A sky130_fd_sc_hd__and2_1
X_4698_ _4697_/A _4653_/X _4697_/B vssd1 vssd1 vccd1 vccd1 _4698_/X sky130_fd_sc_hd__o21ba_1
XFILLER_0_15_187 vssd1 vssd1 vccd1 vccd1 sky130_fd_sc_hd__fill_2
X_3718_ _3718_/A _3718_/B vssd1 vssd1 vccd1 vccd1 _3783_/B sky130_fd_sc_hd__xor2_1
X_6437_ _6427_/X _6432_/Y _6433_/Y vssd1 vssd1 vccd1 vccd1 _6437_/Y sky130_fd_sc_hd__a21oi_1
XANTENNA__6332__A0 hold181/X vssd1 vssd1 vccd1 vccd1 sky130_fd_sc_hd__diode_2
XFILLER_0_15_198 vssd1 vssd1 vccd1 vccd1 sky130_fd_sc_hd__fill_1
X_3649_ _3649_/A _3649_/B vssd1 vssd1 vccd1 vccd1 _3651_/B sky130_fd_sc_hd__or2_1
X_6368_ hold53/A _6383_/A _6368_/S vssd1 vssd1 vccd1 vccd1 _6381_/B sky130_fd_sc_hd__mux2_1
XFILLER_0_11_393 vssd1 vssd1 vccd1 vccd1 sky130_ef_sc_hd__decap_12
X_5319_ _3541_/A _3541_/C _3541_/B vssd1 vssd1 vccd1 vccd1 _5321_/A sky130_fd_sc_hd__a21bo_1
Xhold12 hold12/A vssd1 vssd1 vccd1 vccd1 hold12/X sky130_fd_sc_hd__dlygate4sd3_1
X_6299_ hold220/X _6300_/B _6298_/Y _6294_/X vssd1 vssd1 vccd1 vccd1 _6783_/D sky130_fd_sc_hd__o22a_1
Xhold23 hold23/A vssd1 vssd1 vccd1 vccd1 hold23/X sky130_fd_sc_hd__dlygate4sd3_1
XANTENNA__5603__A _5718_/B vssd1 vssd1 vccd1 vccd1 sky130_fd_sc_hd__diode_2
Xhold34 hold34/A vssd1 vssd1 vccd1 vccd1 hold34/X sky130_fd_sc_hd__dlygate4sd3_1
Xhold56 hold56/A vssd1 vssd1 vccd1 vccd1 hold56/X sky130_fd_sc_hd__dlygate4sd3_1
Xhold45 hold45/A vssd1 vssd1 vccd1 vccd1 hold45/X sky130_fd_sc_hd__dlygate4sd3_1
Xhold78 hold78/A vssd1 vssd1 vccd1 vccd1 hold78/X sky130_fd_sc_hd__dlygate4sd3_1
Xhold67 hold67/A vssd1 vssd1 vccd1 vccd1 hold67/X sky130_fd_sc_hd__dlygate4sd3_1
Xhold89 hold89/A vssd1 vssd1 vccd1 vccd1 hold89/X sky130_fd_sc_hd__dlygate4sd3_1
XFILLER_0_97_113 vssd1 vssd1 vccd1 vccd1 sky130_fd_sc_hd__decap_3
XFILLER_0_85_308 vssd1 vssd1 vccd1 vccd1 sky130_fd_sc_hd__decap_3
XANTENNA__4177__A2 _4816_/B vssd1 vssd1 vccd1 vccd1 sky130_fd_sc_hd__diode_2
XANTENNA_9 sstream_i[10] vssd1 vssd1 vccd1 vccd1 sky130_fd_sc_hd__diode_2
XANTENNA__4401__B _4476_/D vssd1 vssd1 vccd1 vccd1 sky130_fd_sc_hd__diode_2
XFILLER_0_21_157 vssd1 vssd1 vccd1 vccd1 sky130_fd_sc_hd__decap_3
XTAP_319 vssd1 vccd1 sky130_fd_sc_hd__tapvpwrvgnd_1
XTAP_308 vssd1 vccd1 sky130_fd_sc_hd__tapvpwrvgnd_1
XFILLER_0_83_17 vssd1 vssd1 vccd1 vccd1 sky130_fd_sc_hd__decap_4
XANTENNA__4774__D _4814_/D vssd1 vssd1 vccd1 vccd1 sky130_fd_sc_hd__diode_2
XFILLER_0_107_57 vssd1 vssd1 vccd1 vccd1 sky130_fd_sc_hd__fill_2
XFILLER_0_88_124 vssd1 vssd1 vccd1 vccd1 sky130_fd_sc_hd__fill_2
XANTENNA__6344__A hold98/A vssd1 vssd1 vccd1 vccd1 sky130_fd_sc_hd__diode_2
XFILLER_0_123_34 vssd1 vssd1 vccd1 vccd1 sky130_fd_sc_hd__fill_2
XFILLER_0_69_393 vssd1 vssd1 vccd1 vccd1 sky130_ef_sc_hd__decap_12
XTAP_1091 vssd1 vccd1 sky130_fd_sc_hd__tapvpwrvgnd_1
XTAP_1080 vssd1 vccd1 sky130_fd_sc_hd__tapvpwrvgnd_1
X_5670_ tex_addr_i[3] _5670_/B vssd1 vssd1 vccd1 vccd1 _5671_/B sky130_fd_sc_hd__or2_1
X_4621_ _4621_/A _4621_/B vssd1 vssd1 vccd1 vccd1 _4636_/B sky130_fd_sc_hd__xnor2_2
XFILLER_0_44_216 vssd1 vssd1 vccd1 vccd1 sky130_ef_sc_hd__decap_12
XFILLER_0_4_302 vssd1 vssd1 vccd1 vccd1 sky130_fd_sc_hd__fill_2
X_4552_ _5656_/A _4614_/C vssd1 vssd1 vccd1 vccd1 _4554_/B sky130_fd_sc_hd__and2_1
XFILLER_0_4_357 vssd1 vssd1 vccd1 vccd1 sky130_fd_sc_hd__fill_2
X_4483_ _4482_/A _4482_/B _4482_/C vssd1 vssd1 vccd1 vccd1 _4484_/D sky130_fd_sc_hd__a21o_1
XFILLER_0_12_124 vssd1 vssd1 vccd1 vccd1 sky130_fd_sc_hd__fill_2
X_3503_ _3502_/B _3502_/C _3502_/A vssd1 vssd1 vccd1 vccd1 _3504_/B sky130_fd_sc_hd__o21ai_1
X_6222_ pix_mport_o[49] _6224_/B _6219_/Y _6221_/X vssd1 vssd1 vccd1 vccd1 _6777_/D
+ sky130_fd_sc_hd__o22a_1
XFILLER_0_12_179 vssd1 vssd1 vccd1 vccd1 sky130_fd_sc_hd__fill_2
X_3434_ _5306_/A _5276_/B _6686_/Q _5292_/A vssd1 vssd1 vccd1 vccd1 _3437_/D sky130_fd_sc_hd__a22o_1
X_6153_ _6224_/B _6163_/A vssd1 vssd1 vccd1 vccd1 _6153_/Y sky130_fd_sc_hd__nand2_1
XTAP_853 vssd1 vccd1 sky130_fd_sc_hd__tapvpwrvgnd_1
XTAP_842 vssd1 vccd1 sky130_fd_sc_hd__tapvpwrvgnd_1
XTAP_831 vssd1 vccd1 sky130_fd_sc_hd__tapvpwrvgnd_1
XTAP_820 vssd1 vccd1 sky130_fd_sc_hd__tapvpwrvgnd_1
X_3365_ _3440_/A _6686_/Q _5311_/A _3365_/D vssd1 vssd1 vccd1 vccd1 _3440_/B sky130_fd_sc_hd__and4b_1
XFILLER_0_20_190 vssd1 vssd1 vccd1 vccd1 sky130_fd_sc_hd__fill_2
X_3296_ depth_mport_i[29] vssd1 vssd1 vccd1 vccd1 _3296_/Y sky130_fd_sc_hd__inv_2
X_6084_ _6623_/Q hold258/X _6098_/S vssd1 vssd1 vccd1 vccd1 _6084_/X sky130_fd_sc_hd__mux2_1
XTAP_886 vssd1 vccd1 sky130_fd_sc_hd__tapvpwrvgnd_1
XTAP_875 vssd1 vccd1 sky130_fd_sc_hd__tapvpwrvgnd_1
XTAP_864 vssd1 vccd1 sky130_fd_sc_hd__tapvpwrvgnd_1
X_5104_ _5100_/X _5160_/A vssd1 vssd1 vccd1 vccd1 _5112_/A sky130_fd_sc_hd__and2b_1
XTAP_897 vssd1 vccd1 sky130_fd_sc_hd__tapvpwrvgnd_1
X_5035_ _5028_/Y _5029_/X _4132_/Y _4134_/X vssd1 vssd1 vccd1 vccd1 _5035_/X sky130_fd_sc_hd__a211o_1
XFILLER_0_79_113 vssd1 vssd1 vccd1 vccd1 sky130_fd_sc_hd__fill_2
XFILLER_0_79_102 vssd1 vssd1 vccd1 vccd1 sky130_fd_sc_hd__fill_1
XFILLER_0_25_3 vssd1 vssd1 vccd1 vccd1 sky130_ef_sc_hd__decap_12
XANTENNA__3878__A _5049_/A vssd1 vssd1 vccd1 vccd1 sky130_fd_sc_hd__diode_2
XFILLER_0_94_105 vssd1 vssd1 vccd1 vccd1 sky130_fd_sc_hd__fill_1
XFILLER_0_94_149 vssd1 vssd1 vccd1 vccd1 sky130_ef_sc_hd__decap_12
X_5937_ _5937_/A filt_depth_fly_o vssd1 vssd1 vccd1 vccd1 _5937_/Y sky130_fd_sc_hd__nand2_1
XFILLER_0_90_333 vssd1 vssd1 vccd1 vccd1 sky130_fd_sc_hd__decap_4
X_5868_ tex_addr_i[20] tex_addr_i[21] tex_addr_i[22] tex_addr_i[23] _5913_/B vssd1
+ vssd1 vccd1 vccd1 _5869_/A sky130_fd_sc_hd__o41a_1
X_4819_ _4956_/B _4817_/X _4809_/X _4813_/X vssd1 vssd1 vccd1 vccd1 _4820_/B sky130_fd_sc_hd__a211o_1
X_5799_ _5802_/B _5802_/C _5801_/A vssd1 vssd1 vccd1 vccd1 _5803_/B sky130_fd_sc_hd__and3b_1
XANTENNA__6420__C _6546_/Q vssd1 vssd1 vccd1 vccd1 sky130_fd_sc_hd__diode_2
XFILLER_0_90_377 vssd1 vssd1 vccd1 vccd1 sky130_ef_sc_hd__decap_12
XFILLER_0_43_293 vssd1 vssd1 vccd1 vccd1 sky130_fd_sc_hd__fill_2
XFILLER_0_101_354 vssd1 vssd1 vccd1 vccd1 sky130_ef_sc_hd__decap_12
XANTENNA_clkbuf_leaf_8_clk_i_A clkbuf_leaf_9_clk_i/A vssd1 vssd1 vccd1 vccd1 sky130_fd_sc_hd__diode_2
XANTENNA__3842__A1 _3999_/A vssd1 vssd1 vccd1 vccd1 sky130_fd_sc_hd__diode_2
XANTENNA__5595__B2 _5588_/C vssd1 vssd1 vccd1 vccd1 sky130_fd_sc_hd__diode_2
XPHY_152 vssd1 vssd1 vccd1 vccd1 sky130_fd_sc_hd__decap_3
XPHY_141 vssd1 vssd1 vccd1 vccd1 sky130_fd_sc_hd__decap_3
XPHY_130 vssd1 vssd1 vccd1 vccd1 sky130_fd_sc_hd__decap_3
XPHY_185 vssd1 vssd1 vccd1 vccd1 sky130_fd_sc_hd__decap_3
XPHY_174 vssd1 vssd1 vccd1 vccd1 sky130_fd_sc_hd__decap_3
XPHY_163 vssd1 vssd1 vccd1 vccd1 sky130_fd_sc_hd__decap_3
XFILLER_0_26_205 vssd1 vssd1 vccd1 vccd1 sky130_fd_sc_hd__decap_3
XPHY_196 vssd1 vssd1 vccd1 vccd1 sky130_fd_sc_hd__decap_3
XFILLER_0_111_107 vssd1 vssd1 vccd1 vccd1 sky130_fd_sc_hd__decap_3
XANTENNA__6339__A _6539_/Q vssd1 vssd1 vccd1 vccd1 sky130_fd_sc_hd__diode_2
XANTENNA__3530__B1 _5277_/B vssd1 vssd1 vccd1 vccd1 sky130_fd_sc_hd__diode_2
X_6840_ _6855_/CLK _6840_/D vssd1 vssd1 vccd1 vccd1 _6840_/Q sky130_fd_sc_hd__dfxtp_1
X_6771_ _6832_/CLK _6771_/D fanout153/X vssd1 vssd1 vccd1 vccd1 pix_mport_o[43] sky130_fd_sc_hd__dfrtp_4
XFILLER_0_69_190 vssd1 vssd1 vccd1 vccd1 sky130_fd_sc_hd__fill_2
XFILLER_0_9_405 vssd1 vssd1 vccd1 vccd1 sky130_fd_sc_hd__fill_2
X_5722_ tex_addr_i[8] _5723_/B vssd1 vssd1 vccd1 vccd1 _5739_/A sky130_fd_sc_hd__nand2_2
X_3983_ _5091_/A _5091_/B _5286_/B _6684_/Q vssd1 vssd1 vccd1 vccd1 _3984_/B sky130_fd_sc_hd__and4_1
XANTENNA__4025__C _4527_/B vssd1 vssd1 vccd1 vccd1 sky130_fd_sc_hd__diode_2
X_5653_ _5784_/S _5651_/X _5652_/Y _5561_/X vssd1 vssd1 vccd1 vccd1 _5653_/X sky130_fd_sc_hd__a31o_1
X_5584_ tex_mport_o[50] _5576_/S _5583_/X vssd1 vssd1 vccd1 vccd1 _6607_/D sky130_fd_sc_hd__a21o_1
X_4604_ _4603_/A _4603_/C _4603_/B vssd1 vssd1 vccd1 vccd1 _4604_/Y sky130_fd_sc_hd__a21oi_1
XFILLER_0_72_388 vssd1 vssd1 vccd1 vccd1 sky130_ef_sc_hd__decap_12
XFILLER_0_4_121 vssd1 vssd1 vccd1 vccd1 sky130_ef_sc_hd__decap_12
XANTENNA__3349__B1 _5276_/A vssd1 vssd1 vccd1 vccd1 sky130_fd_sc_hd__diode_2
XANTENNA__6013__S _6038_/C vssd1 vssd1 vccd1 vccd1 sky130_fd_sc_hd__diode_2
XFILLER_0_25_260 vssd1 vssd1 vccd1 vccd1 sky130_fd_sc_hd__decap_3
X_4535_ _4536_/A _4536_/B vssd1 vssd1 vccd1 vccd1 _4535_/X sky130_fd_sc_hd__or2_1
XFILLER_0_40_241 vssd1 vssd1 vccd1 vccd1 sky130_fd_sc_hd__decap_4
X_4466_ _4438_/A _4438_/C _4438_/B vssd1 vssd1 vccd1 vccd1 _4482_/B sky130_fd_sc_hd__a21o_1
XFILLER_0_68_72 vssd1 vssd1 vccd1 vccd1 sky130_fd_sc_hd__fill_2
X_6205_ _6204_/A _6204_/B _6207_/B vssd1 vssd1 vccd1 vccd1 _6205_/Y sky130_fd_sc_hd__a21oi_1
X_4397_ _4397_/A _4397_/B _4397_/C vssd1 vssd1 vccd1 vccd1 _4443_/A sky130_fd_sc_hd__and3_1
X_3417_ _3574_/A _3574_/B _3415_/A vssd1 vssd1 vccd1 vccd1 _3426_/A sky130_fd_sc_hd__o21ai_1
XANTENNA__3880__B _5064_/B vssd1 vssd1 vccd1 vccd1 sky130_fd_sc_hd__diode_2
X_6136_ hold61/X _6136_/B _6136_/C _6136_/D vssd1 vssd1 vccd1 vccd1 _6136_/Y sky130_fd_sc_hd__nand4_2
XFILLER_0_0_393 vssd1 vssd1 vccd1 vccd1 sky130_ef_sc_hd__decap_12
X_3348_ _5277_/A _5296_/A _5276_/A _5300_/B vssd1 vssd1 vccd1 vccd1 _3352_/A sky130_fd_sc_hd__and4_1
XTAP_650 vssd1 vccd1 sky130_fd_sc_hd__tapvpwrvgnd_1
XTAP_661 vssd1 vccd1 sky130_fd_sc_hd__tapvpwrvgnd_1
XTAP_672 vssd1 vccd1 sky130_fd_sc_hd__tapvpwrvgnd_1
XTAP_683 vssd1 vccd1 sky130_fd_sc_hd__tapvpwrvgnd_1
XTAP_694 vssd1 vccd1 sky130_fd_sc_hd__tapvpwrvgnd_1
X_6067_ hold95/X _6550_/Q _6072_/S vssd1 vssd1 vccd1 vccd1 hold96/A sky130_fd_sc_hd__mux2_1
X_3279_ _6879_/Q vssd1 vssd1 vccd1 vccd1 _5948_/A sky130_fd_sc_hd__inv_2
X_5018_ _5018_/A _5018_/B _5018_/C vssd1 vssd1 vccd1 vccd1 _5018_/Y sky130_fd_sc_hd__nand3_2
X_6969_ vssd1 vssd1 vccd1 vccd1 _6969_/HI tex_mport_o[22] sky130_fd_sc_hd__conb_1
XFILLER_0_82_108 vssd1 vssd1 vccd1 vccd1 sky130_fd_sc_hd__fill_1
XFILLER_0_75_160 vssd1 vssd1 vccd1 vccd1 sky130_fd_sc_hd__fill_2
XANTENNA_fanout11_A _5468_/X vssd1 vssd1 vccd1 vccd1 sky130_fd_sc_hd__diode_2
XFILLER_0_118_295 vssd1 vssd1 vccd1 vccd1 sky130_fd_sc_hd__fill_2
XFILLER_0_90_163 vssd1 vssd1 vccd1 vccd1 sky130_fd_sc_hd__fill_2
XFILLER_0_121_405 vssd1 vssd1 vccd1 vccd1 sky130_fd_sc_hd__fill_2
XANTENNA__5047__B _5064_/B vssd1 vssd1 vccd1 vccd1 sky130_fd_sc_hd__diode_2
XFILLER_0_31_263 vssd1 vssd1 vccd1 vccd1 sky130_fd_sc_hd__fill_1
XFILLER_0_39_363 vssd1 vssd1 vccd1 vccd1 sky130_fd_sc_hd__fill_2
XFILLER_0_89_49 vssd1 vssd1 vccd1 vccd1 sky130_fd_sc_hd__decap_4
XFILLER_0_89_38 vssd1 vssd1 vccd1 vccd1 sky130_fd_sc_hd__fill_2
XFILLER_0_89_27 vssd1 vssd1 vccd1 vccd1 sky130_fd_sc_hd__fill_2
XFILLER_0_124_276 vssd1 vssd1 vccd1 vccd1 sky130_fd_sc_hd__fill_2
XFILLER_0_1_113 vssd1 vssd1 vccd1 vccd1 sky130_ef_sc_hd__decap_12
X_4320_ _4320_/A _4320_/B vssd1 vssd1 vccd1 vccd1 _4396_/B sky130_fd_sc_hd__xor2_1
XFILLER_0_1_135 vssd1 vssd1 vccd1 vccd1 sky130_fd_sc_hd__fill_2
XFILLER_0_22_285 vssd1 vssd1 vccd1 vccd1 sky130_fd_sc_hd__fill_2
X_4251_ _4240_/A _4240_/C _4240_/D _4241_/A vssd1 vssd1 vccd1 vccd1 _4251_/X sky130_fd_sc_hd__a22o_1
XFILLER_0_59_9 vssd1 vssd1 vccd1 vccd1 sky130_fd_sc_hd__fill_1
X_4182_ _4971_/D _4822_/B vssd1 vssd1 vccd1 vccd1 _4187_/A sky130_fd_sc_hd__nand2_1
XANTENNA__6048__A2 _6038_/B vssd1 vssd1 vccd1 vccd1 sky130_fd_sc_hd__diode_2
XANTENNA__5701__A _5701_/A vssd1 vssd1 vccd1 vccd1 sky130_fd_sc_hd__diode_2
XFILLER_0_89_241 vssd1 vssd1 vccd1 vccd1 sky130_fd_sc_hd__fill_2
XANTENNA__6559__RESET_B fanout149/X vssd1 vssd1 vccd1 vccd1 sky130_fd_sc_hd__diode_2
XFILLER_0_54_85 vssd1 vssd1 vccd1 vccd1 sky130_fd_sc_hd__fill_1
X_6823_ _6830_/CLK _6823_/D fanout153/X vssd1 vssd1 vccd1 vccd1 depth_mport_o[45]
+ sky130_fd_sc_hd__dfrtp_4
XFILLER_0_9_213 vssd1 vssd1 vccd1 vccd1 sky130_fd_sc_hd__decap_4
XFILLER_0_9_202 vssd1 vssd1 vccd1 vccd1 sky130_fd_sc_hd__decap_4
X_6754_ _6864_/CLK _6754_/D _5468_/A vssd1 vssd1 vccd1 vccd1 pix_mport_o[2] sky130_fd_sc_hd__dfrtp_4
X_3966_ _3870_/X _3966_/B _3966_/C vssd1 vssd1 vccd1 vccd1 _3992_/A sky130_fd_sc_hd__and3b_1
XFILLER_0_57_160 vssd1 vssd1 vccd1 vccd1 sky130_fd_sc_hd__fill_1
X_5705_ _5692_/A _5699_/X _5704_/X vssd1 vssd1 vccd1 vccd1 _5705_/Y sky130_fd_sc_hd__a21oi_1
XFILLER_0_9_279 vssd1 vssd1 vccd1 vccd1 sky130_fd_sc_hd__fill_1
X_6685_ _6693_/CLK _6685_/D vssd1 vssd1 vccd1 vccd1 _6685_/Q sky130_fd_sc_hd__dfxtp_1
X_5636_ _5636_/A _5636_/B _5636_/C _5636_/D vssd1 vssd1 vccd1 vccd1 _5800_/C sky130_fd_sc_hd__nor4_2
XFILLER_0_92_3 vssd1 vssd1 vccd1 vccd1 sky130_fd_sc_hd__decap_8
XFILLER_0_72_163 vssd1 vssd1 vccd1 vccd1 sky130_fd_sc_hd__fill_2
X_3897_ _5106_/A _6683_/Q _3885_/X _3888_/B vssd1 vssd1 vccd1 vccd1 _3898_/B sky130_fd_sc_hd__a211o_1
XFILLER_0_103_405 vssd1 vssd1 vccd1 vccd1 sky130_fd_sc_hd__fill_2
XFILLER_0_60_325 vssd1 vssd1 vccd1 vccd1 sky130_fd_sc_hd__fill_2
XFILLER_0_130_213 vssd1 vssd1 vccd1 vccd1 sky130_fd_sc_hd__decap_6
X_5567_ _5796_/A _5567_/B _5588_/C vssd1 vssd1 vccd1 vccd1 _5567_/X sky130_fd_sc_hd__and3_1
XFILLER_0_13_241 vssd1 vssd1 vccd1 vccd1 sky130_fd_sc_hd__fill_2
Xhold120 _6843_/Q vssd1 vssd1 vccd1 vccd1 hold120/X sky130_fd_sc_hd__dlygate4sd3_1
Xhold131 _6842_/Q vssd1 vssd1 vccd1 vccd1 hold131/X sky130_fd_sc_hd__dlygate4sd3_1
Xhold153 _6849_/Q vssd1 vssd1 vccd1 vccd1 hold153/X sky130_fd_sc_hd__dlygate4sd3_1
X_5498_ hold21/X sstream_i[89] _6450_/S vssd1 vssd1 vccd1 vccd1 _6531_/D sky130_fd_sc_hd__mux2_1
X_4518_ _4789_/B _5645_/B _4551_/D _4518_/D vssd1 vssd1 vccd1 vccd1 _4519_/B sky130_fd_sc_hd__and4_1
XFILLER_0_79_82 vssd1 vssd1 vccd1 vccd1 sky130_fd_sc_hd__fill_1
Xhold142 _6520_/Q vssd1 vssd1 vccd1 vccd1 hold142/X sky130_fd_sc_hd__dlygate4sd3_1
XFILLER_0_13_263 vssd1 vssd1 vccd1 vccd1 sky130_fd_sc_hd__fill_2
X_4449_ _6631_/Q _4449_/B vssd1 vssd1 vccd1 vccd1 _4451_/C sky130_fd_sc_hd__or2_1
XANTENNA__6634__SET_B fanout144/X vssd1 vssd1 vccd1 vccd1 sky130_fd_sc_hd__diode_2
Xhold175 _6650_/Q vssd1 vssd1 vccd1 vccd1 hold175/X sky130_fd_sc_hd__dlygate4sd3_1
Xhold186 _6652_/Q vssd1 vssd1 vccd1 vccd1 hold186/X sky130_fd_sc_hd__dlygate4sd3_1
Xhold164 _6872_/Q vssd1 vssd1 vccd1 vccd1 hold164/X sky130_fd_sc_hd__dlygate4sd3_1
Xhold197 _6094_/X vssd1 vssd1 vccd1 vccd1 _6732_/D sky130_fd_sc_hd__dlygate4sd3_1
XANTENNA__6039__A2 _6038_/B vssd1 vssd1 vccd1 vccd1 sky130_fd_sc_hd__diode_2
X_6119_ hold64/X pix_mport_o[3] _6223_/B vssd1 vssd1 vccd1 vccd1 _6755_/D sky130_fd_sc_hd__mux2_1
XTAP_480 vssd1 vccd1 sky130_fd_sc_hd__tapvpwrvgnd_1
XTAP_491 vssd1 vccd1 sky130_fd_sc_hd__tapvpwrvgnd_1
XANTENNA_fanout59_A _5115_/D vssd1 vssd1 vccd1 vccd1 sky130_fd_sc_hd__diode_2
XFILLER_0_95_222 vssd1 vssd1 vccd1 vccd1 sky130_fd_sc_hd__fill_2
XANTENNA__4470__B2 _4942_/B vssd1 vssd1 vccd1 vccd1 sky130_fd_sc_hd__diode_2
XANTENNA__4470__A1 _4942_/A vssd1 vssd1 vccd1 vccd1 sky130_fd_sc_hd__diode_2
XFILLER_0_138_313 vssd1 vssd1 vccd1 vccd1 sky130_fd_sc_hd__fill_1
XFILLER_0_138_346 vssd1 vssd1 vccd1 vccd1 sky130_fd_sc_hd__fill_2
XFILLER_0_95_288 vssd1 vssd1 vccd1 vccd1 sky130_fd_sc_hd__fill_1
XFILLER_0_36_300 vssd1 vssd1 vccd1 vccd1 sky130_fd_sc_hd__fill_2
XANTENNA__3785__B _4832_/C vssd1 vssd1 vccd1 vccd1 sky130_fd_sc_hd__diode_2
XFILLER_0_106_210 vssd1 vssd1 vccd1 vccd1 sky130_fd_sc_hd__fill_2
XFILLER_0_106_243 vssd1 vssd1 vccd1 vccd1 sky130_fd_sc_hd__fill_2
XFILLER_0_63_196 vssd1 vssd1 vccd1 vccd1 sky130_fd_sc_hd__decap_3
XANTENNA__4112__D _4774_/B vssd1 vssd1 vccd1 vccd1 sky130_fd_sc_hd__diode_2
XANTENNA__4289__A1 _4432_/A vssd1 vssd1 vccd1 vccd1 sky130_fd_sc_hd__diode_2
XANTENNA__4782__D _4822_/B vssd1 vssd1 vccd1 vccd1 sky130_fd_sc_hd__diode_2
XFILLER_0_86_211 vssd1 vssd1 vccd1 vccd1 sky130_fd_sc_hd__fill_1
XANTENNA__4137__A _4614_/C vssd1 vssd1 vccd1 vccd1 sky130_fd_sc_hd__diode_2
XFILLER_0_24_33 vssd1 vssd1 vccd1 vccd1 sky130_fd_sc_hd__fill_1
XFILLER_0_115_57 vssd1 vssd1 vccd1 vccd1 sky130_fd_sc_hd__decap_4
XFILLER_0_74_406 vssd1 vssd1 vccd1 vccd1 sky130_fd_sc_hd__fill_1
XFILLER_0_24_44 vssd1 vssd1 vccd1 vccd1 sky130_fd_sc_hd__fill_2
XFILLER_0_24_77 vssd1 vssd1 vccd1 vccd1 sky130_fd_sc_hd__decap_4
X_3820_ _5049_/A _5071_/A _5064_/B _5049_/B vssd1 vssd1 vccd1 vccd1 _3821_/B sky130_fd_sc_hd__a22o_1
XANTENNA__3976__A _5049_/A vssd1 vssd1 vccd1 vccd1 sky130_fd_sc_hd__diode_2
X_3751_ _3751_/A _3751_/B vssd1 vssd1 vccd1 vccd1 _3833_/B sky130_fd_sc_hd__xor2_2
XFILLER_0_27_333 vssd1 vssd1 vccd1 vccd1 sky130_fd_sc_hd__decap_3
XFILLER_0_131_45 vssd1 vssd1 vccd1 vccd1 sky130_fd_sc_hd__fill_1
XFILLER_0_6_249 vssd1 vssd1 vccd1 vccd1 sky130_fd_sc_hd__decap_3
XANTENNA__4764__A2 _5656_/A vssd1 vssd1 vccd1 vccd1 sky130_fd_sc_hd__diode_2
XFILLER_0_54_141 vssd1 vssd1 vccd1 vccd1 sky130_fd_sc_hd__fill_2
X_6470_ hold191/X sstream_i[28] _6473_/S vssd1 vssd1 vccd1 vccd1 _6861_/D sky130_fd_sc_hd__mux2_1
X_3682_ _3667_/X _3670_/B _3999_/A _6686_/Q vssd1 vssd1 vccd1 vccd1 _3686_/A sky130_fd_sc_hd__o211ai_1
X_5421_ _5421_/A _5421_/B _5421_/C vssd1 vssd1 vccd1 vccd1 _5424_/C sky130_fd_sc_hd__nand3_1
XFILLER_0_40_98 vssd1 vssd1 vccd1 vccd1 sky130_fd_sc_hd__fill_2
XANTENNA__3724__B1 _5081_/D vssd1 vssd1 vccd1 vccd1 sky130_fd_sc_hd__diode_2
X_5352_ _5033_/B _5421_/B _5421_/C _5031_/X _5039_/B vssd1 vssd1 vccd1 vccd1 _5357_/A
+ sky130_fd_sc_hd__a311o_1
X_4303_ _4305_/A _4305_/B vssd1 vssd1 vccd1 vccd1 _4303_/Y sky130_fd_sc_hd__nand2b_1
XFILLER_0_10_244 vssd1 vssd1 vccd1 vccd1 sky130_fd_sc_hd__fill_2
XFILLER_0_10_222 vssd1 vssd1 vccd1 vccd1 sky130_fd_sc_hd__fill_2
XFILLER_0_49_52 vssd1 vssd1 vccd1 vccd1 sky130_fd_sc_hd__fill_2
X_5283_ _6652_/Q _5283_/B vssd1 vssd1 vccd1 vccd1 _5284_/B sky130_fd_sc_hd__xnor2_1
X_4234_ _4234_/A _4234_/B vssd1 vssd1 vccd1 vccd1 _4236_/B sky130_fd_sc_hd__xnor2_1
X_4165_ _4165_/A _4895_/B _4165_/C vssd1 vssd1 vccd1 vccd1 _4165_/X sky130_fd_sc_hd__and3_1
XFILLER_0_4_65 vssd1 vssd1 vccd1 vccd1 sky130_ef_sc_hd__decap_12
XFILLER_0_65_84 vssd1 vssd1 vccd1 vccd1 sky130_fd_sc_hd__fill_2
X_4096_ _5754_/B _6664_/Q _4095_/B _4092_/X vssd1 vssd1 vccd1 vccd1 _4101_/A sky130_fd_sc_hd__a31o_1
XFILLER_0_77_211 vssd1 vssd1 vccd1 vccd1 sky130_fd_sc_hd__fill_1
X_6806_ _6818_/CLK _6806_/D fanout150/X vssd1 vssd1 vccd1 vccd1 hold39/A sky130_fd_sc_hd__dfrtp_4
XFILLER_0_77_299 vssd1 vssd1 vccd1 vccd1 sky130_fd_sc_hd__fill_2
XFILLER_0_77_277 vssd1 vssd1 vccd1 vccd1 sky130_fd_sc_hd__decap_3
XFILLER_0_135_316 vssd1 vssd1 vccd1 vccd1 sky130_fd_sc_hd__decap_3
X_4998_ _5235_/A _4996_/X _4770_/X _4772_/Y vssd1 vssd1 vccd1 vccd1 _4998_/X sky130_fd_sc_hd__o211a_1
XFILLER_0_135_349 vssd1 vssd1 vccd1 vccd1 sky130_fd_sc_hd__decap_4
X_6737_ _6751_/CLK _6737_/D fanout140/X vssd1 vssd1 vccd1 vccd1 _6737_/Q sky130_fd_sc_hd__dfstp_1
X_3949_ _3949_/A _3949_/B _3949_/C vssd1 vssd1 vccd1 vccd1 _3956_/A sky130_fd_sc_hd__nand3_1
X_6668_ _6880_/CLK _6668_/D vssd1 vssd1 vccd1 vccd1 _6668_/Q sky130_fd_sc_hd__dfxtp_1
X_6599_ _6802_/CLK _6599_/D fanout150/X vssd1 vssd1 vccd1 vccd1 tex_mport_o[42] sky130_fd_sc_hd__dfrtp_4
X_5619_ tex_width_i[15] _3267_/Y _3268_/Y _5787_/A vssd1 vssd1 vccd1 vccd1 _5621_/C
+ sky130_fd_sc_hd__a22o_1
XFILLER_0_5_260 vssd1 vssd1 vccd1 vccd1 sky130_fd_sc_hd__fill_2
XFILLER_0_60_166 vssd1 vssd1 vccd1 vccd1 sky130_fd_sc_hd__fill_2
XFILLER_0_103_268 vssd1 vssd1 vccd1 vccd1 sky130_fd_sc_hd__fill_2
XFILLER_0_68_233 vssd1 vssd1 vccd1 vccd1 sky130_fd_sc_hd__fill_1
XFILLER_0_83_225 vssd1 vssd1 vccd1 vccd1 sky130_fd_sc_hd__fill_2
XANTENNA__4107__D _5049_/D vssd1 vssd1 vccd1 vccd1 sky130_fd_sc_hd__diode_2
XFILLER_0_138_176 vssd1 vssd1 vccd1 vccd1 sky130_fd_sc_hd__decap_3
XFILLER_0_138_165 vssd1 vssd1 vccd1 vccd1 sky130_fd_sc_hd__decap_3
XFILLER_0_138_187 vssd1 vssd1 vccd1 vccd1 sky130_fd_sc_hd__fill_2
XFILLER_0_83_269 vssd1 vssd1 vccd1 vccd1 sky130_fd_sc_hd__fill_1
Xfanout92 tex_width_i[6] vssd1 vssd1 vccd1 vccd1 _5049_/A sky130_fd_sc_hd__clkbuf_8
Xfanout81 tex_width_i[9] vssd1 vssd1 vccd1 vccd1 _5081_/C sky130_fd_sc_hd__clkbuf_4
XFILLER_0_36_141 vssd1 vssd1 vccd1 vccd1 sky130_fd_sc_hd__fill_1
Xfanout70 hold199/X vssd1 vssd1 vccd1 vccd1 _4971_/B sky130_fd_sc_hd__buf_4
XFILLER_0_51_111 vssd1 vssd1 vccd1 vccd1 sky130_fd_sc_hd__fill_1
XFILLER_0_51_177 vssd1 vssd1 vccd1 vccd1 sky130_fd_sc_hd__fill_1
XFILLER_0_51_188 vssd1 vssd1 vccd1 vccd1 sky130_fd_sc_hd__fill_1
XANTENNA__5459__B1 _5922_/S vssd1 vssd1 vccd1 vccd1 sky130_fd_sc_hd__diode_2
XANTENNA__6423__A2 hold70/A vssd1 vssd1 vccd1 vccd1 sky130_fd_sc_hd__diode_2
XFILLER_0_99_380 vssd1 vssd1 vccd1 vccd1 sky130_ef_sc_hd__decap_12
XANTENNA__4434__A1 _4789_/C vssd1 vssd1 vccd1 vccd1 sky130_fd_sc_hd__diode_2
XANTENNA__4434__B2 _4789_/B vssd1 vssd1 vccd1 vccd1 sky130_fd_sc_hd__diode_2
X_5970_ _5950_/X _5964_/X _5969_/X vssd1 vssd1 vccd1 vccd1 _6000_/S sky130_fd_sc_hd__a21oi_4
XFILLER_0_35_76 vssd1 vssd1 vccd1 vccd1 sky130_fd_sc_hd__fill_2
XFILLER_0_59_255 vssd1 vssd1 vccd1 vccd1 sky130_fd_sc_hd__decap_6
X_4921_ _4919_/A _4919_/Y _4889_/X _4891_/Y vssd1 vssd1 vccd1 vccd1 _4921_/X sky130_fd_sc_hd__a211o_1
X_4852_ _4852_/A _4852_/B _4852_/C vssd1 vssd1 vccd1 vccd1 _4855_/B sky130_fd_sc_hd__nand3_4
XFILLER_0_74_236 vssd1 vssd1 vccd1 vccd1 sky130_fd_sc_hd__fill_2
X_3803_ _3870_/A _5049_/D _5081_/C _5081_/D vssd1 vssd1 vccd1 vccd1 _3805_/C sky130_fd_sc_hd__nand4_2
XFILLER_0_51_31 vssd1 vssd1 vccd1 vccd1 sky130_fd_sc_hd__fill_1
XFILLER_0_117_349 vssd1 vssd1 vccd1 vccd1 sky130_fd_sc_hd__fill_2
XANTENNA__4314__B _4814_/D vssd1 vssd1 vccd1 vccd1 sky130_fd_sc_hd__diode_2
X_4783_ _4778_/X _4782_/X _4808_/B _4777_/X vssd1 vssd1 vccd1 vccd1 _4783_/X sky130_fd_sc_hd__o211a_1
X_6522_ _6834_/CLK _6522_/D vssd1 vssd1 vccd1 vccd1 _6522_/Q sky130_fd_sc_hd__dfxtp_1
X_3734_ _3755_/B _3734_/B vssd1 vssd1 vccd1 vccd1 _3735_/C sky130_fd_sc_hd__or2_1
X_6453_ hold123/X sstream_i[11] _6472_/S vssd1 vssd1 vccd1 vccd1 _6844_/D sky130_fd_sc_hd__mux2_1
XFILLER_0_82_291 vssd1 vssd1 vccd1 vccd1 sky130_fd_sc_hd__fill_2
X_3665_ _5327_/A _6687_/Q _6688_/Q _5290_/A vssd1 vssd1 vccd1 vccd1 _3669_/D sky130_fd_sc_hd__a22o_1
XFILLER_0_125_393 vssd1 vssd1 vccd1 vccd1 sky130_ef_sc_hd__decap_12
X_5404_ _5421_/C _5404_/B vssd1 vssd1 vccd1 vccd1 _5407_/B sky130_fd_sc_hd__and2_1
X_6384_ _6368_/S _6416_/B _6382_/X vssd1 vssd1 vccd1 vccd1 _6384_/X sky130_fd_sc_hd__o21a_1
X_3596_ _5081_/A _5277_/B _5118_/B _5308_/B vssd1 vssd1 vccd1 vccd1 _3597_/B sky130_fd_sc_hd__a22o_1
XANTENNA_fanout109_A _4638_/A vssd1 vssd1 vccd1 vccd1 sky130_fd_sc_hd__diode_2
XFILLER_0_2_285 vssd1 vssd1 vccd1 vccd1 sky130_fd_sc_hd__fill_2
X_5335_ _5336_/B _5336_/C _5336_/A vssd1 vssd1 vccd1 vccd1 _5594_/B sky130_fd_sc_hd__a21oi_2
XANTENNA__5860__S _5922_/S vssd1 vssd1 vccd1 vccd1 sky130_fd_sc_hd__diode_2
X_5266_ _5266_/A _5266_/B vssd1 vssd1 vccd1 vccd1 _5267_/B sky130_fd_sc_hd__and2_1
X_4217_ _4217_/A _4217_/B _4169_/X vssd1 vssd1 vccd1 vccd1 _4217_/Y sky130_fd_sc_hd__nor3b_4
XANTENNA__5799__C _5801_/A vssd1 vssd1 vccd1 vccd1 sky130_fd_sc_hd__diode_2
X_5197_ _5197_/A _5197_/B _5197_/C vssd1 vssd1 vccd1 vccd1 _5197_/Y sky130_fd_sc_hd__nand3_1
XFILLER_0_97_306 vssd1 vssd1 vccd1 vccd1 sky130_fd_sc_hd__fill_2
X_4148_ _4145_/X _4148_/B vssd1 vssd1 vccd1 vccd1 _4212_/B sky130_fd_sc_hd__and2b_1
XFILLER_0_92_60 vssd1 vssd1 vccd1 vccd1 sky130_fd_sc_hd__decap_3
X_4079_ _6635_/Q _4080_/B vssd1 vssd1 vccd1 vccd1 _4081_/A sky130_fd_sc_hd__and2_1
XFILLER_0_65_247 vssd1 vssd1 vccd1 vccd1 sky130_fd_sc_hd__fill_2
XFILLER_0_65_225 vssd1 vssd1 vccd1 vccd1 sky130_fd_sc_hd__fill_2
XFILLER_0_80_228 vssd1 vssd1 vccd1 vccd1 sky130_fd_sc_hd__fill_1
XFILLER_0_123_319 vssd1 vssd1 vccd1 vccd1 sky130_fd_sc_hd__fill_1
XANTENNA__4113__B1 _4774_/B vssd1 vssd1 vccd1 vccd1 sky130_fd_sc_hd__diode_2
XANTENNA__3467__A2 _5296_/B vssd1 vssd1 vccd1 vccd1 sky130_fd_sc_hd__diode_2
XANTENNA__5071__A _5071_/A vssd1 vssd1 vccd1 vccd1 sky130_fd_sc_hd__diode_2
XFILLER_0_88_317 vssd1 vssd1 vccd1 vccd1 sky130_fd_sc_hd__fill_2
XTAP_1240 vssd1 vccd1 sky130_fd_sc_hd__tapvpwrvgnd_1
XFILLER_0_96_361 vssd1 vssd1 vccd1 vccd1 sky130_fd_sc_hd__decap_3
XANTENNA__4967__A2 _4966_/B vssd1 vssd1 vccd1 vccd1 sky130_fd_sc_hd__diode_2
XTAP_1262 vssd1 vccd1 sky130_fd_sc_hd__tapvpwrvgnd_1
XTAP_1251 vssd1 vccd1 sky130_fd_sc_hd__tapvpwrvgnd_1
XFILLER_0_56_247 vssd1 vssd1 vccd1 vccd1 sky130_fd_sc_hd__fill_1
XFILLER_0_122_7 vssd1 vssd1 vccd1 vccd1 sky130_fd_sc_hd__fill_1
XFILLER_0_112_14 vssd1 vssd1 vccd1 vccd1 sky130_fd_sc_hd__decap_4
XFILLER_0_64_280 vssd1 vssd1 vccd1 vccd1 sky130_fd_sc_hd__fill_2
XFILLER_0_107_360 vssd1 vssd1 vccd1 vccd1 sky130_ef_sc_hd__decap_12
XFILLER_0_122_330 vssd1 vssd1 vccd1 vccd1 sky130_fd_sc_hd__fill_2
XFILLER_0_107_393 vssd1 vssd1 vccd1 vccd1 sky130_ef_sc_hd__decap_12
X_3450_ _3450_/A _3450_/B vssd1 vssd1 vccd1 vccd1 _3451_/C sky130_fd_sc_hd__or2_1
X_3381_ _3379_/X _3381_/B vssd1 vssd1 vccd1 vccd1 _3658_/A sky130_fd_sc_hd__nand2b_1
X_5120_ _5049_/D _5083_/B _3962_/A _3961_/D vssd1 vssd1 vccd1 vccd1 _5121_/C sky130_fd_sc_hd__a22o_1
X_5051_ _5051_/A _5051_/B _5051_/C _5051_/D vssd1 vssd1 vccd1 vccd1 _5054_/A sky130_fd_sc_hd__nand4_2
X_4002_ _6644_/Q _5206_/B vssd1 vssd1 vccd1 vccd1 _5207_/A sky130_fd_sc_hd__nand2_1
XANTENNA__5852__B1 _5882_/B vssd1 vssd1 vccd1 vccd1 sky130_fd_sc_hd__diode_2
XFILLER_0_94_309 vssd1 vssd1 vccd1 vccd1 sky130_fd_sc_hd__decap_4
XFILLER_0_1_55 vssd1 vssd1 vccd1 vccd1 sky130_fd_sc_hd__fill_1
X_5953_ _6867_/Q _3291_/Y _6866_/Q _5952_/B vssd1 vssd1 vccd1 vccd1 _5953_/X sky130_fd_sc_hd__a22o_1
XANTENNA__5080__A1 _4822_/B vssd1 vssd1 vccd1 vccd1 sky130_fd_sc_hd__diode_2
XFILLER_0_47_203 vssd1 vssd1 vccd1 vccd1 sky130_fd_sc_hd__fill_2
XANTENNA__4325__A _5701_/A vssd1 vssd1 vccd1 vccd1 sky130_fd_sc_hd__diode_2
X_4904_ _4902_/Y _4904_/B _4904_/C vssd1 vssd1 vccd1 vccd1 _4904_/Y sky130_fd_sc_hd__nand3b_4
X_5884_ tex_addr_i[24] tex_addr_i[25] _5882_/B vssd1 vssd1 vccd1 vccd1 _5884_/X sky130_fd_sc_hd__o21a_1
XFILLER_0_117_113 vssd1 vssd1 vccd1 vccd1 sky130_fd_sc_hd__fill_2
XANTENNA__4044__B _4774_/B vssd1 vssd1 vccd1 vccd1 sky130_fd_sc_hd__diode_2
XFILLER_0_7_333 vssd1 vssd1 vccd1 vccd1 sky130_fd_sc_hd__decap_3
XFILLER_0_7_311 vssd1 vssd1 vccd1 vccd1 sky130_fd_sc_hd__fill_2
XFILLER_0_7_300 vssd1 vssd1 vccd1 vccd1 sky130_fd_sc_hd__fill_1
X_4835_ _4835_/A _4835_/B _4835_/C vssd1 vssd1 vccd1 vccd1 _4847_/A sky130_fd_sc_hd__nand3_1
XFILLER_0_117_157 vssd1 vssd1 vccd1 vccd1 sky130_fd_sc_hd__fill_2
XFILLER_0_7_366 vssd1 vssd1 vccd1 vccd1 sky130_ef_sc_hd__decap_12
X_4766_ _4766_/A _4766_/B vssd1 vssd1 vccd1 vccd1 _4768_/B sky130_fd_sc_hd__xnor2_1
X_6505_ _6834_/CLK _6505_/D vssd1 vssd1 vccd1 vccd1 hold18/A sky130_fd_sc_hd__dfxtp_1
X_3717_ _3961_/A _5286_/A vssd1 vssd1 vccd1 vccd1 _3718_/B sky130_fd_sc_hd__and2_1
XFILLER_0_55_291 vssd1 vssd1 vccd1 vccd1 sky130_fd_sc_hd__fill_2
X_4697_ _4697_/A _4697_/B vssd1 vssd1 vccd1 vccd1 _5365_/B sky130_fd_sc_hd__nor2_1
XFILLER_0_70_272 vssd1 vssd1 vccd1 vccd1 sky130_fd_sc_hd__fill_2
X_6436_ depth_mport_o[50] _6440_/B _6434_/Y _6435_/X vssd1 vssd1 vccd1 vccd1 _6828_/D
+ sky130_fd_sc_hd__a22o_1
XANTENNA__4060__A _5701_/A vssd1 vssd1 vccd1 vccd1 sky130_fd_sc_hd__diode_2
X_3648_ _5083_/B _5273_/B _3352_/A _3350_/Y vssd1 vssd1 vccd1 vccd1 _3649_/B sky130_fd_sc_hd__o2bb2a_1
XFILLER_0_30_114 vssd1 vssd1 vccd1 vccd1 sky130_fd_sc_hd__decap_3
X_6367_ _6367_/A _6367_/B vssd1 vssd1 vccd1 vccd1 _6383_/A sky130_fd_sc_hd__and2_1
X_3579_ _3579_/A _3579_/B vssd1 vssd1 vccd1 vccd1 _3580_/C sky130_fd_sc_hd__xnor2_1
XFILLER_0_30_158 vssd1 vssd1 vccd1 vccd1 sky130_fd_sc_hd__decap_3
XFILLER_0_87_93 vssd1 vssd1 vccd1 vccd1 sky130_fd_sc_hd__fill_1
XFILLER_0_11_383 vssd1 vssd1 vccd1 vccd1 sky130_fd_sc_hd__decap_8
X_5318_ _5318_/A _5318_/B vssd1 vssd1 vccd1 vccd1 _5332_/A sky130_fd_sc_hd__xnor2_1
X_6298_ hold241/X _6440_/B _6300_/B vssd1 vssd1 vccd1 vccd1 _6298_/Y sky130_fd_sc_hd__o21ai_1
Xhold13 hold13/A vssd1 vssd1 vccd1 vccd1 hold13/X sky130_fd_sc_hd__dlygate4sd3_1
Xhold35 hold35/A vssd1 vssd1 vccd1 vccd1 hold35/X sky130_fd_sc_hd__dlygate4sd3_1
Xhold24 hold24/A vssd1 vssd1 vccd1 vccd1 hold24/X sky130_fd_sc_hd__dlygate4sd3_1
Xhold46 hold46/A vssd1 vssd1 vccd1 vccd1 hold46/X sky130_fd_sc_hd__dlygate4sd3_1
X_5249_ _5250_/B _5250_/C vssd1 vssd1 vccd1 vccd1 _5251_/B sky130_fd_sc_hd__nor2_1
XANTENNA__5843__A0 _5426_/X vssd1 vssd1 vccd1 vccd1 sky130_fd_sc_hd__diode_2
Xhold79 hold79/A vssd1 vssd1 vccd1 vccd1 hold79/X sky130_fd_sc_hd__dlygate4sd3_1
Xhold68 hold68/A vssd1 vssd1 vccd1 vccd1 hold68/X sky130_fd_sc_hd__dlygate4sd3_1
Xhold57 hold57/A vssd1 vssd1 vccd1 vccd1 hold57/X sky130_fd_sc_hd__dlygate4sd3_1
XFILLER_0_97_169 vssd1 vssd1 vccd1 vccd1 sky130_fd_sc_hd__decap_6
XANTENNA_fanout41_A _5064_/B vssd1 vssd1 vccd1 vccd1 sky130_fd_sc_hd__diode_2
XFILLER_0_123_116 vssd1 vssd1 vccd1 vccd1 sky130_fd_sc_hd__decap_4
XANTENNA__3385__A1 _5327_/A vssd1 vssd1 vccd1 vccd1 sky130_fd_sc_hd__diode_2
XFILLER_0_116_190 vssd1 vssd1 vccd1 vccd1 sky130_fd_sc_hd__decap_3
XANTENNA__3385__B2 _5290_/A vssd1 vssd1 vccd1 vccd1 sky130_fd_sc_hd__diode_2
XFILLER_0_104_363 vssd1 vssd1 vccd1 vccd1 sky130_fd_sc_hd__fill_1
XANTENNA_clkbuf_leaf_4_clk_i_A clkbuf_leaf_9_clk_i/A vssd1 vssd1 vccd1 vccd1 sky130_fd_sc_hd__diode_2
XFILLER_0_131_160 vssd1 vssd1 vccd1 vccd1 sky130_fd_sc_hd__fill_2
XFILLER_0_21_169 vssd1 vssd1 vccd1 vccd1 sky130_fd_sc_hd__fill_2
XTAP_309 vssd1 vccd1 sky130_fd_sc_hd__tapvpwrvgnd_1
XANTENNA__6344__B hold75/A vssd1 vssd1 vccd1 vccd1 sky130_fd_sc_hd__diode_2
XFILLER_0_76_309 vssd1 vssd1 vccd1 vccd1 sky130_fd_sc_hd__decap_3
XFILLER_0_84_320 vssd1 vssd1 vccd1 vccd1 sky130_fd_sc_hd__fill_2
XFILLER_0_29_225 vssd1 vssd1 vccd1 vccd1 sky130_fd_sc_hd__fill_2
XFILLER_0_123_57 vssd1 vssd1 vccd1 vccd1 sky130_fd_sc_hd__decap_4
XTAP_1092 vssd1 vccd1 sky130_fd_sc_hd__tapvpwrvgnd_1
XTAP_1081 vssd1 vccd1 sky130_fd_sc_hd__tapvpwrvgnd_1
XTAP_1070 vssd1 vccd1 sky130_fd_sc_hd__tapvpwrvgnd_1
XANTENNA__6011__A0 _5115_/D vssd1 vssd1 vccd1 vccd1 sky130_fd_sc_hd__diode_2
XFILLER_0_32_33 vssd1 vssd1 vccd1 vccd1 sky130_fd_sc_hd__fill_1
XANTENNA__6360__A _6440_/B vssd1 vssd1 vccd1 vccd1 sky130_fd_sc_hd__diode_2
XANTENNA__5675__S _5844_/S vssd1 vssd1 vccd1 vccd1 sky130_fd_sc_hd__diode_2
X_4620_ _4621_/B _4621_/A vssd1 vssd1 vccd1 vccd1 _4625_/B sky130_fd_sc_hd__nand2b_1
XFILLER_0_32_66 vssd1 vssd1 vccd1 vccd1 sky130_fd_sc_hd__fill_1
XFILLER_0_32_77 vssd1 vssd1 vccd1 vccd1 sky130_fd_sc_hd__fill_1
XFILLER_0_44_206 vssd1 vssd1 vccd1 vccd1 sky130_fd_sc_hd__fill_2
XFILLER_0_44_228 vssd1 vssd1 vccd1 vccd1 sky130_fd_sc_hd__decap_8
X_4551_ _5645_/A _5645_/B _4582_/D _4551_/D vssd1 vssd1 vccd1 vccd1 _4554_/A sky130_fd_sc_hd__nand4_1
X_4482_ _4482_/A _4482_/B _4482_/C vssd1 vssd1 vccd1 vccd1 _4494_/A sky130_fd_sc_hd__nand3_2
XFILLER_0_12_114 vssd1 vssd1 vccd1 vccd1 sky130_fd_sc_hd__decap_4
X_3502_ _3502_/A _3502_/B _3502_/C vssd1 vssd1 vccd1 vccd1 _5298_/S sky130_fd_sc_hd__or3_1
X_6221_ fb_i _6217_/B _6215_/Y vssd1 vssd1 vccd1 vccd1 _6221_/X sky130_fd_sc_hd__a21bo_1
XFILLER_0_122_160 vssd1 vssd1 vccd1 vccd1 sky130_fd_sc_hd__fill_2
X_3433_ _3433_/A _3450_/B vssd1 vssd1 vccd1 vccd1 _3444_/A sky130_fd_sc_hd__or2_1
X_6152_ _6152_/A _6152_/B _6152_/C vssd1 vssd1 vccd1 vccd1 _6152_/X sky130_fd_sc_hd__and3_1
XTAP_810 vssd1 vccd1 sky130_fd_sc_hd__tapvpwrvgnd_1
XTAP_843 vssd1 vccd1 sky130_fd_sc_hd__tapvpwrvgnd_1
XTAP_832 vssd1 vccd1 sky130_fd_sc_hd__tapvpwrvgnd_1
XTAP_821 vssd1 vccd1 sky130_fd_sc_hd__tapvpwrvgnd_1
X_3364_ _5311_/A _6686_/Q _3362_/Y _3440_/A vssd1 vssd1 vccd1 vccd1 _3366_/A sky130_fd_sc_hd__o2bb2a_1
XFILLER_0_20_180 vssd1 vssd1 vccd1 vccd1 sky130_fd_sc_hd__fill_2
X_5103_ _5101_/A _5101_/B _5100_/X _5102_/Y vssd1 vssd1 vccd1 vccd1 _5160_/A sky130_fd_sc_hd__a211o_1
X_3295_ _6863_/Q vssd1 vssd1 vccd1 vccd1 _3295_/Y sky130_fd_sc_hd__inv_2
X_6083_ _6622_/Q hold232/X _6098_/S vssd1 vssd1 vccd1 vccd1 _6083_/X sky130_fd_sc_hd__mux2_1
XTAP_876 vssd1 vccd1 sky130_fd_sc_hd__tapvpwrvgnd_1
XTAP_865 vssd1 vccd1 sky130_fd_sc_hd__tapvpwrvgnd_1
XTAP_854 vssd1 vccd1 sky130_fd_sc_hd__tapvpwrvgnd_1
XTAP_898 vssd1 vccd1 sky130_fd_sc_hd__tapvpwrvgnd_1
XTAP_887 vssd1 vccd1 sky130_fd_sc_hd__tapvpwrvgnd_1
X_5034_ _5034_/A vssd1 vssd1 vccd1 vccd1 _5421_/A sky130_fd_sc_hd__inv_2
XFILLER_0_18_3 vssd1 vssd1 vccd1 vccd1 sky130_ef_sc_hd__decap_12
XANTENNA__3878__B _5049_/B vssd1 vssd1 vccd1 vccd1 sky130_fd_sc_hd__diode_2
XFILLER_0_79_169 vssd1 vssd1 vccd1 vccd1 sky130_fd_sc_hd__fill_2
X_5936_ nrst_i _6803_/Q _6807_/Q vssd1 vssd1 vccd1 vccd1 _6061_/S sky130_fd_sc_hd__and3_4
X_5867_ _5867_/A _5867_/B vssd1 vssd1 vccd1 vccd1 _5867_/Y sky130_fd_sc_hd__nor2_1
XANTENNA__5585__S _5601_/S vssd1 vssd1 vccd1 vccd1 sky130_fd_sc_hd__diode_2
XFILLER_0_90_345 vssd1 vssd1 vccd1 vccd1 sky130_ef_sc_hd__decap_12
X_5798_ hold250/X _5797_/X _5844_/S vssd1 vssd1 vccd1 vccd1 _6635_/D sky130_fd_sc_hd__mux2_1
X_4818_ _4809_/X _4813_/X _4956_/B _4817_/X vssd1 vssd1 vccd1 vccd1 _4818_/X sky130_fd_sc_hd__o211a_1
XFILLER_0_90_389 vssd1 vssd1 vccd1 vccd1 sky130_ef_sc_hd__decap_12
XFILLER_0_7_185 vssd1 vssd1 vccd1 vccd1 sky130_fd_sc_hd__fill_1
X_4749_ _4748_/B _4748_/C _4748_/A vssd1 vssd1 vccd1 vccd1 _4750_/C sky130_fd_sc_hd__a21bo_1
X_6419_ depth_mport_o[48] _6333_/S _6427_/A _6418_/Y vssd1 vssd1 vccd1 vccd1 _6826_/D
+ sky130_fd_sc_hd__a22o_1
XANTENNA__4316__B1 _4658_/D vssd1 vssd1 vccd1 vccd1 sky130_fd_sc_hd__diode_2
XFILLER_0_3_391 vssd1 vssd1 vccd1 vccd1 sky130_fd_sc_hd__fill_1
XFILLER_0_101_366 vssd1 vssd1 vccd1 vccd1 sky130_ef_sc_hd__decap_12
XFILLER_0_85_117 vssd1 vssd1 vccd1 vccd1 sky130_fd_sc_hd__fill_1
XFILLER_0_128_208 vssd1 vssd1 vccd1 vccd1 sky130_fd_sc_hd__fill_2
XPHY_142 vssd1 vssd1 vccd1 vccd1 sky130_fd_sc_hd__decap_3
XPHY_131 vssd1 vssd1 vccd1 vccd1 sky130_fd_sc_hd__decap_3
XPHY_120 vssd1 vssd1 vccd1 vccd1 sky130_fd_sc_hd__decap_3
XFILLER_0_136_241 vssd1 vssd1 vccd1 vccd1 sky130_fd_sc_hd__fill_2
XPHY_175 vssd1 vssd1 vccd1 vccd1 sky130_fd_sc_hd__decap_3
XPHY_164 vssd1 vssd1 vccd1 vccd1 sky130_fd_sc_hd__decap_3
XPHY_153 vssd1 vssd1 vccd1 vccd1 sky130_fd_sc_hd__decap_3
XPHY_197 vssd1 vssd1 vccd1 vccd1 sky130_fd_sc_hd__decap_3
XPHY_186 vssd1 vssd1 vccd1 vccd1 sky130_fd_sc_hd__decap_3
XFILLER_0_78_29 vssd1 vssd1 vccd1 vccd1 sky130_fd_sc_hd__decap_4
XANTENNA__3530__B2 _3961_/A vssd1 vssd1 vccd1 vccd1 sky130_fd_sc_hd__diode_2
XFILLER_0_27_44 vssd1 vssd1 vccd1 vccd1 sky130_fd_sc_hd__fill_2
XANTENNA__3979__A _5051_/A vssd1 vssd1 vccd1 vccd1 sky130_fd_sc_hd__diode_2
XFILLER_0_76_106 vssd1 vssd1 vccd1 vccd1 sky130_fd_sc_hd__fill_2
XFILLER_0_43_21 vssd1 vssd1 vccd1 vccd1 sky130_fd_sc_hd__fill_1
X_6770_ _6792_/CLK _6770_/D fanout153/X vssd1 vssd1 vccd1 vccd1 pix_mport_o[42] sky130_fd_sc_hd__dfrtp_4
XPHY_0 vssd1 vssd1 vccd1 vccd1 sky130_fd_sc_hd__decap_3
X_3982_ _5091_/B _6683_/Q _5296_/B _5091_/A vssd1 vssd1 vccd1 vccd1 _3984_/A sky130_fd_sc_hd__a22oi_1
XFILLER_0_91_109 vssd1 vssd1 vccd1 vccd1 sky130_fd_sc_hd__decap_3
X_5721_ _5720_/Y _6514_/Q _5802_/B vssd1 vssd1 vccd1 vccd1 _5723_/B sky130_fd_sc_hd__mux2_1
XFILLER_0_57_331 vssd1 vssd1 vccd1 vccd1 sky130_fd_sc_hd__fill_2
XANTENNA__4025__D _4658_/D vssd1 vssd1 vccd1 vccd1 sky130_fd_sc_hd__diode_2
X_5652_ _5652_/A _5652_/B vssd1 vssd1 vccd1 vccd1 _5652_/Y sky130_fd_sc_hd__nand2_1
XFILLER_0_17_239 vssd1 vssd1 vccd1 vccd1 sky130_fd_sc_hd__fill_2
X_4603_ _4603_/A _4603_/B _4603_/C vssd1 vssd1 vccd1 vccd1 _4607_/A sky130_fd_sc_hd__and3_1
X_5583_ _5599_/A _5583_/B _5588_/C vssd1 vssd1 vccd1 vccd1 _5583_/X sky130_fd_sc_hd__and3_1
XFILLER_0_4_133 vssd1 vssd1 vccd1 vccd1 sky130_fd_sc_hd__decap_6
XFILLER_0_102_108 vssd1 vssd1 vccd1 vccd1 sky130_fd_sc_hd__fill_1
X_4534_ _6629_/Q _4534_/B vssd1 vssd1 vccd1 vccd1 _4536_/B sky130_fd_sc_hd__xnor2_1
XFILLER_0_25_294 vssd1 vssd1 vccd1 vccd1 sky130_fd_sc_hd__fill_2
XFILLER_0_40_253 vssd1 vssd1 vccd1 vccd1 sky130_fd_sc_hd__decap_8
XFILLER_0_110_141 vssd1 vssd1 vccd1 vccd1 sky130_fd_sc_hd__fill_2
X_4465_ _5718_/A _4688_/C _4841_/C _4816_/B vssd1 vssd1 vccd1 vccd1 _4484_/B sky130_fd_sc_hd__a22o_1
X_6204_ _6204_/A _6204_/B vssd1 vssd1 vccd1 vccd1 _6212_/A sky130_fd_sc_hd__or2_1
XFILLER_0_110_174 vssd1 vssd1 vccd1 vccd1 sky130_fd_sc_hd__fill_1
X_4396_ _4396_/A _4396_/B vssd1 vssd1 vccd1 vccd1 _4397_/C sky130_fd_sc_hd__xnor2_1
X_3416_ _5277_/A _5286_/A vssd1 vssd1 vccd1 vccd1 _3574_/B sky130_fd_sc_hd__nand2_1
XFILLER_0_0_361 vssd1 vssd1 vccd1 vccd1 sky130_fd_sc_hd__decap_3
X_6135_ hold61/X _6136_/B _6136_/C _6136_/D vssd1 vssd1 vccd1 vccd1 _6135_/X sky130_fd_sc_hd__a22o_1
X_3347_ _3353_/B _3353_/A vssd1 vssd1 vccd1 vccd1 _3393_/A sky130_fd_sc_hd__and2b_1
XTAP_640 vssd1 vccd1 sky130_fd_sc_hd__tapvpwrvgnd_1
XTAP_651 vssd1 vccd1 sky130_fd_sc_hd__tapvpwrvgnd_1
X_6066_ hold51/X _6549_/Q _6072_/S vssd1 vssd1 vccd1 vccd1 hold52/A sky130_fd_sc_hd__mux2_1
XTAP_662 vssd1 vccd1 sky130_fd_sc_hd__tapvpwrvgnd_1
XTAP_673 vssd1 vccd1 sky130_fd_sc_hd__tapvpwrvgnd_1
XTAP_684 vssd1 vccd1 sky130_fd_sc_hd__tapvpwrvgnd_1
XTAP_695 vssd1 vccd1 sky130_fd_sc_hd__tapvpwrvgnd_1
XFILLER_0_84_72 vssd1 vssd1 vccd1 vccd1 sky130_fd_sc_hd__fill_2
X_5017_ _5018_/A _5018_/B _5018_/C vssd1 vssd1 vccd1 vccd1 _5017_/X sky130_fd_sc_hd__and3_1
X_3278_ tex_height_i[15] vssd1 vssd1 vccd1 vccd1 _3278_/Y sky130_fd_sc_hd__inv_2
X_6968_ vssd1 vssd1 vccd1 vccd1 _6968_/HI tex_mport_o[21] sky130_fd_sc_hd__conb_1
X_6899_ vssd1 vssd1 vccd1 vccd1 _6899_/HI depth_mport_o[58] sky130_fd_sc_hd__conb_1
X_5919_ tex_addr_i[31] _5919_/B vssd1 vssd1 vccd1 vccd1 _5921_/A sky130_fd_sc_hd__xor2_1
XFILLER_0_48_386 vssd1 vssd1 vccd1 vccd1 sky130_ef_sc_hd__decap_12
XFILLER_0_63_323 vssd1 vssd1 vccd1 vccd1 sky130_fd_sc_hd__decap_3
XFILLER_0_90_175 vssd1 vssd1 vccd1 vccd1 sky130_fd_sc_hd__fill_2
XANTENNA__6770__RESET_B fanout153/X vssd1 vssd1 vccd1 vccd1 sky130_fd_sc_hd__diode_2
XFILLER_0_90_197 vssd1 vssd1 vccd1 vccd1 sky130_fd_sc_hd__fill_2
XFILLER_0_16_261 vssd1 vssd1 vccd1 vccd1 sky130_fd_sc_hd__decap_4
XFILLER_0_16_283 vssd1 vssd1 vccd1 vccd1 sky130_fd_sc_hd__fill_2
XFILLER_0_7_3 vssd1 vssd1 vccd1 vccd1 sky130_ef_sc_hd__decap_12
XFILLER_0_98_231 vssd1 vssd1 vccd1 vccd1 sky130_fd_sc_hd__fill_2
XFILLER_0_98_253 vssd1 vssd1 vccd1 vccd1 sky130_fd_sc_hd__fill_2
XFILLER_0_98_242 vssd1 vssd1 vccd1 vccd1 sky130_fd_sc_hd__fill_2
XFILLER_0_58_139 vssd1 vssd1 vccd1 vccd1 sky130_fd_sc_hd__fill_1
XFILLER_0_39_342 vssd1 vssd1 vccd1 vccd1 sky130_fd_sc_hd__decap_3
XFILLER_0_39_353 vssd1 vssd1 vccd1 vccd1 sky130_fd_sc_hd__fill_2
XFILLER_0_13_57 vssd1 vssd1 vccd1 vccd1 sky130_ef_sc_hd__decap_12
XFILLER_0_124_200 vssd1 vssd1 vccd1 vccd1 sky130_fd_sc_hd__fill_1
XFILLER_0_66_194 vssd1 vssd1 vccd1 vccd1 sky130_fd_sc_hd__fill_2
XFILLER_0_1_125 vssd1 vssd1 vccd1 vccd1 sky130_fd_sc_hd__decap_8
XFILLER_0_22_242 vssd1 vssd1 vccd1 vccd1 sky130_fd_sc_hd__decap_4
XFILLER_0_22_253 vssd1 vssd1 vccd1 vccd1 sky130_fd_sc_hd__fill_2
XFILLER_0_1_147 vssd1 vssd1 vccd1 vccd1 sky130_fd_sc_hd__fill_2
XFILLER_0_129_23 vssd1 vssd1 vccd1 vccd1 sky130_fd_sc_hd__decap_3
X_4250_ _4250_/A _4250_/B vssd1 vssd1 vccd1 vccd1 _4305_/A sky130_fd_sc_hd__xnor2_4
XANTENNA__3886__A2_N _5286_/B vssd1 vssd1 vccd1 vccd1 sky130_fd_sc_hd__diode_2
X_4181_ _4181_/A _4181_/B vssd1 vssd1 vccd1 vccd1 _4205_/A sky130_fd_sc_hd__xor2_1
XFILLER_0_38_65 vssd1 vssd1 vccd1 vccd1 sky130_fd_sc_hd__fill_2
XANTENNA__3806__A2 _5754_/B vssd1 vssd1 vccd1 vccd1 sky130_fd_sc_hd__diode_2
XFILLER_0_89_264 vssd1 vssd1 vccd1 vccd1 sky130_fd_sc_hd__decap_8
XFILLER_0_89_253 vssd1 vssd1 vccd1 vccd1 sky130_fd_sc_hd__fill_1
X_6822_ _6827_/CLK _6822_/D fanout151/X vssd1 vssd1 vccd1 vccd1 depth_mport_o[44]
+ sky130_fd_sc_hd__dfrtp_4
XANTENNA__5008__A1 _4794_/B vssd1 vssd1 vccd1 vccd1 sky130_fd_sc_hd__diode_2
XFILLER_0_54_97 vssd1 vssd1 vccd1 vccd1 sky130_fd_sc_hd__fill_2
XFILLER_0_9_225 vssd1 vssd1 vccd1 vccd1 sky130_fd_sc_hd__fill_1
X_6753_ _6864_/CLK _6753_/D _5468_/A vssd1 vssd1 vccd1 vccd1 pix_mport_o[1] sky130_fd_sc_hd__dfrtp_4
X_3965_ _3870_/A _5083_/B _3870_/C _3870_/D vssd1 vssd1 vccd1 vccd1 _3966_/C sky130_fd_sc_hd__a22o_1
XANTENNA__4333__A _4789_/B vssd1 vssd1 vccd1 vccd1 sky130_fd_sc_hd__diode_2
X_5704_ tex_addr_i[6] _5704_/B vssd1 vssd1 vccd1 vccd1 _5704_/X sky130_fd_sc_hd__xor2_2
XFILLER_0_72_131 vssd1 vssd1 vccd1 vccd1 sky130_fd_sc_hd__fill_1
XFILLER_0_70_85 vssd1 vssd1 vccd1 vccd1 sky130_fd_sc_hd__fill_2
XANTENNA__6024__S _6037_/S vssd1 vssd1 vccd1 vccd1 sky130_fd_sc_hd__diode_2
X_6684_ _6684_/CLK _6684_/D vssd1 vssd1 vccd1 vccd1 _6684_/Q sky130_fd_sc_hd__dfxtp_2
X_3896_ _3885_/X _3888_/B _5106_/A _6683_/Q vssd1 vssd1 vccd1 vccd1 _3900_/A sky130_fd_sc_hd__o211ai_1
X_5635_ hold31/A _6524_/Q hold25/A _6522_/Q vssd1 vssd1 vccd1 vccd1 _5636_/D sky130_fd_sc_hd__or4_1
XANTENNA_fanout139_A fanout140/X vssd1 vssd1 vccd1 vccd1 sky130_fd_sc_hd__diode_2
XFILLER_0_115_266 vssd1 vssd1 vccd1 vccd1 sky130_fd_sc_hd__fill_1
XFILLER_0_45_389 vssd1 vssd1 vccd1 vccd1 sky130_fd_sc_hd__decap_3
XFILLER_0_60_337 vssd1 vssd1 vccd1 vccd1 sky130_fd_sc_hd__fill_2
Xhold110 _6653_/Q vssd1 vssd1 vccd1 vccd1 hold110/X sky130_fd_sc_hd__dlygate4sd3_1
X_5566_ tex_mport_o[35] _5576_/S _5565_/X vssd1 vssd1 vccd1 vccd1 _6592_/D sky130_fd_sc_hd__a21o_1
Xhold143 _6851_/Q vssd1 vssd1 vccd1 vccd1 hold143/X sky130_fd_sc_hd__dlygate4sd3_1
X_5497_ hold37/X sstream_i[88] _6450_/S vssd1 vssd1 vccd1 vccd1 _6530_/D sky130_fd_sc_hd__mux2_1
X_4517_ _4789_/C _4551_/D _4518_/D _4789_/B vssd1 vssd1 vccd1 vccd1 _4519_/A sky130_fd_sc_hd__a22oi_2
XFILLER_0_79_94 vssd1 vssd1 vccd1 vccd1 sky130_fd_sc_hd__fill_2
XFILLER_0_13_275 vssd1 vssd1 vccd1 vccd1 sky130_fd_sc_hd__fill_2
Xhold132 _6692_/Q vssd1 vssd1 vccd1 vccd1 hold132/X sky130_fd_sc_hd__dlygate4sd3_1
Xhold121 _6866_/Q vssd1 vssd1 vccd1 vccd1 hold121/X sky130_fd_sc_hd__dlygate4sd3_1
X_4448_ _4488_/A _4518_/D _4446_/A _4492_/A vssd1 vssd1 vccd1 vccd1 _4454_/A sky130_fd_sc_hd__a31o_1
Xhold165 _6514_/Q vssd1 vssd1 vccd1 vccd1 hold165/X sky130_fd_sc_hd__dlygate4sd3_1
Xhold154 _6687_/Q vssd1 vssd1 vccd1 vccd1 hold154/X sky130_fd_sc_hd__dlygate4sd3_1
Xhold176 _6111_/X vssd1 vssd1 vccd1 vccd1 _6749_/D sky130_fd_sc_hd__dlygate4sd3_1
Xhold187 _6113_/X vssd1 vssd1 vccd1 vccd1 _6751_/D sky130_fd_sc_hd__dlygate4sd3_1
Xhold198 _6878_/Q vssd1 vssd1 vccd1 vccd1 hold198/X sky130_fd_sc_hd__dlygate4sd3_1
X_4379_ _4432_/A _4476_/D vssd1 vssd1 vccd1 vccd1 _4383_/A sky130_fd_sc_hd__nand2_1
XFILLER_0_0_191 vssd1 vssd1 vccd1 vccd1 sky130_fd_sc_hd__decap_3
X_6118_ hold3/X pix_mport_o[2] _6223_/B vssd1 vssd1 vccd1 vccd1 _6754_/D sky130_fd_sc_hd__mux2_1
XTAP_470 vssd1 vccd1 sky130_fd_sc_hd__tapvpwrvgnd_1
XTAP_481 vssd1 vccd1 sky130_fd_sc_hd__tapvpwrvgnd_1
XTAP_492 vssd1 vccd1 sky130_fd_sc_hd__tapvpwrvgnd_1
X_6049_ hold208/X _6038_/B _6054_/B1 vssd1 vssd1 vccd1 vccd1 _6688_/D sky130_fd_sc_hd__a21o_1
XANTENNA__4470__A2 _4527_/B vssd1 vssd1 vccd1 vccd1 sky130_fd_sc_hd__diode_2
XFILLER_0_48_161 vssd1 vssd1 vccd1 vccd1 sky130_fd_sc_hd__fill_2
XFILLER_0_63_120 vssd1 vssd1 vccd1 vccd1 sky130_fd_sc_hd__fill_1
XANTENNA__3785__C _4966_/B vssd1 vssd1 vccd1 vccd1 sky130_fd_sc_hd__diode_2
XFILLER_0_48_194 vssd1 vssd1 vccd1 vccd1 sky130_fd_sc_hd__fill_2
XFILLER_0_63_164 vssd1 vssd1 vccd1 vccd1 sky130_fd_sc_hd__fill_2
XFILLER_0_8_280 vssd1 vssd1 vccd1 vccd1 sky130_fd_sc_hd__fill_2
XFILLER_0_51_304 vssd1 vssd1 vccd1 vccd1 sky130_fd_sc_hd__fill_1
XANTENNA__4289__A2 _4774_/B vssd1 vssd1 vccd1 vccd1 sky130_fd_sc_hd__diode_2
XANTENNA__4137__B _4822_/B vssd1 vssd1 vccd1 vccd1 sky130_fd_sc_hd__diode_2
XFILLER_0_86_234 vssd1 vssd1 vccd1 vccd1 sky130_fd_sc_hd__fill_2
XANTENNA__3976__B _5049_/B vssd1 vssd1 vccd1 vccd1 sky130_fd_sc_hd__diode_2
XFILLER_0_39_161 vssd1 vssd1 vccd1 vccd1 sky130_fd_sc_hd__fill_2
XFILLER_0_131_24 vssd1 vssd1 vccd1 vccd1 sky130_fd_sc_hd__fill_2
XANTENNA__4153__A _5083_/A vssd1 vssd1 vccd1 vccd1 sky130_fd_sc_hd__diode_2
X_3750_ _3750_/A _3750_/B vssd1 vssd1 vccd1 vccd1 _3833_/A sky130_fd_sc_hd__or2_2
XFILLER_0_27_345 vssd1 vssd1 vccd1 vccd1 sky130_fd_sc_hd__fill_2
XANTENNA__6621__RESET_B fanout145/X vssd1 vssd1 vccd1 vccd1 sky130_fd_sc_hd__diode_2
XANTENNA__6640__SET_B _5937_/A vssd1 vssd1 vccd1 vccd1 sky130_fd_sc_hd__diode_2
X_3681_ _3612_/Y _3624_/X _3678_/A _3678_/Y vssd1 vssd1 vccd1 vccd1 _3694_/B sky130_fd_sc_hd__o211a_1
XFILLER_0_54_175 vssd1 vssd1 vccd1 vccd1 sky130_fd_sc_hd__decap_4
XFILLER_0_54_197 vssd1 vssd1 vccd1 vccd1 sky130_fd_sc_hd__fill_2
X_5420_ _5421_/B _5421_/C _5421_/A vssd1 vssd1 vccd1 vccd1 _5424_/B sky130_fd_sc_hd__a21o_1
X_5351_ _4714_/Y _4715_/Y _5038_/X vssd1 vssd1 vccd1 vccd1 _5421_/C sky130_fd_sc_hd__a21bo_1
XANTENNA__3724__A1 _4944_/B vssd1 vssd1 vccd1 vccd1 sky130_fd_sc_hd__diode_2
X_4302_ _4301_/A _4302_/B vssd1 vssd1 vccd1 vccd1 _4305_/B sky130_fd_sc_hd__nand2b_2
X_5282_ _6651_/Q _3454_/B _3453_/A vssd1 vssd1 vccd1 vccd1 _5283_/B sky130_fd_sc_hd__a21oi_1
XFILLER_0_10_212 vssd1 vssd1 vccd1 vccd1 sky130_fd_sc_hd__fill_1
XFILLER_0_49_64 vssd1 vssd1 vccd1 vccd1 sky130_fd_sc_hd__fill_2
X_4233_ _4222_/A _4222_/B _4222_/C vssd1 vssd1 vccd1 vccd1 _4237_/B sky130_fd_sc_hd__a21oi_1
Xclkbuf_2_3__f_clk_i clkbuf_0_clk_i/X vssd1 vssd1 vccd1 vccd1 clkbuf_2_3__f_clk_i/X
+ sky130_fd_sc_hd__clkbuf_16
X_4164_ _4895_/A _4163_/C _4163_/A vssd1 vssd1 vccd1 vccd1 _4165_/C sky130_fd_sc_hd__a21o_1
X_4095_ _4092_/X _4095_/B vssd1 vssd1 vccd1 vccd1 _4234_/B sky130_fd_sc_hd__and2b_1
XFILLER_0_4_77 vssd1 vssd1 vccd1 vccd1 sky130_fd_sc_hd__decap_6
XANTENNA__6019__S _6037_/S vssd1 vssd1 vccd1 vccd1 sky130_fd_sc_hd__diode_2
XANTENNA__3660__B1 _5272_/B vssd1 vssd1 vccd1 vccd1 sky130_fd_sc_hd__diode_2
X_6805_ _6863_/CLK _6805_/D _6073_/A vssd1 vssd1 vccd1 vccd1 _6805_/Q sky130_fd_sc_hd__dfrtp_4
XFILLER_0_77_289 vssd1 vssd1 vccd1 vccd1 sky130_fd_sc_hd__decap_3
X_6736_ _6751_/CLK _6736_/D fanout140/X vssd1 vssd1 vccd1 vccd1 _6736_/Q sky130_fd_sc_hd__dfstp_1
XFILLER_0_45_120 vssd1 vssd1 vccd1 vccd1 sky130_fd_sc_hd__decap_3
X_4997_ _4770_/X _4772_/Y _5235_/A _4996_/X vssd1 vssd1 vccd1 vccd1 _5235_/B sky130_fd_sc_hd__a211oi_2
XFILLER_0_135_328 vssd1 vssd1 vccd1 vccd1 sky130_fd_sc_hd__decap_8
XFILLER_0_18_345 vssd1 vssd1 vccd1 vccd1 sky130_fd_sc_hd__fill_1
XANTENNA__3963__A1 _5081_/A vssd1 vssd1 vccd1 vccd1 sky130_fd_sc_hd__diode_2
X_3948_ _3947_/B _3947_/C _3947_/A vssd1 vssd1 vccd1 vccd1 _3949_/C sky130_fd_sc_hd__a21bo_1
X_3879_ _5049_/B _5071_/A _5051_/B _5049_/A vssd1 vssd1 vccd1 vccd1 _3880_/D sky130_fd_sc_hd__a22o_1
X_6667_ _6880_/CLK _6667_/D vssd1 vssd1 vccd1 vccd1 _6667_/Q sky130_fd_sc_hd__dfxtp_1
XANTENNA__5593__S _5601_/S vssd1 vssd1 vccd1 vccd1 sky130_fd_sc_hd__diode_2
XFILLER_0_60_123 vssd1 vssd1 vccd1 vccd1 sky130_fd_sc_hd__fill_1
X_6598_ _6802_/CLK _6598_/D fanout142/X vssd1 vssd1 vccd1 vccd1 tex_mport_o[41] sky130_fd_sc_hd__dfrtp_4
X_5618_ _5787_/A _3268_/Y _3269_/Y _5787_/B vssd1 vssd1 vccd1 vccd1 _5621_/B sky130_fd_sc_hd__o22ai_1
XFILLER_0_33_348 vssd1 vssd1 vccd1 vccd1 sky130_fd_sc_hd__fill_2
X_5549_ depth_mport_o[24] hold117/X _5556_/S vssd1 vssd1 vccd1 vccd1 _6580_/D sky130_fd_sc_hd__mux2_1
XFILLER_0_103_258 vssd1 vssd1 vccd1 vccd1 sky130_fd_sc_hd__fill_1
XFILLER_0_60_189 vssd1 vssd1 vccd1 vccd1 sky130_fd_sc_hd__fill_2
XANTENNA_fanout71_A _4842_/A vssd1 vssd1 vccd1 vccd1 sky130_fd_sc_hd__diode_2
XFILLER_0_68_278 vssd1 vssd1 vccd1 vccd1 sky130_fd_sc_hd__decap_8
XANTENNA__3796__B _5754_/B vssd1 vssd1 vccd1 vccd1 sky130_fd_sc_hd__diode_2
Xfanout82 _4958_/B vssd1 vssd1 vccd1 vccd1 _5732_/A sky130_fd_sc_hd__buf_4
Xfanout71 _4842_/A vssd1 vssd1 vccd1 vccd1 _4614_/C sky130_fd_sc_hd__buf_4
Xfanout60 hold295/X vssd1 vssd1 vccd1 vccd1 _5115_/D sky130_fd_sc_hd__clkbuf_8
XFILLER_0_119_391 vssd1 vssd1 vccd1 vccd1 sky130_fd_sc_hd__fill_1
Xfanout93 tex_width_i[6] vssd1 vssd1 vccd1 vccd1 _5306_/A sky130_fd_sc_hd__buf_2
XFILLER_0_24_326 vssd1 vssd1 vccd1 vccd1 sky130_fd_sc_hd__decap_8
XFILLER_0_24_337 vssd1 vssd1 vccd1 vccd1 sky130_fd_sc_hd__fill_2
XFILLER_0_36_164 vssd1 vssd1 vccd1 vccd1 sky130_fd_sc_hd__fill_2
XFILLER_0_101_38 vssd1 vssd1 vccd1 vccd1 sky130_fd_sc_hd__fill_1
XFILLER_0_19_45 vssd1 vssd1 vccd1 vccd1 sky130_fd_sc_hd__fill_2
XFILLER_0_19_89 vssd1 vssd1 vccd1 vccd1 sky130_fd_sc_hd__fill_1
XANTENNA__4434__A2 _4476_/D vssd1 vssd1 vccd1 vccd1 sky130_fd_sc_hd__diode_2
XANTENNA__6363__A hold98/A vssd1 vssd1 vccd1 vccd1 sky130_fd_sc_hd__diode_2
XFILLER_0_35_88 vssd1 vssd1 vccd1 vccd1 sky130_fd_sc_hd__decap_3
XFILLER_0_35_99 vssd1 vssd1 vccd1 vccd1 sky130_fd_sc_hd__decap_4
XFILLER_0_59_234 vssd1 vssd1 vccd1 vccd1 sky130_fd_sc_hd__fill_1
X_4920_ _4919_/A _4919_/Y _4889_/X _4891_/Y vssd1 vssd1 vccd1 vccd1 _4924_/A sky130_fd_sc_hd__a211oi_1
X_4851_ _4850_/B _4850_/C _4850_/A vssd1 vssd1 vccd1 vccd1 _4852_/C sky130_fd_sc_hd__a21bo_1
X_3802_ _3870_/A _3961_/A _5081_/C _5081_/D vssd1 vssd1 vccd1 vccd1 _3813_/A sky130_fd_sc_hd__and4_1
XFILLER_0_129_199 vssd1 vssd1 vccd1 vccd1 sky130_fd_sc_hd__fill_2
XFILLER_0_51_65 vssd1 vssd1 vccd1 vccd1 sky130_fd_sc_hd__decap_3
X_4782_ _4778_/X _4782_/B _4970_/B _4822_/B vssd1 vssd1 vccd1 vccd1 _4782_/X sky130_fd_sc_hd__and4b_1
X_6521_ _6834_/CLK _6521_/D vssd1 vssd1 vccd1 vccd1 _6521_/Q sky130_fd_sc_hd__dfxtp_1
X_3733_ _3733_/A _3733_/B _3733_/C vssd1 vssd1 vccd1 vccd1 _3734_/B sky130_fd_sc_hd__nor3_1
XFILLER_0_27_186 vssd1 vssd1 vccd1 vccd1 sky130_fd_sc_hd__fill_2
X_6452_ hold120/X sstream_i[10] _6465_/S vssd1 vssd1 vccd1 vccd1 _6843_/D sky130_fd_sc_hd__mux2_1
XANTENNA__6302__S _6319_/S vssd1 vssd1 vccd1 vccd1 sky130_fd_sc_hd__diode_2
XFILLER_0_15_348 vssd1 vssd1 vccd1 vccd1 sky130_fd_sc_hd__fill_2
X_3664_ _3671_/A _3671_/B vssd1 vssd1 vccd1 vccd1 _3664_/X sky130_fd_sc_hd__and2b_1
X_5403_ _5396_/A _4714_/B _5038_/X _4368_/X vssd1 vssd1 vccd1 vccd1 _5404_/B sky130_fd_sc_hd__a211o_1
XFILLER_0_2_231 vssd1 vssd1 vccd1 vccd1 sky130_fd_sc_hd__fill_2
X_6383_ _6383_/A _6383_/B vssd1 vssd1 vccd1 vccd1 _6416_/B sky130_fd_sc_hd__nand2_1
XFILLER_0_2_253 vssd1 vssd1 vccd1 vccd1 sky130_fd_sc_hd__decap_3
X_3595_ _5081_/A _5308_/B _5277_/B _5118_/B vssd1 vssd1 vccd1 vccd1 _3595_/X sky130_fd_sc_hd__and4_1
X_5334_ _5334_/A _5334_/B vssd1 vssd1 vccd1 vccd1 _5457_/B sky130_fd_sc_hd__xnor2_4
X_5265_ _4024_/B _5265_/B vssd1 vssd1 vccd1 vccd1 _5441_/C sky130_fd_sc_hd__and2b_1
X_4216_ _4205_/Y _4206_/X _4211_/Y _4214_/X vssd1 vssd1 vccd1 vccd1 _4217_/B sky130_fd_sc_hd__a211oi_2
X_5196_ _5197_/A _5197_/B _5197_/C vssd1 vssd1 vccd1 vccd1 _5196_/X sky130_fd_sc_hd__and3_1
X_4147_ _4170_/B _4144_/X _4136_/X _4140_/X vssd1 vssd1 vccd1 vccd1 _4148_/B sky130_fd_sc_hd__a211o_1
XANTENNA__5870__A1 _5807_/B vssd1 vssd1 vccd1 vccd1 sky130_fd_sc_hd__diode_2
X_4078_ _4078_/A _4078_/B vssd1 vssd1 vccd1 vccd1 _4080_/B sky130_fd_sc_hd__xnor2_1
XFILLER_0_108_306 vssd1 vssd1 vccd1 vccd1 sky130_fd_sc_hd__fill_2
XFILLER_0_65_237 vssd1 vssd1 vccd1 vccd1 sky130_fd_sc_hd__decap_3
XFILLER_0_80_207 vssd1 vssd1 vccd1 vccd1 sky130_fd_sc_hd__fill_2
XFILLER_0_18_131 vssd1 vssd1 vccd1 vccd1 sky130_fd_sc_hd__fill_1
XFILLER_0_135_169 vssd1 vssd1 vccd1 vccd1 sky130_fd_sc_hd__fill_2
X_6719_ _6853_/CLK _6719_/D vssd1 vssd1 vccd1 vccd1 hold16/A sky130_fd_sc_hd__dfxtp_1
XFILLER_0_73_281 vssd1 vssd1 vccd1 vccd1 sky130_fd_sc_hd__fill_2
XANTENNA_hold216_A _6876_/Q vssd1 vssd1 vccd1 vccd1 sky130_fd_sc_hd__diode_2
XFILLER_0_116_372 vssd1 vssd1 vccd1 vccd1 sky130_ef_sc_hd__decap_12
XFILLER_0_33_123 vssd1 vssd1 vccd1 vccd1 sky130_fd_sc_hd__fill_2
XANTENNA__4113__B2 _5687_/A vssd1 vssd1 vccd1 vccd1 sky130_fd_sc_hd__diode_2
XANTENNA__5071__B _5106_/A vssd1 vssd1 vccd1 vccd1 sky130_fd_sc_hd__diode_2
XFILLER_0_88_307 vssd1 vssd1 vccd1 vccd1 sky130_fd_sc_hd__fill_1
XANTENNA_clkbuf_leaf_0_clk_i_A clkbuf_leaf_1_clk_i/A vssd1 vssd1 vccd1 vccd1 sky130_fd_sc_hd__diode_2
XTAP_1241 vssd1 vccd1 sky130_fd_sc_hd__tapvpwrvgnd_1
XTAP_1230 vssd1 vccd1 sky130_fd_sc_hd__tapvpwrvgnd_1
XTAP_1263 vssd1 vccd1 sky130_fd_sc_hd__tapvpwrvgnd_1
XTAP_1252 vssd1 vccd1 sky130_fd_sc_hd__tapvpwrvgnd_1
XFILLER_0_56_237 vssd1 vssd1 vccd1 vccd1 sky130_fd_sc_hd__fill_2
XANTENNA__6122__S _6223_/B vssd1 vssd1 vccd1 vccd1 sky130_fd_sc_hd__diode_2
XFILLER_0_114_309 vssd1 vssd1 vccd1 vccd1 sky130_fd_sc_hd__fill_2
XFILLER_0_107_372 vssd1 vssd1 vccd1 vccd1 sky130_ef_sc_hd__decap_12
XFILLER_0_21_57 vssd1 vssd1 vccd1 vccd1 sky130_fd_sc_hd__fill_1
XFILLER_0_21_79 vssd1 vssd1 vccd1 vccd1 sky130_fd_sc_hd__fill_2
XFILLER_0_24_167 vssd1 vssd1 vccd1 vccd1 sky130_fd_sc_hd__fill_2
X_3380_ _5306_/A _5272_/B _5286_/B _5292_/A vssd1 vssd1 vccd1 vccd1 _3381_/B sky130_fd_sc_hd__a22o_1
X_5050_ _5049_/B _6677_/Q _6676_/Q _5049_/A vssd1 vssd1 vccd1 vccd1 _5051_/D sky130_fd_sc_hd__a22o_1
X_4001_ _4001_/A _4001_/B vssd1 vssd1 vccd1 vccd1 _5206_/B sky130_fd_sc_hd__xnor2_1
XFILLER_0_46_21 vssd1 vssd1 vccd1 vccd1 sky130_fd_sc_hd__decap_4
XFILLER_0_46_54 vssd1 vssd1 vccd1 vccd1 sky130_fd_sc_hd__fill_2
XANTENNA__5604__A1 _5718_/B vssd1 vssd1 vccd1 vccd1 sky130_fd_sc_hd__diode_2
XANTENNA__5604__B2 _4942_/A vssd1 vssd1 vccd1 vccd1 sky130_fd_sc_hd__diode_2
X_5952_ _6866_/Q _5952_/B vssd1 vssd1 vccd1 vccd1 _5952_/X sky130_fd_sc_hd__or2_1
XFILLER_0_87_362 vssd1 vssd1 vccd1 vccd1 sky130_fd_sc_hd__fill_2
X_4903_ _4879_/X _4893_/Y _4205_/B _4205_/Y vssd1 vssd1 vccd1 vccd1 _4904_/B sky130_fd_sc_hd__o211ai_4
XANTENNA__5080__A2 _5115_/D vssd1 vssd1 vccd1 vccd1 sky130_fd_sc_hd__diode_2
X_5883_ _5883_/A _5883_/B vssd1 vssd1 vccd1 vccd1 _5887_/A sky130_fd_sc_hd__nand2_1
XFILLER_0_47_237 vssd1 vssd1 vccd1 vccd1 sky130_fd_sc_hd__fill_1
X_4834_ _4842_/A _4832_/C _4841_/D tex_width_i[15] vssd1 vssd1 vccd1 vccd1 _4835_/C
+ sky130_fd_sc_hd__a22o_1
X_4765_ _4944_/B _5666_/A vssd1 vssd1 vccd1 vccd1 _4766_/B sky130_fd_sc_hd__nand2_1
X_6504_ _6834_/CLK _6504_/D vssd1 vssd1 vccd1 vccd1 hold28/A sky130_fd_sc_hd__dfxtp_1
XFILLER_0_15_134 vssd1 vssd1 vccd1 vccd1 sky130_fd_sc_hd__decap_3
XFILLER_0_7_378 vssd1 vssd1 vccd1 vccd1 sky130_ef_sc_hd__decap_12
X_3716_ _3716_/A _3716_/B vssd1 vssd1 vccd1 vccd1 _3718_/A sky130_fd_sc_hd__nand2_1
X_4696_ _5366_/A _5366_/B _4653_/X vssd1 vssd1 vccd1 vccd1 _5365_/A sky130_fd_sc_hd__a21oi_1
XFILLER_0_102_81 vssd1 vssd1 vccd1 vccd1 sky130_fd_sc_hd__decap_3
XANTENNA__3748__A1_N _5299_/A vssd1 vssd1 vccd1 vccd1 sky130_fd_sc_hd__diode_2
X_6435_ _6427_/X _6432_/A _6433_/Y _6441_/B vssd1 vssd1 vccd1 vccd1 _6435_/X sky130_fd_sc_hd__o31a_1
XANTENNA__4060__B _5687_/A vssd1 vssd1 vccd1 vccd1 sky130_fd_sc_hd__diode_2
X_3647_ _3639_/A _3639_/B _3637_/B vssd1 vssd1 vccd1 vccd1 _3651_/A sky130_fd_sc_hd__o21ai_2
X_6366_ _6376_/A _6365_/C _6365_/A vssd1 vssd1 vccd1 vccd1 _6367_/B sky130_fd_sc_hd__o21ai_1
X_3578_ _3578_/A _3578_/B _3593_/A vssd1 vssd1 vccd1 vccd1 _3580_/B sky130_fd_sc_hd__nor3_1
XFILLER_0_30_148 vssd1 vssd1 vccd1 vccd1 sky130_fd_sc_hd__decap_4
XFILLER_0_87_72 vssd1 vssd1 vccd1 vccd1 sky130_fd_sc_hd__fill_2
X_5317_ _5317_/A _5317_/B vssd1 vssd1 vccd1 vccd1 _5318_/B sky130_fd_sc_hd__xnor2_1
X_6297_ hold204/X _6233_/X _6295_/X _6300_/B vssd1 vssd1 vccd1 vccd1 _6297_/X sky130_fd_sc_hd__a22o_1
Xhold14 hold14/A vssd1 vssd1 vccd1 vccd1 hold14/X sky130_fd_sc_hd__dlygate4sd3_1
Xhold25 hold25/A vssd1 vssd1 vccd1 vccd1 hold25/X sky130_fd_sc_hd__dlygate4sd3_1
Xhold47 hold47/A vssd1 vssd1 vccd1 vccd1 hold47/X sky130_fd_sc_hd__dlygate4sd3_1
Xhold36 hold36/A vssd1 vssd1 vccd1 vccd1 hold36/X sky130_fd_sc_hd__dlygate4sd3_1
X_5248_ _4013_/X _5245_/Y _5214_/Y _5215_/B vssd1 vssd1 vccd1 vccd1 _5250_/C sky130_fd_sc_hd__a211oi_1
Xhold58 hold58/A vssd1 vssd1 vccd1 vccd1 hold58/X sky130_fd_sc_hd__dlygate4sd3_1
Xhold69 hold69/A vssd1 vssd1 vccd1 vccd1 hold69/X sky130_fd_sc_hd__dlygate4sd3_1
X_5179_ _5177_/A _5177_/Y _5164_/X _5165_/Y vssd1 vssd1 vccd1 vccd1 _5179_/Y sky130_fd_sc_hd__o211ai_2
XANTENNA__4516__A _4638_/A vssd1 vssd1 vccd1 vccd1 sky130_fd_sc_hd__diode_2
XFILLER_0_78_373 vssd1 vssd1 vccd1 vccd1 sky130_ef_sc_hd__decap_12
XFILLER_0_78_362 vssd1 vssd1 vccd1 vccd1 sky130_fd_sc_hd__fill_2
XANTENNA__3420__A _5296_/A vssd1 vssd1 vccd1 vccd1 sky130_fd_sc_hd__diode_2
XANTENNA_fanout34_A _5599_/A vssd1 vssd1 vccd1 vccd1 sky130_fd_sc_hd__diode_2
XFILLER_0_93_332 vssd1 vssd1 vccd1 vccd1 sky130_fd_sc_hd__fill_1
XFILLER_0_93_310 vssd1 vssd1 vccd1 vccd1 sky130_fd_sc_hd__decap_6
XFILLER_0_38_215 vssd1 vssd1 vccd1 vccd1 sky130_fd_sc_hd__fill_2
XFILLER_0_53_207 vssd1 vssd1 vccd1 vccd1 sky130_fd_sc_hd__fill_2
XFILLER_0_108_169 vssd1 vssd1 vccd1 vccd1 sky130_fd_sc_hd__fill_1
XFILLER_0_61_251 vssd1 vssd1 vccd1 vccd1 sky130_fd_sc_hd__decap_6
XFILLER_0_61_284 vssd1 vssd1 vccd1 vccd1 sky130_ef_sc_hd__decap_12
XANTENNA__6117__S _6223_/B vssd1 vssd1 vccd1 vccd1 sky130_fd_sc_hd__diode_2
XANTENNA__5598__A0 _5440_/X vssd1 vssd1 vccd1 vccd1 sky130_fd_sc_hd__diode_2
XFILLER_0_88_137 vssd1 vssd1 vccd1 vccd1 sky130_fd_sc_hd__decap_3
XANTENNA__4426__A _4942_/A vssd1 vssd1 vccd1 vccd1 sky130_fd_sc_hd__diode_2
XFILLER_0_29_204 vssd1 vssd1 vccd1 vccd1 sky130_fd_sc_hd__decap_4
XFILLER_0_8_109 vssd1 vssd1 vccd1 vccd1 sky130_ef_sc_hd__decap_12
XFILLER_0_32_12 vssd1 vssd1 vccd1 vccd1 sky130_fd_sc_hd__fill_2
XFILLER_0_123_47 vssd1 vssd1 vccd1 vccd1 sky130_fd_sc_hd__decap_3
XTAP_1082 vssd1 vccd1 sky130_fd_sc_hd__tapvpwrvgnd_1
XTAP_1071 vssd1 vccd1 sky130_fd_sc_hd__tapvpwrvgnd_1
XTAP_1060 vssd1 vccd1 sky130_fd_sc_hd__tapvpwrvgnd_1
XFILLER_0_84_365 vssd1 vssd1 vccd1 vccd1 sky130_fd_sc_hd__fill_2
XTAP_1093 vssd1 vccd1 sky130_fd_sc_hd__tapvpwrvgnd_1
XFILLER_0_37_292 vssd1 vssd1 vccd1 vccd1 sky130_fd_sc_hd__fill_2
X_4550_ _4816_/B _4527_/B _4536_/A _4527_/D vssd1 vssd1 vccd1 vccd1 _4573_/B sky130_fd_sc_hd__a22oi_1
XFILLER_0_52_251 vssd1 vssd1 vccd1 vccd1 sky130_fd_sc_hd__fill_1
X_4481_ _4480_/B _4480_/C _4480_/A vssd1 vssd1 vccd1 vccd1 _4482_/C sky130_fd_sc_hd__a21bo_1
XFILLER_0_12_104 vssd1 vssd1 vccd1 vccd1 sky130_fd_sc_hd__fill_2
X_3501_ _5296_/A _5276_/A _5286_/B _5296_/B vssd1 vssd1 vccd1 vccd1 _3502_/C sky130_fd_sc_hd__and4_1
X_6220_ _6218_/X _6219_/Y pix_mport_o[48] _6223_/B vssd1 vssd1 vccd1 vccd1 _6776_/D
+ sky130_fd_sc_hd__a2bb2o_1
X_3432_ _3450_/A _6689_/Q _5299_/A _3432_/D vssd1 vssd1 vccd1 vccd1 _3450_/B sky130_fd_sc_hd__and4b_1
XFILLER_0_122_194 vssd1 vssd1 vccd1 vccd1 sky130_fd_sc_hd__fill_2
X_6151_ _6152_/A _6152_/B _6152_/C vssd1 vssd1 vccd1 vccd1 _6163_/A sky130_fd_sc_hd__a21o_1
XTAP_800 vssd1 vccd1 sky130_fd_sc_hd__tapvpwrvgnd_1
X_3363_ _5306_/A _5049_/B _5296_/B _5276_/B vssd1 vssd1 vccd1 vccd1 _3440_/A sky130_fd_sc_hd__and4_1
XTAP_844 vssd1 vccd1 sky130_fd_sc_hd__tapvpwrvgnd_1
XTAP_833 vssd1 vccd1 sky130_fd_sc_hd__tapvpwrvgnd_1
XTAP_822 vssd1 vccd1 sky130_fd_sc_hd__tapvpwrvgnd_1
XTAP_811 vssd1 vccd1 sky130_fd_sc_hd__tapvpwrvgnd_1
XFILLER_0_20_170 vssd1 vssd1 vccd1 vccd1 sky130_fd_sc_hd__fill_1
X_5102_ _5100_/B _5100_/C _5100_/A vssd1 vssd1 vccd1 vccd1 _5102_/Y sky130_fd_sc_hd__a21oi_1
X_3294_ depth_mport_i[30] vssd1 vssd1 vccd1 vccd1 _3294_/Y sky130_fd_sc_hd__inv_2
X_6082_ hold150/X _6720_/Q _6098_/S vssd1 vssd1 vccd1 vccd1 _6082_/X sky130_fd_sc_hd__mux2_1
XTAP_877 vssd1 vccd1 sky130_fd_sc_hd__tapvpwrvgnd_1
XTAP_866 vssd1 vccd1 sky130_fd_sc_hd__tapvpwrvgnd_1
XTAP_855 vssd1 vccd1 sky130_fd_sc_hd__tapvpwrvgnd_1
XTAP_899 vssd1 vccd1 sky130_fd_sc_hd__tapvpwrvgnd_1
XTAP_888 vssd1 vccd1 sky130_fd_sc_hd__tapvpwrvgnd_1
X_5033_ _5031_/X _5033_/B vssd1 vssd1 vccd1 vccd1 _5034_/A sky130_fd_sc_hd__and2b_1
XANTENNA__3878__C _5071_/A vssd1 vssd1 vccd1 vccd1 sky130_fd_sc_hd__diode_2
X_5935_ hold134/X _3262_/Y _5935_/S vssd1 vssd1 vccd1 vccd1 _6661_/D sky130_fd_sc_hd__mux2_1
XFILLER_0_94_118 vssd1 vssd1 vccd1 vccd1 sky130_fd_sc_hd__fill_2
X_5866_ _5841_/A _5864_/A _5865_/Y _5841_/B _5852_/Y vssd1 vssd1 vccd1 vccd1 _5867_/B
+ sky130_fd_sc_hd__o2111a_1
XFILLER_0_7_131 vssd1 vssd1 vccd1 vccd1 sky130_fd_sc_hd__fill_2
XFILLER_0_35_218 vssd1 vssd1 vccd1 vccd1 sky130_fd_sc_hd__decap_6
X_4817_ _4816_/A _4816_/B _4956_/A _4816_/D vssd1 vssd1 vccd1 vccd1 _4817_/X sky130_fd_sc_hd__a22o_1
XFILLER_0_90_357 vssd1 vssd1 vccd1 vccd1 sky130_fd_sc_hd__decap_6
X_5797_ _5599_/A _5395_/X _5794_/X _5796_/Y vssd1 vssd1 vccd1 vccd1 _5797_/X sky130_fd_sc_hd__a22o_1
XFILLER_0_105_128 vssd1 vssd1 vccd1 vccd1 sky130_fd_sc_hd__fill_2
XANTENNA__4564__A1 _5656_/A vssd1 vssd1 vccd1 vccd1 sky130_fd_sc_hd__diode_2
X_4748_ _4748_/A _4748_/B _4748_/C vssd1 vssd1 vccd1 vccd1 _4757_/A sky130_fd_sc_hd__nand3_1
X_4679_ _4692_/A _4692_/B vssd1 vssd1 vccd1 vccd1 _4679_/X sky130_fd_sc_hd__and2_1
X_6418_ _6415_/A _6417_/Y _6440_/B vssd1 vssd1 vccd1 vccd1 _6418_/Y sky130_fd_sc_hd__a21oi_1
XFILLER_0_98_93 vssd1 vssd1 vccd1 vccd1 sky130_fd_sc_hd__decap_3
XFILLER_0_98_82 vssd1 vssd1 vccd1 vccd1 sky130_fd_sc_hd__fill_2
XANTENNA__4316__A1 _4958_/B vssd1 vssd1 vccd1 vccd1 sky130_fd_sc_hd__diode_2
XANTENNA__6069__A1 _6552_/Q vssd1 vssd1 vccd1 vccd1 sky130_fd_sc_hd__diode_2
X_6349_ _6350_/A _6350_/B _6350_/C vssd1 vssd1 vccd1 vccd1 _6349_/Y sky130_fd_sc_hd__a21oi_1
XFILLER_0_101_378 vssd1 vssd1 vccd1 vccd1 sky130_ef_sc_hd__decap_12
XFILLER_0_11_181 vssd1 vssd1 vccd1 vccd1 sky130_ef_sc_hd__decap_12
XANTENNA__5816__A1 _5599_/A vssd1 vssd1 vccd1 vccd1 sky130_fd_sc_hd__diode_2
XANTENNA__4252__B1 _4658_/D vssd1 vssd1 vccd1 vccd1 sky130_fd_sc_hd__diode_2
XANTENNA_clkbuf_leaf_26_clk_i_A clkbuf_leaf_1_clk_i/A vssd1 vssd1 vccd1 vccd1 sky130_fd_sc_hd__diode_2
XANTENNA__5776__S _5844_/S vssd1 vssd1 vccd1 vccd1 sky130_fd_sc_hd__diode_2
XPHY_143 vssd1 vssd1 vccd1 vccd1 sky130_fd_sc_hd__decap_3
XPHY_132 vssd1 vssd1 vccd1 vccd1 sky130_fd_sc_hd__decap_3
XPHY_110 vssd1 vssd1 vccd1 vccd1 sky130_fd_sc_hd__decap_3
XPHY_121 vssd1 vssd1 vccd1 vccd1 sky130_fd_sc_hd__decap_3
XPHY_176 vssd1 vssd1 vccd1 vccd1 sky130_fd_sc_hd__decap_3
XPHY_165 vssd1 vssd1 vccd1 vccd1 sky130_fd_sc_hd__decap_3
XPHY_154 vssd1 vssd1 vccd1 vccd1 sky130_fd_sc_hd__decap_3
XFILLER_0_66_365 vssd1 vssd1 vccd1 vccd1 sky130_ef_sc_hd__decap_12
XFILLER_0_124_404 vssd1 vssd1 vccd1 vccd1 sky130_fd_sc_hd__decap_3
XPHY_198 vssd1 vssd1 vccd1 vccd1 sky130_fd_sc_hd__decap_3
XPHY_187 vssd1 vssd1 vccd1 vccd1 sky130_fd_sc_hd__decap_3
XFILLER_0_93_184 vssd1 vssd1 vccd1 vccd1 sky130_fd_sc_hd__fill_1
XFILLER_0_19_281 vssd1 vssd1 vccd1 vccd1 sky130_fd_sc_hd__fill_2
XFILLER_0_22_402 vssd1 vssd1 vccd1 vccd1 sky130_fd_sc_hd__decap_4
XFILLER_0_34_251 vssd1 vssd1 vccd1 vccd1 sky130_fd_sc_hd__fill_1
XANTENNA__6027__A_N _6038_/C vssd1 vssd1 vccd1 vccd1 sky130_fd_sc_hd__diode_2
XFILLER_0_27_34 vssd1 vssd1 vccd1 vccd1 sky130_fd_sc_hd__decap_4
XANTENNA__3979__B _5071_/A vssd1 vssd1 vccd1 vccd1 sky130_fd_sc_hd__diode_2
XFILLER_0_134_24 vssd1 vssd1 vccd1 vccd1 sky130_fd_sc_hd__fill_2
XANTENNA__4156__A _4942_/A vssd1 vssd1 vccd1 vccd1 sky130_fd_sc_hd__diode_2
XFILLER_0_76_129 vssd1 vssd1 vccd1 vccd1 sky130_fd_sc_hd__fill_1
XPHY_1 vssd1 vssd1 vccd1 vccd1 sky130_fd_sc_hd__decap_3
X_3981_ _3989_/A vssd1 vssd1 vccd1 vccd1 _3981_/Y sky130_fd_sc_hd__inv_2
XANTENNA__5686__S _5844_/S vssd1 vssd1 vccd1 vccd1 sky130_fd_sc_hd__diode_2
X_5720_ _5732_/B _5720_/B vssd1 vssd1 vccd1 vccd1 _5720_/Y sky130_fd_sc_hd__nand2_1
X_5651_ _5652_/A _5652_/B vssd1 vssd1 vccd1 vccd1 _5651_/X sky130_fd_sc_hd__or2_1
X_5582_ _5422_/X tex_mport_o[49] _5598_/S vssd1 vssd1 vccd1 vccd1 _6606_/D sky130_fd_sc_hd__mux2_1
X_4602_ _4573_/A _4573_/B _4573_/C _4573_/D vssd1 vssd1 vccd1 vccd1 _4603_/C sky130_fd_sc_hd__o22ai_1
XANTENNA__3349__A2 _5296_/A vssd1 vssd1 vccd1 vccd1 sky130_fd_sc_hd__diode_2
X_4533_ _6628_/Q _4567_/B _4531_/X vssd1 vssd1 vccd1 vccd1 _4538_/A sky130_fd_sc_hd__a21o_1
XFILLER_0_4_156 vssd1 vssd1 vccd1 vccd1 sky130_fd_sc_hd__fill_2
XANTENNA__6310__S _6319_/S vssd1 vssd1 vccd1 vccd1 sky130_fd_sc_hd__diode_2
X_6203_ _6208_/B _6203_/B vssd1 vssd1 vccd1 vccd1 _6204_/B sky130_fd_sc_hd__nand2_1
X_4464_ _4452_/A _4442_/C _4442_/A vssd1 vssd1 vccd1 vccd1 _4485_/B sky130_fd_sc_hd__o21ai_1
XFILLER_0_7_55 vssd1 vssd1 vccd1 vccd1 sky130_fd_sc_hd__fill_1
X_4395_ _4394_/B _4394_/C _4394_/A vssd1 vssd1 vccd1 vccd1 _4397_/B sky130_fd_sc_hd__a21o_1
X_3415_ _3415_/A _3415_/B vssd1 vssd1 vccd1 vccd1 _3574_/A sky130_fd_sc_hd__nand2_1
XFILLER_0_0_373 vssd1 vssd1 vccd1 vccd1 sky130_fd_sc_hd__fill_2
XFILLER_0_40_298 vssd1 vssd1 vccd1 vccd1 sky130_fd_sc_hd__decap_3
X_6134_ _6801_/Q _6786_/Q vssd1 vssd1 vccd1 vccd1 _6136_/D sky130_fd_sc_hd__nand2_1
X_3346_ _3425_/B _3346_/B vssd1 vssd1 vccd1 vccd1 _3353_/B sky130_fd_sc_hd__or2_1
XTAP_630 vssd1 vccd1 sky130_fd_sc_hd__tapvpwrvgnd_1
XTAP_641 vssd1 vccd1 sky130_fd_sc_hd__tapvpwrvgnd_1
XTAP_652 vssd1 vccd1 sky130_fd_sc_hd__tapvpwrvgnd_1
X_6065_ hold23/X _6548_/Q _6072_/S vssd1 vssd1 vccd1 vccd1 hold24/A sky130_fd_sc_hd__mux2_1
XTAP_663 vssd1 vccd1 sky130_fd_sc_hd__tapvpwrvgnd_1
XTAP_674 vssd1 vccd1 sky130_fd_sc_hd__tapvpwrvgnd_1
XTAP_685 vssd1 vccd1 sky130_fd_sc_hd__tapvpwrvgnd_1
XFILLER_0_84_51 vssd1 vssd1 vccd1 vccd1 sky130_fd_sc_hd__fill_1
X_5016_ _4904_/Y _5005_/X _4217_/A _4217_/Y vssd1 vssd1 vccd1 vccd1 _5018_/C sky130_fd_sc_hd__a211o_1
XFILLER_0_30_3 vssd1 vssd1 vccd1 vccd1 sky130_fd_sc_hd__decap_3
X_3277_ tex_height_i[0] vssd1 vssd1 vccd1 vccd1 _3277_/Y sky130_fd_sc_hd__inv_2
XTAP_696 vssd1 vccd1 sky130_fd_sc_hd__tapvpwrvgnd_1
XFILLER_0_108_80 vssd1 vssd1 vccd1 vccd1 sky130_fd_sc_hd__fill_2
XFILLER_0_95_405 vssd1 vssd1 vccd1 vccd1 sky130_fd_sc_hd__fill_2
X_6967_ vssd1 vssd1 vccd1 vccd1 _6967_/HI tex_mport_o[20] sky130_fd_sc_hd__conb_1
X_5918_ hold226/X _5917_/X _5923_/S vssd1 vssd1 vccd1 vccd1 _6651_/D sky130_fd_sc_hd__mux2_1
XFILLER_0_48_321 vssd1 vssd1 vccd1 vccd1 sky130_fd_sc_hd__fill_2
X_6898_ vssd1 vssd1 vccd1 vccd1 _6898_/HI depth_mport_o[57] sky130_fd_sc_hd__conb_1
XFILLER_0_75_195 vssd1 vssd1 vccd1 vccd1 sky130_fd_sc_hd__decap_4
XFILLER_0_63_335 vssd1 vssd1 vccd1 vccd1 sky130_fd_sc_hd__fill_1
XFILLER_0_48_398 vssd1 vssd1 vccd1 vccd1 sky130_fd_sc_hd__decap_8
X_5849_ hold277/X _5848_/X _5923_/S vssd1 vssd1 vccd1 vccd1 _6642_/D sky130_fd_sc_hd__mux2_1
XFILLER_0_118_275 vssd1 vssd1 vccd1 vccd1 sky130_fd_sc_hd__decap_3
XFILLER_0_16_251 vssd1 vssd1 vccd1 vccd1 sky130_fd_sc_hd__fill_1
XFILLER_0_133_289 vssd1 vssd1 vccd1 vccd1 sky130_fd_sc_hd__fill_2
XFILLER_0_16_295 vssd1 vssd1 vccd1 vccd1 sky130_fd_sc_hd__decap_4
XFILLER_0_31_221 vssd1 vssd1 vccd1 vccd1 sky130_fd_sc_hd__decap_3
XFILLER_0_101_120 vssd1 vssd1 vccd1 vccd1 sky130_fd_sc_hd__fill_2
XFILLER_0_101_153 vssd1 vssd1 vccd1 vccd1 sky130_fd_sc_hd__fill_2
XFILLER_0_101_186 vssd1 vssd1 vccd1 vccd1 sky130_fd_sc_hd__decap_8
XFILLER_0_98_265 vssd1 vssd1 vccd1 vccd1 sky130_fd_sc_hd__decap_6
XANTENNA__6214__A1 _6224_/B vssd1 vssd1 vccd1 vccd1 sky130_fd_sc_hd__diode_2
XFILLER_0_104_27 vssd1 vssd1 vccd1 vccd1 sky130_fd_sc_hd__fill_1
XFILLER_0_13_69 vssd1 vssd1 vccd1 vccd1 sky130_fd_sc_hd__decap_8
XFILLER_0_81_154 vssd1 vssd1 vccd1 vccd1 sky130_fd_sc_hd__decap_4
XFILLER_0_124_267 vssd1 vssd1 vccd1 vccd1 sky130_fd_sc_hd__decap_3
X_4180_ _4178_/X _4180_/B vssd1 vssd1 vccd1 vccd1 _4181_/B sky130_fd_sc_hd__and2b_1
XFILLER_0_77_405 vssd1 vssd1 vccd1 vccd1 sky130_fd_sc_hd__fill_2
X_6821_ _6827_/CLK _6821_/D fanout151/X vssd1 vssd1 vccd1 vccd1 depth_mport_o[43]
+ sky130_fd_sc_hd__dfrtp_4
XFILLER_0_89_298 vssd1 vssd1 vccd1 vccd1 sky130_fd_sc_hd__decap_3
XANTENNA__5008__A2 _4488_/A vssd1 vssd1 vccd1 vccd1 sky130_fd_sc_hd__diode_2
X_6752_ _6864_/CLK _6752_/D _5468_/A vssd1 vssd1 vccd1 vccd1 pix_mport_o[0] sky130_fd_sc_hd__dfrtp_4
XANTENNA__6305__S _6319_/S vssd1 vssd1 vccd1 vccd1 sky130_fd_sc_hd__diode_2
XFILLER_0_9_248 vssd1 vssd1 vccd1 vccd1 sky130_fd_sc_hd__fill_2
X_3964_ _4944_/B _5083_/B _3870_/C _3870_/D vssd1 vssd1 vccd1 vccd1 _3964_/Y sky130_fd_sc_hd__a22oi_1
XANTENNA__4333__B _4736_/D vssd1 vssd1 vccd1 vccd1 sky130_fd_sc_hd__diode_2
X_5703_ _5702_/Y _6512_/Q _5802_/B vssd1 vssd1 vccd1 vccd1 _5704_/B sky130_fd_sc_hd__mux2_2
X_6683_ _6683_/CLK _6683_/D vssd1 vssd1 vccd1 vccd1 _6683_/Q sky130_fd_sc_hd__dfxtp_2
X_3895_ _3895_/A _3895_/B vssd1 vssd1 vccd1 vccd1 _3901_/B sky130_fd_sc_hd__nand2_1
XFILLER_0_45_346 vssd1 vssd1 vccd1 vccd1 sky130_fd_sc_hd__fill_2
XFILLER_0_57_173 vssd1 vssd1 vccd1 vccd1 sky130_fd_sc_hd__fill_2
X_5634_ hold62/A hold63/A hold8/A hold26/A vssd1 vssd1 vccd1 vccd1 _5636_/C sky130_fd_sc_hd__or4_1
XFILLER_0_72_176 vssd1 vssd1 vccd1 vccd1 sky130_ef_sc_hd__decap_12
XFILLER_0_13_210 vssd1 vssd1 vccd1 vccd1 sky130_fd_sc_hd__decap_3
Xhold100 _6656_/Q vssd1 vssd1 vccd1 vccd1 hold100/X sky130_fd_sc_hd__dlygate4sd3_1
X_5565_ _5796_/A _5565_/B _5588_/C vssd1 vssd1 vccd1 vccd1 _5565_/X sky130_fd_sc_hd__and3_1
XFILLER_0_79_62 vssd1 vssd1 vccd1 vccd1 sky130_fd_sc_hd__decap_4
XFILLER_0_13_232 vssd1 vssd1 vccd1 vccd1 sky130_fd_sc_hd__fill_1
XFILLER_0_53_390 vssd1 vssd1 vccd1 vccd1 sky130_fd_sc_hd__fill_2
XFILLER_0_60_349 vssd1 vssd1 vccd1 vccd1 sky130_fd_sc_hd__fill_2
Xhold122 _6840_/Q vssd1 vssd1 vccd1 vccd1 hold122/X sky130_fd_sc_hd__dlygate4sd3_1
Xhold144 _6845_/Q vssd1 vssd1 vccd1 vccd1 hold144/X sky130_fd_sc_hd__dlygate4sd3_1
X_5496_ hold62/X sstream_i[87] _5502_/S vssd1 vssd1 vccd1 vccd1 _6529_/D sky130_fd_sc_hd__mux2_1
X_4516_ _4638_/A _4582_/D vssd1 vssd1 vccd1 vccd1 _4520_/A sky130_fd_sc_hd__nand2_1
Xhold111 _6891_/Q vssd1 vssd1 vccd1 vccd1 hold111/X sky130_fd_sc_hd__dlygate4sd3_1
XFILLER_0_13_254 vssd1 vssd1 vccd1 vccd1 sky130_fd_sc_hd__decap_3
Xhold133 _6869_/Q vssd1 vssd1 vccd1 vccd1 hold133/X sky130_fd_sc_hd__dlygate4sd3_1
Xhold155 _6847_/Q vssd1 vssd1 vccd1 vccd1 hold155/X sky130_fd_sc_hd__dlygate4sd3_1
X_4447_ _6630_/Q _4491_/B vssd1 vssd1 vccd1 vccd1 _4492_/A sky130_fd_sc_hd__and2_1
Xhold166 _6517_/Q vssd1 vssd1 vccd1 vccd1 hold166/X sky130_fd_sc_hd__dlygate4sd3_1
Xhold177 _6643_/Q vssd1 vssd1 vccd1 vccd1 hold177/X sky130_fd_sc_hd__dlygate4sd3_1
Xhold199 _6666_/Q vssd1 vssd1 vccd1 vccd1 hold199/X sky130_fd_sc_hd__dlygate4sd3_1
Xhold188 _6879_/Q vssd1 vssd1 vccd1 vccd1 hold188/X sky130_fd_sc_hd__dlygate4sd3_1
X_6117_ hold91/X pix_mport_o[1] _6223_/B vssd1 vssd1 vccd1 vccd1 _6753_/D sky130_fd_sc_hd__mux2_1
X_4378_ _4378_/A _4378_/B _4378_/C vssd1 vssd1 vccd1 vccd1 _4386_/A sky130_fd_sc_hd__nand3_1
XTAP_460 vssd1 vccd1 sky130_fd_sc_hd__tapvpwrvgnd_1
X_3329_ _6792_/Q vssd1 vssd1 vccd1 vccd1 _6208_/A sky130_fd_sc_hd__inv_2
XTAP_471 vssd1 vccd1 sky130_fd_sc_hd__tapvpwrvgnd_1
XTAP_482 vssd1 vccd1 sky130_fd_sc_hd__tapvpwrvgnd_1
XTAP_493 vssd1 vccd1 sky130_fd_sc_hd__tapvpwrvgnd_1
X_6048_ hold154/X _6038_/B _6054_/B1 vssd1 vssd1 vccd1 vccd1 _6687_/D sky130_fd_sc_hd__a21o_1
XFILLER_0_68_405 vssd1 vssd1 vccd1 vccd1 sky130_fd_sc_hd__fill_2
XFILLER_0_138_304 vssd1 vssd1 vccd1 vccd1 sky130_fd_sc_hd__decap_4
XFILLER_0_95_279 vssd1 vssd1 vccd1 vccd1 sky130_fd_sc_hd__fill_1
XANTENNA__3785__D _5115_/C vssd1 vssd1 vccd1 vccd1 sky130_fd_sc_hd__diode_2
XANTENNA__5707__B1 _5796_/A vssd1 vssd1 vccd1 vccd1 sky130_fd_sc_hd__diode_2
XFILLER_0_8_270 vssd1 vssd1 vccd1 vccd1 sky130_fd_sc_hd__decap_3
XFILLER_0_36_357 vssd1 vssd1 vccd1 vccd1 sky130_fd_sc_hd__fill_2
XFILLER_0_106_267 vssd1 vssd1 vccd1 vccd1 sky130_fd_sc_hd__fill_2
XANTENNA__6736__SET_B fanout140/X vssd1 vssd1 vccd1 vccd1 sky130_fd_sc_hd__diode_2
XFILLER_0_59_405 vssd1 vssd1 vccd1 vccd1 sky130_fd_sc_hd__fill_2
XFILLER_0_86_224 vssd1 vssd1 vccd1 vccd1 sky130_fd_sc_hd__fill_2
XFILLER_0_129_315 vssd1 vssd1 vccd1 vccd1 sky130_fd_sc_hd__fill_1
XFILLER_0_86_246 vssd1 vssd1 vccd1 vccd1 sky130_fd_sc_hd__decap_6
XFILLER_0_129_337 vssd1 vssd1 vccd1 vccd1 sky130_fd_sc_hd__decap_8
XANTENNA__6125__S _6224_/B vssd1 vssd1 vccd1 vccd1 sky130_fd_sc_hd__diode_2
XANTENNA__3976__C _6678_/Q vssd1 vssd1 vccd1 vccd1 sky130_fd_sc_hd__diode_2
XANTENNA__4153__B _4432_/A vssd1 vssd1 vccd1 vccd1 sky130_fd_sc_hd__diode_2
XFILLER_0_39_173 vssd1 vssd1 vccd1 vccd1 sky130_fd_sc_hd__fill_1
XFILLER_0_39_184 vssd1 vssd1 vccd1 vccd1 sky130_fd_sc_hd__fill_2
X_3680_ _3694_/A vssd1 vssd1 vccd1 vccd1 _3680_/Y sky130_fd_sc_hd__inv_2
XFILLER_0_40_56 vssd1 vssd1 vccd1 vccd1 sky130_fd_sc_hd__fill_2
XFILLER_0_42_327 vssd1 vssd1 vccd1 vccd1 sky130_ef_sc_hd__decap_12
X_5350_ _5348_/Y _5349_/X _5337_/X _5338_/Y _5343_/Y vssd1 vssd1 vccd1 vccd1 _5431_/A
+ sky130_fd_sc_hd__o2111a_1
X_4301_ _4301_/A _4301_/B _4301_/C vssd1 vssd1 vccd1 vccd1 _4302_/B sky130_fd_sc_hd__or3_2
X_5281_ _3622_/A _3619_/X _3621_/A vssd1 vssd1 vccd1 vccd1 _5284_/A sky130_fd_sc_hd__o21ai_2
X_4232_ _4232_/A _4232_/B vssd1 vssd1 vccd1 vccd1 _4244_/A sky130_fd_sc_hd__xnor2_4
XFILLER_0_65_31 vssd1 vssd1 vccd1 vccd1 sky130_fd_sc_hd__fill_2
X_4163_ _4163_/A _4895_/A _4163_/C vssd1 vssd1 vccd1 vccd1 _4895_/B sky130_fd_sc_hd__nand3_1
X_4094_ _4966_/A _4527_/B _4841_/C _4966_/C vssd1 vssd1 vccd1 vccd1 _4095_/B sky130_fd_sc_hd__a22o_1
XFILLER_0_65_53 vssd1 vssd1 vccd1 vccd1 sky130_fd_sc_hd__decap_3
XANTENNA__3660__A1 _5049_/A vssd1 vssd1 vccd1 vccd1 sky130_fd_sc_hd__diode_2
XANTENNA__3660__B2 _5049_/B vssd1 vssd1 vccd1 vccd1 sky130_fd_sc_hd__diode_2
XANTENNA_fanout151_A fanout153/X vssd1 vssd1 vccd1 vccd1 sky130_fd_sc_hd__diode_2
X_6804_ _6818_/CLK _6804_/D fanout150/X vssd1 vssd1 vccd1 vccd1 pix_mport_o[64] sky130_fd_sc_hd__dfrtp_4
X_4996_ _4992_/X _4994_/Y _4890_/B _4890_/Y vssd1 vssd1 vccd1 vccd1 _4996_/X sky130_fd_sc_hd__o211a_1
X_6735_ _6751_/CLK _6735_/D fanout140/X vssd1 vssd1 vccd1 vccd1 _6735_/Q sky130_fd_sc_hd__dfstp_1
XANTENNA__3412__A1 _3999_/A vssd1 vssd1 vccd1 vccd1 sky130_fd_sc_hd__diode_2
XFILLER_0_18_335 vssd1 vssd1 vccd1 vccd1 sky130_fd_sc_hd__fill_2
X_3947_ _3947_/A _3947_/B _3947_/C vssd1 vssd1 vccd1 vccd1 _5136_/A sky130_fd_sc_hd__nand3_1
XFILLER_0_128_370 vssd1 vssd1 vccd1 vccd1 sky130_ef_sc_hd__decap_12
XFILLER_0_18_357 vssd1 vssd1 vccd1 vccd1 sky130_fd_sc_hd__fill_2
XANTENNA__3963__A2 _5286_/A vssd1 vssd1 vccd1 vccd1 sky130_fd_sc_hd__diode_2
X_3878_ _5049_/A _5049_/B _5071_/A _5051_/B vssd1 vssd1 vccd1 vccd1 _3881_/A sky130_fd_sc_hd__nand4_2
X_6666_ _6892_/CLK _6666_/D vssd1 vssd1 vccd1 vccd1 _6666_/Q sky130_fd_sc_hd__dfxtp_1
X_6597_ _6802_/CLK _6597_/D fanout142/X vssd1 vssd1 vccd1 vccd1 tex_mport_o[40] sky130_fd_sc_hd__dfrtp_4
X_5617_ _4832_/C _3268_/Y _3269_/Y _5787_/B vssd1 vssd1 vccd1 vccd1 _5617_/X sky130_fd_sc_hd__o22a_1
XFILLER_0_45_198 vssd1 vssd1 vccd1 vccd1 sky130_fd_sc_hd__fill_2
X_5548_ depth_mport_o[23] hold167/X _5556_/S vssd1 vssd1 vccd1 vccd1 _6579_/D sky130_fd_sc_hd__mux2_1
XFILLER_0_41_382 vssd1 vssd1 vccd1 vccd1 sky130_fd_sc_hd__decap_8
XFILLER_0_41_393 vssd1 vssd1 vccd1 vccd1 sky130_ef_sc_hd__decap_12
XFILLER_0_111_281 vssd1 vssd1 vccd1 vccd1 sky130_fd_sc_hd__decap_3
XFILLER_0_111_270 vssd1 vssd1 vccd1 vccd1 sky130_fd_sc_hd__fill_1
X_5479_ hold160/X sstream_i[70] _6450_/S vssd1 vssd1 vccd1 vccd1 _6512_/D sky130_fd_sc_hd__mux2_1
XTAP_290 vssd1 vccd1 sky130_fd_sc_hd__tapvpwrvgnd_1
XFILLER_0_83_238 vssd1 vssd1 vccd1 vccd1 sky130_fd_sc_hd__fill_1
XFILLER_0_126_318 vssd1 vssd1 vccd1 vccd1 sky130_fd_sc_hd__decap_3
XANTENNA__5784__S _5784_/S vssd1 vssd1 vccd1 vccd1 sky130_fd_sc_hd__diode_2
Xfanout50 _6676_/Q vssd1 vssd1 vccd1 vccd1 _5049_/D sky130_fd_sc_hd__clkbuf_8
Xfanout61 _6670_/Q vssd1 vssd1 vccd1 vccd1 _5115_/C sky130_fd_sc_hd__buf_4
Xfanout83 tex_width_i[9] vssd1 vssd1 vccd1 vccd1 _4958_/B sky130_fd_sc_hd__buf_4
Xfanout72 hold291/X vssd1 vssd1 vccd1 vccd1 _4842_/A sky130_fd_sc_hd__buf_4
XFILLER_0_24_316 vssd1 vssd1 vccd1 vccd1 sky130_fd_sc_hd__decap_4
Xfanout94 _5701_/A vssd1 vssd1 vccd1 vccd1 _4942_/A sky130_fd_sc_hd__buf_4
XFILLER_0_51_113 vssd1 vssd1 vccd1 vccd1 sky130_fd_sc_hd__decap_3
XFILLER_0_10_15 vssd1 vssd1 vccd1 vccd1 sky130_ef_sc_hd__decap_12
XFILLER_0_32_382 vssd1 vssd1 vccd1 vccd1 sky130_ef_sc_hd__decap_12
XFILLER_0_19_79 vssd1 vssd1 vccd1 vccd1 sky130_fd_sc_hd__decap_3
XFILLER_0_126_25 vssd1 vssd1 vccd1 vccd1 sky130_fd_sc_hd__fill_1
XFILLER_0_35_12 vssd1 vssd1 vccd1 vccd1 sky130_fd_sc_hd__fill_2
XFILLER_0_59_202 vssd1 vssd1 vccd1 vccd1 sky130_fd_sc_hd__fill_1
XANTENNA__6363__B hold53/A vssd1 vssd1 vccd1 vccd1 sky130_fd_sc_hd__diode_2
XFILLER_0_99_393 vssd1 vssd1 vccd1 vccd1 sky130_ef_sc_hd__decap_12
X_4850_ _4850_/A _4850_/B _4850_/C vssd1 vssd1 vccd1 vccd1 _4865_/A sky130_fd_sc_hd__nand3_2
XFILLER_0_59_279 vssd1 vssd1 vccd1 vccd1 sky130_fd_sc_hd__fill_1
XFILLER_0_136_3 vssd1 vssd1 vccd1 vccd1 sky130_fd_sc_hd__fill_1
XFILLER_0_129_145 vssd1 vssd1 vccd1 vccd1 sky130_fd_sc_hd__fill_2
XFILLER_0_117_307 vssd1 vssd1 vccd1 vccd1 sky130_fd_sc_hd__fill_2
XFILLER_0_74_249 vssd1 vssd1 vccd1 vccd1 sky130_fd_sc_hd__decap_3
X_3801_ _3801_/A _3801_/B _3919_/A vssd1 vssd1 vccd1 vccd1 _3815_/B sky130_fd_sc_hd__nor3_1
XANTENNA__4314__D _4658_/D vssd1 vssd1 vccd1 vccd1 sky130_fd_sc_hd__diode_2
X_6520_ _6892_/CLK _6520_/D vssd1 vssd1 vccd1 vccd1 _6520_/Q sky130_fd_sc_hd__dfxtp_1
X_4781_ _4778_/X _4782_/B vssd1 vssd1 vccd1 vccd1 _4860_/B sky130_fd_sc_hd__and2b_1
XFILLER_0_82_260 vssd1 vssd1 vccd1 vccd1 sky130_fd_sc_hd__decap_8
X_3732_ _3733_/A _3733_/B _3733_/C vssd1 vssd1 vccd1 vccd1 _3755_/B sky130_fd_sc_hd__o21a_1
XFILLER_0_27_154 vssd1 vssd1 vccd1 vccd1 sky130_fd_sc_hd__fill_2
X_6451_ hold131/X sstream_i[9] _6472_/S vssd1 vssd1 vccd1 vccd1 _6842_/D sky130_fd_sc_hd__mux2_1
X_3663_ _5051_/A _6683_/Q _3661_/B _3659_/X vssd1 vssd1 vccd1 vccd1 _3671_/B sky130_fd_sc_hd__a31o_1
X_6382_ _6363_/Y _6367_/A _6376_/B vssd1 vssd1 vccd1 vccd1 _6382_/X sky130_fd_sc_hd__a21o_1
X_5402_ _5402_/A _5402_/B _5402_/C _5402_/D vssd1 vssd1 vccd1 vccd1 _5402_/X sky130_fd_sc_hd__and4_1
X_5333_ _5333_/A _5333_/B vssd1 vssd1 vccd1 vccd1 _5334_/B sky130_fd_sc_hd__xnor2_4
X_3594_ _3594_/A _3594_/B vssd1 vssd1 vccd1 vccd1 _3601_/A sky130_fd_sc_hd__xnor2_1
XFILLER_0_23_393 vssd1 vssd1 vccd1 vccd1 sky130_ef_sc_hd__decap_12
X_5264_ _5264_/A _5264_/B _5264_/C vssd1 vssd1 vccd1 vccd1 _5265_/B sky130_fd_sc_hd__or3_1
XFILLER_0_76_85 vssd1 vssd1 vccd1 vccd1 sky130_fd_sc_hd__fill_2
X_4215_ _4211_/Y _4214_/X _4205_/Y _4206_/X vssd1 vssd1 vccd1 vccd1 _4217_/A sky130_fd_sc_hd__o211a_2
X_5195_ _5173_/X _5185_/X _4988_/B _4988_/Y vssd1 vssd1 vccd1 vccd1 _5197_/C sky130_fd_sc_hd__a211o_1
XFILLER_0_76_96 vssd1 vssd1 vccd1 vccd1 sky130_fd_sc_hd__decap_4
X_4146_ _4146_/A _4146_/B vssd1 vssd1 vccd1 vccd1 _4212_/A sky130_fd_sc_hd__nand2_2
X_4077_ _4816_/A _4488_/A vssd1 vssd1 vccd1 vccd1 _4078_/B sky130_fd_sc_hd__nand2_1
X_4979_ _4978_/B _4978_/C _4978_/A vssd1 vssd1 vccd1 vccd1 _4981_/B sky130_fd_sc_hd__a21o_1
XFILLER_0_58_290 vssd1 vssd1 vccd1 vccd1 sky130_fd_sc_hd__fill_1
X_6718_ _6853_/CLK hold58/X vssd1 vssd1 vccd1 vccd1 hold57/A sky130_fd_sc_hd__dfxtp_1
XFILLER_0_18_176 vssd1 vssd1 vccd1 vccd1 sky130_fd_sc_hd__fill_2
XFILLER_0_33_135 vssd1 vssd1 vccd1 vccd1 sky130_fd_sc_hd__fill_2
X_6649_ _6751_/CLK _6649_/D fanout139/X vssd1 vssd1 vccd1 vccd1 _6649_/Q sky130_fd_sc_hd__dfstp_1
XFILLER_0_116_384 vssd1 vssd1 vccd1 vccd1 sky130_ef_sc_hd__decap_12
XANTENNA__4113__A2 _4433_/D vssd1 vssd1 vccd1 vccd1 sky130_fd_sc_hd__diode_2
XTAP_1231 vssd1 vccd1 sky130_fd_sc_hd__tapvpwrvgnd_1
XTAP_1220 vssd1 vccd1 sky130_fd_sc_hd__tapvpwrvgnd_1
XTAP_1264 vssd1 vccd1 sky130_fd_sc_hd__tapvpwrvgnd_1
XTAP_1253 vssd1 vccd1 sky130_fd_sc_hd__tapvpwrvgnd_1
XTAP_1242 vssd1 vccd1 sky130_fd_sc_hd__tapvpwrvgnd_1
XFILLER_0_56_227 vssd1 vssd1 vccd1 vccd1 sky130_fd_sc_hd__fill_2
XFILLER_0_64_260 vssd1 vssd1 vccd1 vccd1 sky130_fd_sc_hd__fill_2
XFILLER_0_24_124 vssd1 vssd1 vccd1 vccd1 sky130_fd_sc_hd__fill_2
XFILLER_0_134_170 vssd1 vssd1 vccd1 vccd1 sky130_fd_sc_hd__fill_2
XANTENNA__3328__A _6833_/Q vssd1 vssd1 vccd1 vccd1 sky130_fd_sc_hd__diode_2
XFILLER_0_107_384 vssd1 vssd1 vccd1 vccd1 sky130_fd_sc_hd__decap_8
XFILLER_0_24_157 vssd1 vssd1 vccd1 vccd1 sky130_fd_sc_hd__decap_3
XFILLER_0_122_365 vssd1 vssd1 vccd1 vccd1 sky130_fd_sc_hd__fill_2
XFILLER_0_20_363 vssd1 vssd1 vccd1 vccd1 sky130_fd_sc_hd__fill_1
X_4000_ _4001_/B _4001_/A vssd1 vssd1 vccd1 vccd1 _4003_/A sky130_fd_sc_hd__nand2b_1
XANTENNA__6374__A hold60/A vssd1 vssd1 vccd1 vccd1 sky130_fd_sc_hd__diode_2
X_5951_ _6871_/Q _5951_/B vssd1 vssd1 vccd1 vccd1 _5951_/X sky130_fd_sc_hd__or2_1
X_4902_ _4912_/B _4902_/B vssd1 vssd1 vccd1 vccd1 _4902_/Y sky130_fd_sc_hd__nand2_1
XFILLER_0_1_57 vssd1 vssd1 vccd1 vccd1 sky130_ef_sc_hd__decap_12
XANTENNA__4325__C _4614_/C vssd1 vssd1 vccd1 vccd1 sky130_fd_sc_hd__diode_2
X_5882_ tex_addr_i[26] _5882_/B vssd1 vssd1 vccd1 vccd1 _5883_/B sky130_fd_sc_hd__nand2_1
X_4833_ _4971_/B _5787_/B vssd1 vssd1 vccd1 vccd1 _4835_/B sky130_fd_sc_hd__and2_1
XANTENNA__6313__S _6319_/S vssd1 vssd1 vccd1 vccd1 sky130_fd_sc_hd__diode_2
XFILLER_0_117_126 vssd1 vssd1 vccd1 vccd1 sky130_fd_sc_hd__fill_2
XFILLER_0_62_219 vssd1 vssd1 vccd1 vccd1 sky130_fd_sc_hd__fill_1
XFILLER_0_62_208 vssd1 vssd1 vccd1 vccd1 sky130_fd_sc_hd__fill_1
X_4764_ _4944_/B _5656_/A _4739_/A _4737_/B vssd1 vssd1 vccd1 vccd1 _4766_/A sky130_fd_sc_hd__a31o_1
X_6503_ _6834_/CLK _6503_/D vssd1 vssd1 vccd1 vccd1 _6503_/Q sky130_fd_sc_hd__dfxtp_1
X_3715_ _5081_/B _3959_/B _5273_/A _5272_/A vssd1 vssd1 vccd1 vccd1 _3716_/B sky130_fd_sc_hd__nand4_1
XFILLER_0_132_129 vssd1 vssd1 vccd1 vccd1 sky130_fd_sc_hd__fill_2
X_6434_ _6432_/A _6433_/Y _6427_/X vssd1 vssd1 vccd1 vccd1 _6434_/Y sky130_fd_sc_hd__o21ai_1
X_4695_ _4671_/B _5367_/B _4669_/X vssd1 vssd1 vccd1 vccd1 _5366_/B sky130_fd_sc_hd__a21o_1
XFILLER_0_113_332 vssd1 vssd1 vccd1 vccd1 sky130_fd_sc_hd__fill_2
XANTENNA_fanout114_A _4789_/C vssd1 vssd1 vccd1 vccd1 sky130_fd_sc_hd__diode_2
XANTENNA__4060__C _4551_/D vssd1 vssd1 vccd1 vccd1 sky130_fd_sc_hd__diode_2
XFILLER_0_70_285 vssd1 vssd1 vccd1 vccd1 sky130_fd_sc_hd__fill_2
X_3646_ _5277_/A _5308_/A _5296_/A _5276_/A _3645_/X vssd1 vssd1 vccd1 vccd1 _3653_/A
+ sky130_fd_sc_hd__a41o_1
XFILLER_0_30_127 vssd1 vssd1 vccd1 vccd1 sky130_fd_sc_hd__fill_2
X_6365_ _6365_/A _6376_/A _6365_/C vssd1 vssd1 vccd1 vccd1 _6367_/A sky130_fd_sc_hd__or3_1
XFILLER_0_87_40 vssd1 vssd1 vccd1 vccd1 sky130_fd_sc_hd__decap_4
X_3577_ _3580_/A vssd1 vssd1 vccd1 vccd1 _3577_/Y sky130_fd_sc_hd__inv_2
XFILLER_0_11_341 vssd1 vssd1 vccd1 vccd1 sky130_fd_sc_hd__decap_3
XFILLER_0_60_3 vssd1 vssd1 vccd1 vccd1 sky130_fd_sc_hd__fill_2
X_6296_ _3265_/Y _6229_/X _6233_/X vssd1 vssd1 vccd1 vccd1 _6300_/B sky130_fd_sc_hd__o21ba_1
X_5316_ _5316_/A _5316_/B vssd1 vssd1 vccd1 vccd1 _5317_/B sky130_fd_sc_hd__xnor2_1
XANTENNA__4069__A _4432_/A vssd1 vssd1 vccd1 vccd1 sky130_fd_sc_hd__diode_2
X_5247_ _5215_/B _5214_/Y _5245_/Y _4013_/X vssd1 vssd1 vccd1 vccd1 _5247_/Y sky130_fd_sc_hd__o211ai_1
Xhold15 hold15/A vssd1 vssd1 vccd1 vccd1 hold15/X sky130_fd_sc_hd__dlygate4sd3_1
Xhold37 hold37/A vssd1 vssd1 vccd1 vccd1 hold37/X sky130_fd_sc_hd__dlygate4sd3_1
Xhold26 hold26/A vssd1 vssd1 vccd1 vccd1 hold26/X sky130_fd_sc_hd__dlygate4sd3_1
Xhold48 hold48/A vssd1 vssd1 vccd1 vccd1 hold48/X sky130_fd_sc_hd__dlygate4sd3_1
Xhold59 hold59/A vssd1 vssd1 vccd1 vccd1 hold59/X sky130_fd_sc_hd__dlygate4sd3_1
X_5178_ _5177_/A _5177_/Y _5164_/X _5165_/Y vssd1 vssd1 vccd1 vccd1 _5181_/B sky130_fd_sc_hd__o211a_1
X_4129_ _6636_/Q _4130_/B vssd1 vssd1 vccd1 vccd1 _4131_/A sky130_fd_sc_hd__and2_1
XANTENNA__3420__B _5276_/A vssd1 vssd1 vccd1 vccd1 sky130_fd_sc_hd__diode_2
XFILLER_0_78_385 vssd1 vssd1 vccd1 vccd1 sky130_ef_sc_hd__decap_12
XANTENNA_fanout27_A _6061_/S vssd1 vssd1 vccd1 vccd1 sky130_fd_sc_hd__diode_2
XFILLER_0_46_260 vssd1 vssd1 vccd1 vccd1 sky130_fd_sc_hd__fill_2
XFILLER_0_46_271 vssd1 vssd1 vccd1 vccd1 sky130_fd_sc_hd__fill_2
XFILLER_0_61_296 vssd1 vssd1 vccd1 vccd1 sky130_fd_sc_hd__decap_4
XFILLER_0_104_365 vssd1 vssd1 vccd1 vccd1 sky130_ef_sc_hd__decap_12
XANTENNA_clkbuf_leaf_22_clk_i_A _6684_/CLK vssd1 vssd1 vccd1 vccd1 sky130_fd_sc_hd__diode_2
XANTENNA__4098__A1 _4971_/B vssd1 vssd1 vccd1 vccd1 sky130_fd_sc_hd__diode_2
XANTENNA__4098__B2 _4551_/D vssd1 vssd1 vccd1 vccd1 sky130_fd_sc_hd__diode_2
XFILLER_0_88_149 vssd1 vssd1 vccd1 vccd1 sky130_fd_sc_hd__fill_2
XFILLER_0_16_47 vssd1 vssd1 vccd1 vccd1 sky130_fd_sc_hd__fill_1
XANTENNA__4426__B _4942_/B vssd1 vssd1 vccd1 vccd1 sky130_fd_sc_hd__diode_2
XFILLER_0_96_182 vssd1 vssd1 vccd1 vccd1 sky130_fd_sc_hd__fill_2
XTAP_1083 vssd1 vccd1 sky130_fd_sc_hd__tapvpwrvgnd_1
XTAP_1072 vssd1 vccd1 sky130_fd_sc_hd__tapvpwrvgnd_1
XTAP_1061 vssd1 vccd1 sky130_fd_sc_hd__tapvpwrvgnd_1
XTAP_1050 vssd1 vccd1 sky130_fd_sc_hd__tapvpwrvgnd_1
XFILLER_0_96_193 vssd1 vssd1 vccd1 vccd1 sky130_fd_sc_hd__decap_3
XFILLER_0_32_24 vssd1 vssd1 vccd1 vccd1 sky130_fd_sc_hd__fill_2
XANTENNA__5819__A2_N _5919_/B vssd1 vssd1 vccd1 vccd1 sky130_fd_sc_hd__diode_2
XTAP_1094 vssd1 vccd1 sky130_fd_sc_hd__tapvpwrvgnd_1
XANTENNA__5972__S _6037_/S vssd1 vssd1 vccd1 vccd1 sky130_fd_sc_hd__diode_2
X_3500_ _5296_/A _5286_/B _5296_/B _5276_/A vssd1 vssd1 vccd1 vccd1 _3502_/B sky130_fd_sc_hd__a22oi_2
X_4480_ _4480_/A _4480_/B _4480_/C vssd1 vssd1 vccd1 vccd1 _4524_/A sky130_fd_sc_hd__nand3_1
X_3431_ _5299_/A _6689_/Q _3429_/Y _3450_/A vssd1 vssd1 vccd1 vccd1 _3433_/A sky130_fd_sc_hd__o2bb2a_1
X_6150_ _6150_/A _6150_/B vssd1 vssd1 vccd1 vccd1 _6152_/C sky130_fd_sc_hd__xnor2_1
XTAP_801 vssd1 vccd1 sky130_fd_sc_hd__tapvpwrvgnd_1
X_3362_ _3365_/D vssd1 vssd1 vccd1 vccd1 _3362_/Y sky130_fd_sc_hd__inv_2
XANTENNA__5273__A _5273_/A vssd1 vssd1 vccd1 vccd1 sky130_fd_sc_hd__diode_2
XTAP_834 vssd1 vccd1 sky130_fd_sc_hd__tapvpwrvgnd_1
XTAP_823 vssd1 vccd1 sky130_fd_sc_hd__tapvpwrvgnd_1
XTAP_812 vssd1 vccd1 sky130_fd_sc_hd__tapvpwrvgnd_1
X_5101_ _5101_/A _5101_/B vssd1 vssd1 vccd1 vccd1 _5101_/Y sky130_fd_sc_hd__nand2_1
X_6081_ hold16/X hold38/X _6315_/S vssd1 vssd1 vccd1 vccd1 _6719_/D sky130_fd_sc_hd__mux2_1
X_3293_ depth_mport_i[31] vssd1 vssd1 vccd1 vccd1 _3293_/Y sky130_fd_sc_hd__inv_2
XTAP_867 vssd1 vccd1 sky130_fd_sc_hd__tapvpwrvgnd_1
XTAP_856 vssd1 vccd1 sky130_fd_sc_hd__tapvpwrvgnd_1
XTAP_845 vssd1 vccd1 sky130_fd_sc_hd__tapvpwrvgnd_1
XFILLER_0_57_65 vssd1 vssd1 vccd1 vccd1 sky130_fd_sc_hd__decap_3
XTAP_889 vssd1 vccd1 sky130_fd_sc_hd__tapvpwrvgnd_1
XTAP_878 vssd1 vccd1 sky130_fd_sc_hd__tapvpwrvgnd_1
X_5032_ _5028_/Y _5030_/Y _5022_/X _5026_/Y vssd1 vssd1 vccd1 vccd1 _5033_/B sky130_fd_sc_hd__a211o_1
XANTENNA__6308__S _6319_/S vssd1 vssd1 vccd1 vccd1 sky130_fd_sc_hd__diode_2
XANTENNA__4617__A _4638_/A vssd1 vssd1 vccd1 vccd1 sky130_fd_sc_hd__diode_2
XFILLER_0_73_53 vssd1 vssd1 vccd1 vccd1 sky130_fd_sc_hd__decap_3
XFILLER_0_73_75 vssd1 vssd1 vccd1 vccd1 sky130_fd_sc_hd__fill_2
XANTENNA__3878__D _5051_/B vssd1 vssd1 vccd1 vccd1 sky130_fd_sc_hd__diode_2
X_5934_ _3262_/Y _6073_/C _5924_/B _5933_/Y _5576_/S vssd1 vssd1 vccd1 vccd1 _5935_/S
+ sky130_fd_sc_hd__o221a_1
XFILLER_0_87_160 vssd1 vssd1 vccd1 vccd1 sky130_fd_sc_hd__fill_1
XFILLER_0_75_344 vssd1 vssd1 vccd1 vccd1 sky130_fd_sc_hd__decap_3
X_5865_ tex_addr_i[22] tex_addr_i[23] _5882_/B vssd1 vssd1 vccd1 vccd1 _5865_/Y sky130_fd_sc_hd__o21ai_1
XFILLER_0_90_314 vssd1 vssd1 vccd1 vccd1 sky130_fd_sc_hd__fill_2
X_4816_ _4816_/A _4816_/B _4956_/A _4816_/D vssd1 vssd1 vccd1 vccd1 _4956_/B sky130_fd_sc_hd__nand4_1
XFILLER_0_133_405 vssd1 vssd1 vccd1 vccd1 sky130_fd_sc_hd__fill_2
XFILLER_0_113_81 vssd1 vssd1 vccd1 vccd1 sky130_fd_sc_hd__fill_2
X_5796_ _5796_/A _5807_/B vssd1 vssd1 vccd1 vccd1 _5796_/Y sky130_fd_sc_hd__nor2_1
XFILLER_0_7_165 vssd1 vssd1 vccd1 vccd1 sky130_fd_sc_hd__decap_3
XANTENNA__4564__A2 _4614_/C vssd1 vssd1 vccd1 vccd1 sky130_fd_sc_hd__diode_2
X_4747_ _4816_/A _4942_/B _4776_/A _4942_/A vssd1 vssd1 vccd1 vccd1 _4748_/C sky130_fd_sc_hd__a22o_1
XFILLER_0_43_252 vssd1 vssd1 vccd1 vccd1 sky130_fd_sc_hd__fill_2
X_4678_ _4678_/A _4686_/A _4680_/A _4678_/D vssd1 vssd1 vccd1 vccd1 _4692_/B sky130_fd_sc_hd__and4_1
X_6417_ _6415_/B _6427_/B vssd1 vssd1 vccd1 vccd1 _6417_/Y sky130_fd_sc_hd__nand2b_1
X_3629_ _5308_/B _5115_/D _5118_/B _5277_/B vssd1 vssd1 vccd1 vccd1 _3630_/B sky130_fd_sc_hd__a22o_1
X_6348_ _6348_/A _6348_/B vssd1 vssd1 vccd1 vccd1 _6350_/C sky130_fd_sc_hd__or2_1
XFILLER_0_101_346 vssd1 vssd1 vccd1 vccd1 sky130_fd_sc_hd__fill_2
XFILLER_0_101_335 vssd1 vssd1 vccd1 vccd1 sky130_fd_sc_hd__fill_1
XFILLER_0_3_393 vssd1 vssd1 vccd1 vccd1 sky130_ef_sc_hd__decap_12
XFILLER_0_11_193 vssd1 vssd1 vccd1 vccd1 sky130_fd_sc_hd__decap_4
X_6279_ _3299_/Y _6860_/Q _3300_/Y _6859_/Q vssd1 vssd1 vccd1 vccd1 _6283_/A sky130_fd_sc_hd__a22o_1
XANTENNA__4527__A _5718_/B vssd1 vssd1 vccd1 vccd1 sky130_fd_sc_hd__diode_2
XANTENNA__4252__B2 _4822_/B vssd1 vssd1 vccd1 vccd1 sky130_fd_sc_hd__diode_2
XANTENNA__4252__A1 _5754_/A vssd1 vssd1 vccd1 vccd1 sky130_fd_sc_hd__diode_2
XFILLER_0_78_171 vssd1 vssd1 vccd1 vccd1 sky130_fd_sc_hd__decap_3
XPHY_100 vssd1 vssd1 vccd1 vccd1 sky130_fd_sc_hd__decap_3
XPHY_133 vssd1 vssd1 vccd1 vccd1 sky130_fd_sc_hd__decap_3
XFILLER_0_66_355 vssd1 vssd1 vccd1 vccd1 sky130_fd_sc_hd__fill_2
XPHY_111 vssd1 vssd1 vccd1 vccd1 sky130_fd_sc_hd__decap_3
XPHY_122 vssd1 vssd1 vccd1 vccd1 sky130_fd_sc_hd__decap_3
XFILLER_0_93_174 vssd1 vssd1 vccd1 vccd1 sky130_fd_sc_hd__fill_1
XFILLER_0_93_152 vssd1 vssd1 vccd1 vccd1 sky130_ef_sc_hd__decap_12
XFILLER_0_93_141 vssd1 vssd1 vccd1 vccd1 sky130_fd_sc_hd__decap_6
XPHY_166 vssd1 vssd1 vccd1 vccd1 sky130_fd_sc_hd__decap_3
XFILLER_0_81_314 vssd1 vssd1 vccd1 vccd1 sky130_fd_sc_hd__fill_2
XFILLER_0_81_303 vssd1 vssd1 vccd1 vccd1 sky130_fd_sc_hd__decap_3
XPHY_155 vssd1 vssd1 vccd1 vccd1 sky130_fd_sc_hd__decap_3
XPHY_144 vssd1 vssd1 vccd1 vccd1 sky130_fd_sc_hd__decap_3
XFILLER_0_66_377 vssd1 vssd1 vccd1 vccd1 sky130_ef_sc_hd__decap_12
XPHY_199 vssd1 vssd1 vccd1 vccd1 sky130_fd_sc_hd__decap_3
XPHY_188 vssd1 vssd1 vccd1 vccd1 sky130_fd_sc_hd__decap_3
XPHY_177 vssd1 vssd1 vccd1 vccd1 sky130_fd_sc_hd__decap_3
XFILLER_0_34_296 vssd1 vssd1 vccd1 vccd1 sky130_fd_sc_hd__decap_3
XFILLER_0_104_195 vssd1 vssd1 vccd1 vccd1 sky130_fd_sc_hd__fill_1
XANTENNA__5093__A _5093_/A vssd1 vssd1 vccd1 vccd1 sky130_fd_sc_hd__diode_2
XFILLER_0_118_26 vssd1 vssd1 vccd1 vccd1 sky130_fd_sc_hd__fill_2
XANTENNA__6128__S _6224_/B vssd1 vssd1 vccd1 vccd1 sky130_fd_sc_hd__diode_2
XANTENNA__4156__B _4942_/B vssd1 vssd1 vccd1 vccd1 sky130_fd_sc_hd__diode_2
XPHY_2 vssd1 vssd1 vccd1 vccd1 sky130_fd_sc_hd__decap_3
X_3980_ _3976_/X _3979_/X _3881_/B _3975_/X vssd1 vssd1 vccd1 vccd1 _3989_/A sky130_fd_sc_hd__o211ai_4
XFILLER_0_69_182 vssd1 vssd1 vccd1 vccd1 sky130_fd_sc_hd__fill_1
X_5650_ _5648_/Y _5650_/B vssd1 vssd1 vccd1 vccd1 _5652_/B sky130_fd_sc_hd__nand2b_1
XFILLER_0_17_208 vssd1 vssd1 vccd1 vccd1 sky130_fd_sc_hd__fill_1
XFILLER_0_115_405 vssd1 vssd1 vccd1 vccd1 sky130_fd_sc_hd__fill_2
X_4601_ _4628_/A _4628_/B vssd1 vssd1 vccd1 vccd1 _4603_/B sky130_fd_sc_hd__and2_1
XFILLER_0_72_347 vssd1 vssd1 vccd1 vccd1 sky130_fd_sc_hd__fill_1
XFILLER_0_127_287 vssd1 vssd1 vccd1 vccd1 sky130_fd_sc_hd__fill_2
X_5581_ _5407_/B tex_mport_o[48] _5601_/S vssd1 vssd1 vccd1 vccd1 _6605_/D sky130_fd_sc_hd__mux2_1
X_4532_ _4532_/A _4532_/B vssd1 vssd1 vccd1 vccd1 _4567_/B sky130_fd_sc_hd__xnor2_1
X_4463_ _4457_/A _4457_/C _4457_/B vssd1 vssd1 vccd1 vccd1 _4463_/X sky130_fd_sc_hd__a21o_1
XFILLER_0_40_222 vssd1 vssd1 vccd1 vccd1 sky130_fd_sc_hd__fill_1
X_6202_ _6202_/A _6202_/B vssd1 vssd1 vccd1 vccd1 _6203_/B sky130_fd_sc_hd__nand2_1
X_3414_ _3870_/A _5273_/A _5272_/A _5308_/A vssd1 vssd1 vccd1 vccd1 _3415_/B sky130_fd_sc_hd__a22o_1
X_4394_ _4394_/A _4394_/B _4394_/C vssd1 vssd1 vccd1 vccd1 _4397_/A sky130_fd_sc_hd__nand3_1
X_6133_ _6801_/Q _6786_/Q vssd1 vssd1 vccd1 vccd1 _6136_/C sky130_fd_sc_hd__or2_1
X_3345_ _5320_/A _5272_/B _3342_/Y _3425_/A vssd1 vssd1 vccd1 vccd1 _3346_/B sky130_fd_sc_hd__o2bb2a_1
XFILLER_0_0_385 vssd1 vssd1 vccd1 vccd1 sky130_fd_sc_hd__decap_6
XTAP_620 vssd1 vccd1 sky130_fd_sc_hd__tapvpwrvgnd_1
XTAP_631 vssd1 vccd1 sky130_fd_sc_hd__tapvpwrvgnd_1
XTAP_642 vssd1 vccd1 sky130_fd_sc_hd__tapvpwrvgnd_1
X_6064_ hold77/X hold87/X _6072_/S vssd1 vssd1 vccd1 vccd1 _6703_/D sky130_fd_sc_hd__mux2_1
X_3276_ tex_addr_i[1] vssd1 vssd1 vccd1 vccd1 _5649_/A sky130_fd_sc_hd__inv_2
XTAP_653 vssd1 vccd1 sky130_fd_sc_hd__tapvpwrvgnd_1
XTAP_664 vssd1 vccd1 sky130_fd_sc_hd__tapvpwrvgnd_1
XTAP_675 vssd1 vccd1 sky130_fd_sc_hd__tapvpwrvgnd_1
XTAP_686 vssd1 vccd1 sky130_fd_sc_hd__tapvpwrvgnd_1
X_5015_ _5015_/A _5015_/B vssd1 vssd1 vccd1 vccd1 _5018_/B sky130_fd_sc_hd__xnor2_1
XTAP_697 vssd1 vccd1 sky130_fd_sc_hd__tapvpwrvgnd_1
XFILLER_0_84_85 vssd1 vssd1 vccd1 vccd1 sky130_fd_sc_hd__fill_2
XFILLER_0_23_3 vssd1 vssd1 vccd1 vccd1 sky130_ef_sc_hd__decap_12
X_6966_ vssd1 vssd1 vccd1 vccd1 _6966_/HI tex_mport_o[19] sky130_fd_sc_hd__conb_1
X_5917_ _5922_/S _5915_/Y _5916_/X _5599_/X vssd1 vssd1 vccd1 vccd1 _5917_/X sky130_fd_sc_hd__a31o_1
X_6897_ vssd1 vssd1 vccd1 vccd1 _6897_/HI depth_mport_o[56] sky130_fd_sc_hd__conb_1
XFILLER_0_75_174 vssd1 vssd1 vccd1 vccd1 sky130_fd_sc_hd__decap_3
X_5848_ _5417_/X _5847_/Y _5922_/S vssd1 vssd1 vccd1 vccd1 _5848_/X sky130_fd_sc_hd__mux2_1
XFILLER_0_133_202 vssd1 vssd1 vccd1 vccd1 sky130_fd_sc_hd__fill_2
XFILLER_0_118_287 vssd1 vssd1 vccd1 vccd1 sky130_fd_sc_hd__fill_1
X_5779_ tex_addr_i[13] _5780_/B vssd1 vssd1 vccd1 vccd1 _5779_/X sky130_fd_sc_hd__and2_1
XFILLER_0_133_246 vssd1 vssd1 vccd1 vccd1 sky130_fd_sc_hd__decap_3
XANTENNA__4810__A _4966_/B vssd1 vssd1 vccd1 vccd1 sky130_fd_sc_hd__diode_2
XFILLER_0_133_279 vssd1 vssd1 vccd1 vccd1 sky130_fd_sc_hd__fill_1
XANTENNA_fanout94_A _5701_/A vssd1 vssd1 vccd1 vccd1 sky130_fd_sc_hd__diode_2
XFILLER_0_13_15 vssd1 vssd1 vccd1 vccd1 sky130_ef_sc_hd__decap_12
XFILLER_0_39_333 vssd1 vssd1 vccd1 vccd1 sky130_fd_sc_hd__decap_3
XFILLER_0_66_174 vssd1 vssd1 vccd1 vccd1 sky130_fd_sc_hd__decap_3
XFILLER_0_124_224 vssd1 vssd1 vccd1 vccd1 sky130_fd_sc_hd__fill_2
XFILLER_0_124_213 vssd1 vssd1 vccd1 vccd1 sky130_fd_sc_hd__fill_2
XFILLER_0_109_276 vssd1 vssd1 vccd1 vccd1 sky130_fd_sc_hd__fill_1
XFILLER_0_120_27 vssd1 vssd1 vccd1 vccd1 sky130_fd_sc_hd__fill_1
XFILLER_0_22_200 vssd1 vssd1 vccd1 vccd1 sky130_fd_sc_hd__fill_2
XFILLER_0_1_105 vssd1 vssd1 vccd1 vccd1 sky130_fd_sc_hd__decap_6
XFILLER_0_10_406 vssd1 vssd1 vccd1 vccd1 sky130_fd_sc_hd__fill_1
XFILLER_0_22_277 vssd1 vssd1 vccd1 vccd1 sky130_fd_sc_hd__fill_2
XFILLER_0_38_89 vssd1 vssd1 vccd1 vccd1 sky130_fd_sc_hd__fill_1
XFILLER_0_89_222 vssd1 vssd1 vccd1 vccd1 sky130_fd_sc_hd__fill_2
XFILLER_0_89_233 vssd1 vssd1 vccd1 vccd1 sky130_fd_sc_hd__fill_1
X_6820_ _6827_/CLK _6820_/D fanout151/X vssd1 vssd1 vccd1 vccd1 depth_mport_o[42]
+ sky130_fd_sc_hd__dfrtp_4
XANTENNA__5697__S _5784_/S vssd1 vssd1 vccd1 vccd1 sky130_fd_sc_hd__diode_2
XFILLER_0_89_288 vssd1 vssd1 vccd1 vccd1 sky130_fd_sc_hd__decap_4
X_3963_ _5081_/A _5286_/A _3952_/B _3950_/X vssd1 vssd1 vccd1 vccd1 _3966_/B sky130_fd_sc_hd__a31o_1
X_6751_ _6751_/CLK _6751_/D fanout139/X vssd1 vssd1 vccd1 vccd1 _6751_/Q sky130_fd_sc_hd__dfstp_1
XANTENNA__4333__C _4774_/B vssd1 vssd1 vccd1 vccd1 sky130_fd_sc_hd__diode_2
X_5702_ _5718_/C _5702_/B vssd1 vssd1 vccd1 vccd1 _5702_/Y sky130_fd_sc_hd__nand2_1
XFILLER_0_72_111 vssd1 vssd1 vccd1 vccd1 sky130_fd_sc_hd__fill_2
X_6682_ _6683_/CLK _6682_/D vssd1 vssd1 vccd1 vccd1 _6682_/Q sky130_fd_sc_hd__dfxtp_2
X_3894_ _6646_/Q _3894_/B vssd1 vssd1 vccd1 vccd1 _3895_/B sky130_fd_sc_hd__or2_1
XFILLER_0_115_202 vssd1 vssd1 vccd1 vccd1 sky130_fd_sc_hd__fill_1
X_5633_ hold50/A hold76/A hold27/A hold15/A vssd1 vssd1 vccd1 vccd1 _5636_/B sky130_fd_sc_hd__or4_1
X_5564_ tex_mport_o[34] _5576_/S _5563_/X _5588_/C vssd1 vssd1 vccd1 vccd1 _6591_/D
+ sky130_fd_sc_hd__a22o_1
XFILLER_0_72_188 vssd1 vssd1 vccd1 vccd1 sky130_fd_sc_hd__decap_8
XFILLER_0_130_205 vssd1 vssd1 vccd1 vccd1 sky130_fd_sc_hd__fill_1
Xhold101 _6522_/Q vssd1 vssd1 vccd1 vccd1 hold101/X sky130_fd_sc_hd__dlygate4sd3_1
X_4515_ _4515_/A _4515_/B _4563_/A vssd1 vssd1 vccd1 vccd1 _4522_/A sky130_fd_sc_hd__nand3_1
Xhold123 _6844_/Q vssd1 vssd1 vccd1 vccd1 hold123/X sky130_fd_sc_hd__dlygate4sd3_1
Xhold134 _6661_/Q vssd1 vssd1 vccd1 vccd1 hold134/X sky130_fd_sc_hd__dlygate4sd3_1
Xhold112 _6786_/Q vssd1 vssd1 vccd1 vccd1 hold112/X sky130_fd_sc_hd__dlygate4sd3_1
X_5495_ hold63/X sstream_i[86] _5502_/S vssd1 vssd1 vccd1 vccd1 _6528_/D sky130_fd_sc_hd__mux2_1
Xhold167 _6856_/Q vssd1 vssd1 vccd1 vccd1 hold167/X sky130_fd_sc_hd__dlygate4sd3_1
X_4446_ _4446_/A _4446_/B vssd1 vssd1 vccd1 vccd1 _4491_/B sky130_fd_sc_hd__xnor2_1
Xhold145 _6508_/Q vssd1 vssd1 vccd1 vccd1 hold145/X sky130_fd_sc_hd__dlygate4sd3_1
Xhold156 _6509_/Q vssd1 vssd1 vccd1 vccd1 hold156/X sky130_fd_sc_hd__dlygate4sd3_1
XFILLER_0_13_288 vssd1 vssd1 vccd1 vccd1 sky130_fd_sc_hd__decap_6
Xhold189 _6859_/Q vssd1 vssd1 vccd1 vccd1 hold189/X sky130_fd_sc_hd__dlygate4sd3_1
X_4377_ _4376_/B _4376_/C _4376_/A vssd1 vssd1 vccd1 vccd1 _4378_/C sky130_fd_sc_hd__a21bo_1
Xhold178 _6104_/X vssd1 vssd1 vccd1 vccd1 _6742_/D sky130_fd_sc_hd__dlygate4sd3_1
X_6116_ hold82/X pix_mport_o[0] _6223_/B vssd1 vssd1 vccd1 vccd1 _6752_/D sky130_fd_sc_hd__mux2_1
X_3328_ _6833_/Q vssd1 vssd1 vccd1 vccd1 _3328_/Y sky130_fd_sc_hd__inv_2
XFILLER_0_95_84 vssd1 vssd1 vccd1 vccd1 sky130_fd_sc_hd__decap_4
XTAP_450 vssd1 vccd1 sky130_fd_sc_hd__tapvpwrvgnd_1
XFILLER_0_95_95 vssd1 vssd1 vccd1 vccd1 sky130_fd_sc_hd__fill_1
XTAP_461 vssd1 vccd1 sky130_fd_sc_hd__tapvpwrvgnd_1
XTAP_472 vssd1 vccd1 sky130_fd_sc_hd__tapvpwrvgnd_1
XTAP_483 vssd1 vccd1 sky130_fd_sc_hd__tapvpwrvgnd_1
XTAP_494 vssd1 vccd1 sky130_fd_sc_hd__tapvpwrvgnd_1
XANTENNA__4077__A _4816_/A vssd1 vssd1 vccd1 vccd1 sky130_fd_sc_hd__diode_2
X_6047_ hold169/X _6038_/B _6054_/B1 vssd1 vssd1 vccd1 vccd1 _6686_/D sky130_fd_sc_hd__a21o_1
X_3259_ _6741_/Q vssd1 vssd1 vccd1 vccd1 _5418_/A sky130_fd_sc_hd__inv_2
XFILLER_0_138_316 vssd1 vssd1 vccd1 vccd1 sky130_fd_sc_hd__decap_4
XFILLER_0_95_236 vssd1 vssd1 vccd1 vccd1 sky130_fd_sc_hd__fill_2
X_6949_ vssd1 vssd1 vccd1 vccd1 _6949_/HI tex_mport_o[2] sky130_fd_sc_hd__conb_1
XFILLER_0_63_100 vssd1 vssd1 vccd1 vccd1 sky130_fd_sc_hd__fill_2
XANTENNA__5707__B2 _5384_/B vssd1 vssd1 vccd1 vccd1 sky130_fd_sc_hd__diode_2
XFILLER_0_36_369 vssd1 vssd1 vccd1 vccd1 sky130_fd_sc_hd__fill_2
XFILLER_0_121_238 vssd1 vssd1 vccd1 vccd1 sky130_fd_sc_hd__fill_2
XFILLER_0_24_36 vssd1 vssd1 vccd1 vccd1 sky130_fd_sc_hd__fill_2
XFILLER_0_86_269 vssd1 vssd1 vccd1 vccd1 sky130_fd_sc_hd__fill_1
XANTENNA__3976__D _4944_/B vssd1 vssd1 vccd1 vccd1 sky130_fd_sc_hd__diode_2
XFILLER_0_27_325 vssd1 vssd1 vccd1 vccd1 sky130_fd_sc_hd__decap_8
XFILLER_0_54_133 vssd1 vssd1 vccd1 vccd1 sky130_fd_sc_hd__fill_2
XFILLER_0_137_393 vssd1 vssd1 vccd1 vccd1 sky130_ef_sc_hd__decap_12
XANTENNA__3709__B1 _5115_/D vssd1 vssd1 vccd1 vccd1 sky130_fd_sc_hd__diode_2
XFILLER_0_35_391 vssd1 vssd1 vccd1 vccd1 sky130_fd_sc_hd__fill_1
XFILLER_0_42_339 vssd1 vssd1 vccd1 vccd1 sky130_fd_sc_hd__decap_6
XANTENNA__5980__S _6037_/S vssd1 vssd1 vccd1 vccd1 sky130_fd_sc_hd__diode_2
X_4300_ _4241_/B _4251_/X _4264_/X _4287_/X vssd1 vssd1 vccd1 vccd1 _4301_/C sky130_fd_sc_hd__a211oi_1
X_5280_ _5280_/A _5280_/B vssd1 vssd1 vccd1 vccd1 _5295_/A sky130_fd_sc_hd__xnor2_4
X_4231_ _4230_/B _4230_/C _4230_/A vssd1 vssd1 vccd1 vccd1 _4231_/Y sky130_fd_sc_hd__o21ai_1
XFILLER_0_49_88 vssd1 vssd1 vccd1 vccd1 sky130_fd_sc_hd__fill_1
X_4162_ _4161_/A _4161_/B _4161_/C vssd1 vssd1 vccd1 vccd1 _4163_/C sky130_fd_sc_hd__a21o_1
X_4093_ _4822_/B _4841_/D vssd1 vssd1 vccd1 vccd1 _4234_/A sky130_fd_sc_hd__nand2_1
XANTENNA__6316__S _6319_/S vssd1 vssd1 vccd1 vccd1 sky130_fd_sc_hd__diode_2
XFILLER_0_81_53 vssd1 vssd1 vccd1 vccd1 sky130_fd_sc_hd__decap_3
XFILLER_0_77_225 vssd1 vssd1 vccd1 vccd1 sky130_fd_sc_hd__decap_3
XANTENNA__3660__A2 _5273_/B vssd1 vssd1 vccd1 vccd1 sky130_fd_sc_hd__diode_2
X_6803_ _6863_/CLK _6803_/D vssd1 vssd1 vccd1 vccd1 _6803_/Q sky130_fd_sc_hd__dfxtp_1
XFILLER_0_77_269 vssd1 vssd1 vccd1 vccd1 sky130_fd_sc_hd__decap_4
X_4995_ _4890_/B _4890_/Y _4992_/X _4994_/Y vssd1 vssd1 vccd1 vccd1 _5235_/A sky130_fd_sc_hd__a211oi_2
XFILLER_0_92_217 vssd1 vssd1 vccd1 vccd1 sky130_fd_sc_hd__fill_2
X_6734_ _6734_/CLK _6734_/D fanout144/X vssd1 vssd1 vccd1 vccd1 _6734_/Q sky130_fd_sc_hd__dfstp_1
XANTENNA_fanout144_A fanout145/X vssd1 vssd1 vccd1 vccd1 sky130_fd_sc_hd__diode_2
XFILLER_0_14_80 vssd1 vssd1 vccd1 vccd1 sky130_fd_sc_hd__fill_2
X_3946_ _5801_/A _4971_/D _4970_/B _5787_/A vssd1 vssd1 vccd1 vccd1 _3947_/C sky130_fd_sc_hd__a22o_1
XFILLER_0_128_382 vssd1 vssd1 vccd1 vccd1 sky130_ef_sc_hd__decap_12
XFILLER_0_85_291 vssd1 vssd1 vccd1 vccd1 sky130_fd_sc_hd__fill_2
XFILLER_0_90_3 vssd1 vssd1 vccd1 vccd1 sky130_fd_sc_hd__decap_3
X_3877_ _3877_/A _3877_/B vssd1 vssd1 vccd1 vccd1 _3889_/A sky130_fd_sc_hd__xnor2_2
XFILLER_0_33_306 vssd1 vssd1 vccd1 vccd1 sky130_fd_sc_hd__fill_2
XFILLER_0_45_188 vssd1 vssd1 vccd1 vccd1 sky130_fd_sc_hd__fill_2
X_6665_ _6892_/CLK _6665_/D vssd1 vssd1 vccd1 vccd1 _6665_/Q sky130_fd_sc_hd__dfxtp_1
X_6596_ _6802_/CLK _6596_/D fanout142/X vssd1 vssd1 vccd1 vccd1 tex_mport_o[39] sky130_fd_sc_hd__dfrtp_4
X_5616_ _3255_/Y _6518_/Q _6517_/Q _3256_/Y _5615_/X vssd1 vssd1 vccd1 vccd1 _5621_/A
+ sky130_fd_sc_hd__a221o_1
XFILLER_0_5_252 vssd1 vssd1 vccd1 vccd1 sky130_fd_sc_hd__fill_2
X_5547_ depth_mport_o[22] hold184/X _5556_/S vssd1 vssd1 vccd1 vccd1 _6578_/D sky130_fd_sc_hd__mux2_1
XFILLER_0_5_274 vssd1 vssd1 vccd1 vccd1 sky130_fd_sc_hd__fill_2
X_5478_ hold140/X sstream_i[69] _6501_/S vssd1 vssd1 vccd1 vccd1 _6511_/D sky130_fd_sc_hd__mux2_1
X_4429_ _4429_/A _4429_/B _4429_/C vssd1 vssd1 vccd1 vccd1 _4473_/A sky130_fd_sc_hd__nand3_1
XANTENNA__4428__A1 _4942_/A vssd1 vssd1 vccd1 vccd1 sky130_fd_sc_hd__diode_2
XTAP_280 vssd1 vccd1 sky130_fd_sc_hd__tapvpwrvgnd_1
XTAP_291 vssd1 vccd1 sky130_fd_sc_hd__tapvpwrvgnd_1
XANTENNA__4428__B2 _4942_/B vssd1 vssd1 vccd1 vccd1 sky130_fd_sc_hd__diode_2
XANTENNA_fanout57_A _4776_/A vssd1 vssd1 vccd1 vccd1 sky130_fd_sc_hd__diode_2
XFILLER_0_68_225 vssd1 vssd1 vccd1 vccd1 sky130_fd_sc_hd__fill_2
XFILLER_0_138_113 vssd1 vssd1 vccd1 vccd1 sky130_fd_sc_hd__fill_2
XFILLER_0_138_157 vssd1 vssd1 vccd1 vccd1 sky130_fd_sc_hd__fill_2
Xfanout40 _6681_/Q vssd1 vssd1 vccd1 vccd1 _5106_/B sky130_fd_sc_hd__buf_2
XFILLER_0_36_111 vssd1 vssd1 vccd1 vccd1 sky130_fd_sc_hd__fill_1
Xfanout73 _4841_/D vssd1 vssd1 vccd1 vccd1 _4637_/D sky130_fd_sc_hd__buf_4
XFILLER_0_76_291 vssd1 vssd1 vccd1 vccd1 sky130_fd_sc_hd__decap_4
Xfanout62 _6670_/Q vssd1 vssd1 vccd1 vccd1 _4433_/D sky130_fd_sc_hd__buf_4
Xfanout51 _5083_/A vssd1 vssd1 vccd1 vccd1 _3959_/B sky130_fd_sc_hd__buf_4
XFILLER_0_119_393 vssd1 vssd1 vccd1 vccd1 sky130_ef_sc_hd__decap_12
XFILLER_0_91_250 vssd1 vssd1 vccd1 vccd1 sky130_fd_sc_hd__fill_2
Xfanout84 _5081_/D vssd1 vssd1 vccd1 vccd1 _5276_/A sky130_fd_sc_hd__buf_4
Xfanout95 tex_width_i[6] vssd1 vssd1 vccd1 vccd1 _5701_/A sky130_fd_sc_hd__clkbuf_8
XFILLER_0_134_363 vssd1 vssd1 vccd1 vccd1 sky130_fd_sc_hd__fill_1
XFILLER_0_10_27 vssd1 vssd1 vccd1 vccd1 sky130_fd_sc_hd__fill_1
XFILLER_0_32_394 vssd1 vssd1 vccd1 vccd1 sky130_ef_sc_hd__decap_12
XFILLER_0_19_69 vssd1 vssd1 vccd1 vccd1 sky130_fd_sc_hd__decap_4
XFILLER_0_35_57 vssd1 vssd1 vccd1 vccd1 sky130_fd_sc_hd__decap_3
XANTENNA__4445__A _4488_/A vssd1 vssd1 vccd1 vccd1 sky130_fd_sc_hd__diode_2
XANTENNA_clkbuf_leaf_17_clk_i_A clkbuf_2_3__f_clk_i/X vssd1 vssd1 vccd1 vccd1 sky130_fd_sc_hd__diode_2
XFILLER_0_74_217 vssd1 vssd1 vccd1 vccd1 sky130_fd_sc_hd__decap_3
XANTENNA__5975__S _6037_/S vssd1 vssd1 vccd1 vccd1 sky130_fd_sc_hd__diode_2
X_3800_ _3815_/A vssd1 vssd1 vccd1 vccd1 _3800_/Y sky130_fd_sc_hd__inv_2
X_4780_ _4971_/B _5766_/A _4966_/C _4971_/D vssd1 vssd1 vccd1 vccd1 _4782_/B sky130_fd_sc_hd__a22o_1
XFILLER_0_129_3 vssd1 vssd1 vccd1 vccd1 sky130_fd_sc_hd__decap_3
XFILLER_0_117_319 vssd1 vssd1 vccd1 vccd1 sky130_fd_sc_hd__decap_3
X_3731_ _3755_/A _3731_/B vssd1 vssd1 vccd1 vccd1 _3733_/C sky130_fd_sc_hd__nor2_1
XFILLER_0_27_133 vssd1 vssd1 vccd1 vccd1 sky130_fd_sc_hd__fill_2
XFILLER_0_82_272 vssd1 vssd1 vccd1 vccd1 sky130_fd_sc_hd__fill_1
XFILLER_0_70_401 vssd1 vssd1 vccd1 vccd1 sky130_fd_sc_hd__decap_6
XANTENNA__5276__A _5276_/A vssd1 vssd1 vccd1 vccd1 sky130_fd_sc_hd__diode_2
XFILLER_0_27_177 vssd1 vssd1 vccd1 vccd1 sky130_fd_sc_hd__decap_6
XFILLER_0_51_89 vssd1 vssd1 vccd1 vccd1 sky130_fd_sc_hd__fill_2
X_6450_ hold152/X sstream_i[8] _6450_/S vssd1 vssd1 vccd1 vccd1 _6841_/D sky130_fd_sc_hd__mux2_1
X_3662_ _5051_/A _6683_/Q vssd1 vssd1 vccd1 vccd1 _3738_/B sky130_fd_sc_hd__nand2_1
XFILLER_0_125_385 vssd1 vssd1 vccd1 vccd1 sky130_fd_sc_hd__decap_6
X_6381_ _6381_/A _6381_/B vssd1 vssd1 vccd1 vccd1 _6392_/B sky130_fd_sc_hd__and2_1
X_5401_ _6733_/Q _5401_/B vssd1 vssd1 vccd1 vccd1 _5402_/D sky130_fd_sc_hd__xnor2_1
X_3593_ _3593_/A _3593_/B vssd1 vssd1 vccd1 vccd1 _3605_/A sky130_fd_sc_hd__nor2_1
XFILLER_0_30_309 vssd1 vssd1 vccd1 vccd1 sky130_fd_sc_hd__decap_4
X_5332_ _5332_/A _5332_/B vssd1 vssd1 vccd1 vccd1 _5333_/B sky130_fd_sc_hd__xnor2_2
X_5263_ _5263_/A _5336_/C vssd1 vssd1 vccd1 vccd1 _5441_/B sky130_fd_sc_hd__or2_1
XANTENNA__5855__B1 _5599_/A vssd1 vssd1 vccd1 vccd1 sky130_fd_sc_hd__diode_2
X_4214_ _4219_/A _4219_/B vssd1 vssd1 vccd1 vccd1 _4214_/X sky130_fd_sc_hd__and2_1
X_5194_ _5194_/A _5194_/B vssd1 vssd1 vccd1 vccd1 _5197_/B sky130_fd_sc_hd__xnor2_1
X_4145_ _4136_/X _4140_/X _4170_/B _4144_/X vssd1 vssd1 vccd1 vccd1 _4145_/X sky130_fd_sc_hd__o211a_1
X_4076_ _4816_/A _4638_/A _4043_/A _4041_/B vssd1 vssd1 vccd1 vccd1 _4078_/A sky130_fd_sc_hd__a31o_1
XFILLER_0_92_85 vssd1 vssd1 vccd1 vccd1 sky130_fd_sc_hd__decap_3
XFILLER_0_108_319 vssd1 vssd1 vccd1 vccd1 sky130_fd_sc_hd__fill_2
X_4978_ _4978_/A _4978_/B _4978_/C vssd1 vssd1 vccd1 vccd1 _4981_/A sky130_fd_sc_hd__nand3_2
X_6717_ _6853_/CLK _6717_/D vssd1 vssd1 vccd1 vccd1 hold84/A sky130_fd_sc_hd__dfxtp_1
XFILLER_0_18_166 vssd1 vssd1 vccd1 vccd1 sky130_fd_sc_hd__fill_2
X_3929_ _3929_/A _3929_/B vssd1 vssd1 vccd1 vccd1 _3932_/B sky130_fd_sc_hd__xor2_2
XFILLER_0_116_352 vssd1 vssd1 vccd1 vccd1 sky130_fd_sc_hd__fill_2
XFILLER_0_18_188 vssd1 vssd1 vccd1 vccd1 sky130_fd_sc_hd__decap_8
X_6648_ _6747_/CLK _6648_/D _5937_/A vssd1 vssd1 vccd1 vccd1 _6648_/Q sky130_fd_sc_hd__dfstp_1
XFILLER_0_131_311 vssd1 vssd1 vccd1 vccd1 sky130_fd_sc_hd__fill_2
XFILLER_0_116_396 vssd1 vssd1 vccd1 vccd1 sky130_fd_sc_hd__decap_8
X_6579_ _6812_/CLK _6579_/D _6320_/C vssd1 vssd1 vccd1 vccd1 depth_mport_o[23] sky130_fd_sc_hd__dfrtp_4
XFILLER_0_88_309 vssd1 vssd1 vccd1 vccd1 sky130_fd_sc_hd__fill_2
XTAP_1232 vssd1 vccd1 sky130_fd_sc_hd__tapvpwrvgnd_1
XTAP_1221 vssd1 vccd1 sky130_fd_sc_hd__tapvpwrvgnd_1
XTAP_1210 vssd1 vccd1 sky130_fd_sc_hd__tapvpwrvgnd_1
XFILLER_0_96_353 vssd1 vssd1 vccd1 vccd1 sky130_fd_sc_hd__decap_8
XTAP_1254 vssd1 vccd1 sky130_fd_sc_hd__tapvpwrvgnd_1
XTAP_1243 vssd1 vccd1 sky130_fd_sc_hd__tapvpwrvgnd_1
XFILLER_0_126_149 vssd1 vssd1 vccd1 vccd1 sky130_fd_sc_hd__fill_2
XFILLER_0_21_15 vssd1 vssd1 vccd1 vccd1 sky130_ef_sc_hd__decap_12
XFILLER_0_21_37 vssd1 vssd1 vccd1 vccd1 sky130_fd_sc_hd__fill_2
XFILLER_0_24_136 vssd1 vssd1 vccd1 vccd1 sky130_fd_sc_hd__fill_2
XFILLER_0_24_147 vssd1 vssd1 vccd1 vccd1 sky130_fd_sc_hd__decap_3
XFILLER_0_122_355 vssd1 vssd1 vccd1 vccd1 sky130_fd_sc_hd__fill_2
XANTENNA__6374__B _6543_/Q vssd1 vssd1 vccd1 vccd1 sky130_fd_sc_hd__diode_2
XFILLER_0_79_309 vssd1 vssd1 vccd1 vccd1 sky130_ef_sc_hd__decap_12
XFILLER_0_99_180 vssd1 vssd1 vccd1 vccd1 sky130_fd_sc_hd__fill_1
X_5950_ _5949_/X _5938_/X _3278_/Y _6880_/Q vssd1 vssd1 vccd1 vccd1 _5950_/X sky130_fd_sc_hd__a2bb2o_1
X_4901_ _4912_/A _4900_/C _4900_/A vssd1 vssd1 vccd1 vccd1 _4902_/B sky130_fd_sc_hd__a21o_1
XFILLER_0_1_69 vssd1 vssd1 vccd1 vccd1 sky130_ef_sc_hd__decap_12
XANTENNA__6014__A0 _5118_/B vssd1 vssd1 vccd1 vccd1 sky130_fd_sc_hd__diode_2
X_5881_ tex_addr_i[26] _5919_/B vssd1 vssd1 vccd1 vccd1 _5883_/A sky130_fd_sc_hd__or2_1
X_4832_ _4842_/A tex_width_i[15] _4832_/C _4841_/D vssd1 vssd1 vccd1 vccd1 _4835_/A
+ sky130_fd_sc_hd__nand4_1
XFILLER_0_117_149 vssd1 vssd1 vccd1 vccd1 sky130_fd_sc_hd__fill_2
XANTENNA__5718__B _5718_/B vssd1 vssd1 vccd1 vccd1 sky130_fd_sc_hd__diode_2
XFILLER_0_7_347 vssd1 vssd1 vccd1 vccd1 sky130_fd_sc_hd__fill_2
X_4763_ _4754_/X _4884_/A vssd1 vssd1 vccd1 vccd1 _4771_/A sky130_fd_sc_hd__and2b_1
X_4694_ _5368_/A _4693_/B _4679_/X vssd1 vssd1 vccd1 vccd1 _5367_/B sky130_fd_sc_hd__a21o_1
X_6502_ _6834_/CLK _6502_/D vssd1 vssd1 vccd1 vccd1 hold47/A sky130_fd_sc_hd__dfxtp_1
X_3714_ _5081_/B _5273_/A _5272_/A _3959_/B vssd1 vssd1 vccd1 vccd1 _3716_/A sky130_fd_sc_hd__a22o_1
X_6433_ _6546_/Q _6433_/B vssd1 vssd1 vccd1 vccd1 _6433_/Y sky130_fd_sc_hd__nor2_1
XFILLER_0_15_169 vssd1 vssd1 vccd1 vccd1 sky130_fd_sc_hd__decap_4
XANTENNA__4060__D _4970_/B vssd1 vssd1 vccd1 vccd1 sky130_fd_sc_hd__diode_2
XFILLER_0_11_81 vssd1 vssd1 vccd1 vccd1 sky130_ef_sc_hd__decap_12
X_3645_ _5320_/A _5300_/B _3645_/C _3645_/D vssd1 vssd1 vccd1 vccd1 _3645_/X sky130_fd_sc_hd__and4_1
X_6364_ hold98/A hold53/A vssd1 vssd1 vccd1 vccd1 _6365_/C sky130_fd_sc_hd__nor2_1
XFILLER_0_113_388 vssd1 vssd1 vccd1 vccd1 sky130_fd_sc_hd__decap_4
XFILLER_0_11_320 vssd1 vssd1 vccd1 vccd1 sky130_fd_sc_hd__fill_2
X_3576_ _3578_/B _3593_/A _3578_/A vssd1 vssd1 vccd1 vccd1 _3580_/A sky130_fd_sc_hd__o21a_1
XANTENNA_fanout107_A _5093_/A vssd1 vssd1 vccd1 vccd1 sky130_fd_sc_hd__diode_2
XFILLER_0_23_191 vssd1 vssd1 vccd1 vccd1 sky130_fd_sc_hd__fill_2
X_6295_ _6783_/Q _6784_/Q _3335_/B _6294_/X vssd1 vssd1 vccd1 vccd1 _6295_/X sky130_fd_sc_hd__a211o_1
X_5315_ _5299_/A _6690_/Q _3473_/X _3474_/X _6692_/Q vssd1 vssd1 vccd1 vccd1 _5316_/B
+ sky130_fd_sc_hd__a32o_1
X_5246_ _5215_/B _5214_/Y _5245_/Y _4013_/X vssd1 vssd1 vccd1 vccd1 _5250_/B sky130_fd_sc_hd__o211a_1
XANTENNA__5828__B1 _5599_/A vssd1 vssd1 vccd1 vccd1 sky130_fd_sc_hd__diode_2
Xhold16 hold16/A vssd1 vssd1 vccd1 vccd1 hold16/X sky130_fd_sc_hd__dlygate4sd3_1
Xhold38 hold38/A vssd1 vssd1 vccd1 vccd1 hold38/X sky130_fd_sc_hd__dlygate4sd3_1
Xhold27 hold27/A vssd1 vssd1 vccd1 vccd1 hold27/X sky130_fd_sc_hd__dlygate4sd3_1
XANTENNA__4069__B _4776_/A vssd1 vssd1 vccd1 vccd1 sky130_fd_sc_hd__diode_2
Xhold49 hold49/A vssd1 vssd1 vccd1 vccd1 hold49/X sky130_fd_sc_hd__dlygate4sd3_1
X_5177_ _5177_/A _5177_/B _5177_/C vssd1 vssd1 vccd1 vccd1 _5177_/Y sky130_fd_sc_hd__nor3_2
X_4128_ _4128_/A _4128_/B vssd1 vssd1 vccd1 vccd1 _4130_/B sky130_fd_sc_hd__xnor2_1
X_4059_ _4052_/A _4052_/C _4052_/B vssd1 vssd1 vccd1 vccd1 _4065_/B sky130_fd_sc_hd__a21o_1
XANTENNA__3420__C _5273_/B vssd1 vssd1 vccd1 vccd1 sky130_fd_sc_hd__diode_2
XFILLER_0_78_397 vssd1 vssd1 vccd1 vccd1 sky130_fd_sc_hd__decap_8
XFILLER_0_61_242 vssd1 vssd1 vccd1 vccd1 sky130_fd_sc_hd__fill_2
XFILLER_0_21_106 vssd1 vssd1 vccd1 vccd1 sky130_fd_sc_hd__decap_3
XFILLER_0_104_377 vssd1 vssd1 vccd1 vccd1 sky130_ef_sc_hd__decap_12
XFILLER_0_14_191 vssd1 vssd1 vccd1 vccd1 sky130_fd_sc_hd__fill_2
XFILLER_0_16_15 vssd1 vssd1 vccd1 vccd1 sky130_ef_sc_hd__decap_12
XANTENNA__4426__C _6663_/Q vssd1 vssd1 vccd1 vccd1 sky130_fd_sc_hd__diode_2
XFILLER_0_123_16 vssd1 vssd1 vccd1 vccd1 sky130_fd_sc_hd__decap_3
XTAP_1040 vssd1 vccd1 sky130_fd_sc_hd__tapvpwrvgnd_1
XFILLER_0_84_312 vssd1 vssd1 vccd1 vccd1 sky130_fd_sc_hd__fill_2
XFILLER_0_123_27 vssd1 vssd1 vccd1 vccd1 sky130_fd_sc_hd__decap_4
XTAP_1073 vssd1 vccd1 sky130_fd_sc_hd__tapvpwrvgnd_1
XTAP_1062 vssd1 vccd1 sky130_fd_sc_hd__tapvpwrvgnd_1
XTAP_1051 vssd1 vccd1 sky130_fd_sc_hd__tapvpwrvgnd_1
XFILLER_0_29_239 vssd1 vssd1 vccd1 vccd1 sky130_fd_sc_hd__fill_1
XFILLER_0_32_36 vssd1 vssd1 vccd1 vccd1 sky130_fd_sc_hd__fill_2
XTAP_1095 vssd1 vccd1 sky130_fd_sc_hd__tapvpwrvgnd_1
XTAP_1084 vssd1 vccd1 sky130_fd_sc_hd__tapvpwrvgnd_1
XFILLER_0_32_69 vssd1 vssd1 vccd1 vccd1 sky130_fd_sc_hd__fill_2
XFILLER_0_114_108 vssd1 vssd1 vccd1 vccd1 sky130_fd_sc_hd__decap_4
XFILLER_0_4_306 vssd1 vssd1 vccd1 vccd1 sky130_fd_sc_hd__fill_2
XFILLER_0_4_317 vssd1 vssd1 vccd1 vccd1 sky130_fd_sc_hd__fill_2
XFILLER_0_52_253 vssd1 vssd1 vccd1 vccd1 sky130_fd_sc_hd__decap_3
XFILLER_0_40_404 vssd1 vssd1 vccd1 vccd1 sky130_fd_sc_hd__decap_3
X_3430_ _5290_/A _5327_/A _6690_/Q _6691_/Q vssd1 vssd1 vccd1 vccd1 _3450_/A sky130_fd_sc_hd__and4_1
XFILLER_0_110_325 vssd1 vssd1 vccd1 vccd1 sky130_fd_sc_hd__fill_2
X_3361_ _5049_/A _5296_/B _5276_/B _5292_/A vssd1 vssd1 vccd1 vccd1 _3365_/D sky130_fd_sc_hd__a22o_1
XANTENNA__5273__B _5273_/B vssd1 vssd1 vccd1 vccd1 sky130_fd_sc_hd__diode_2
X_6080_ hold57/X _6659_/Q _6315_/S vssd1 vssd1 vccd1 vccd1 hold58/A sky130_fd_sc_hd__mux2_1
XTAP_835 vssd1 vccd1 sky130_fd_sc_hd__tapvpwrvgnd_1
XTAP_824 vssd1 vccd1 sky130_fd_sc_hd__tapvpwrvgnd_1
XTAP_813 vssd1 vccd1 sky130_fd_sc_hd__tapvpwrvgnd_1
XTAP_802 vssd1 vccd1 sky130_fd_sc_hd__tapvpwrvgnd_1
XFILLER_0_20_194 vssd1 vssd1 vccd1 vccd1 sky130_fd_sc_hd__fill_2
X_5100_ _5100_/A _5100_/B _5100_/C vssd1 vssd1 vccd1 vccd1 _5100_/X sky130_fd_sc_hd__and3_1
XTAP_868 vssd1 vccd1 sky130_fd_sc_hd__tapvpwrvgnd_1
XTAP_857 vssd1 vccd1 sky130_fd_sc_hd__tapvpwrvgnd_1
XTAP_846 vssd1 vccd1 sky130_fd_sc_hd__tapvpwrvgnd_1
X_5031_ _5022_/X _5026_/Y _5028_/Y _5030_/Y vssd1 vssd1 vccd1 vccd1 _5031_/X sky130_fd_sc_hd__o211a_1
X_3292_ tex_height_i[1] vssd1 vssd1 vccd1 vccd1 _5952_/B sky130_fd_sc_hd__inv_2
XTAP_879 vssd1 vccd1 sky130_fd_sc_hd__tapvpwrvgnd_1
XFILLER_0_32_8 vssd1 vssd1 vccd1 vccd1 sky130_fd_sc_hd__fill_2
XANTENNA__4617__B _4658_/D vssd1 vssd1 vccd1 vccd1 sky130_fd_sc_hd__diode_2
XFILLER_0_79_117 vssd1 vssd1 vccd1 vccd1 sky130_fd_sc_hd__fill_2
XFILLER_0_73_65 vssd1 vssd1 vccd1 vccd1 sky130_fd_sc_hd__decap_3
XANTENNA__3521__B _3961_/A vssd1 vssd1 vccd1 vccd1 sky130_fd_sc_hd__diode_2
X_6982_ vssd1 vssd1 vccd1 vccd1 _6982_/HI tex_mport_o[68] sky130_fd_sc_hd__conb_1
X_5933_ _5784_/S _3262_/Y hold71/A vssd1 vssd1 vccd1 vccd1 _5933_/Y sky130_fd_sc_hd__a21oi_1
XFILLER_0_94_109 vssd1 vssd1 vccd1 vccd1 sky130_fd_sc_hd__fill_2
XFILLER_0_87_150 vssd1 vssd1 vccd1 vccd1 sky130_fd_sc_hd__fill_2
X_5864_ _5864_/A vssd1 vssd1 vccd1 vccd1 _5864_/Y sky130_fd_sc_hd__inv_2
XFILLER_0_7_111 vssd1 vssd1 vccd1 vccd1 sky130_fd_sc_hd__fill_1
X_4815_ _5115_/D _4958_/B _5118_/B _4814_/D vssd1 vssd1 vccd1 vccd1 _4816_/D sky130_fd_sc_hd__a22o_1
XANTENNA__3249__A _5687_/B vssd1 vssd1 vccd1 vccd1 sky130_fd_sc_hd__diode_2
X_5795_ _5782_/A _5782_/B _5779_/X _5781_/B _5794_/A vssd1 vssd1 vccd1 vccd1 _5807_/B
+ sky130_fd_sc_hd__o311a_4
XFILLER_0_7_155 vssd1 vssd1 vccd1 vccd1 sky130_fd_sc_hd__fill_2
XFILLER_0_28_283 vssd1 vssd1 vccd1 vccd1 sky130_fd_sc_hd__fill_2
XFILLER_0_113_93 vssd1 vssd1 vccd1 vccd1 sky130_fd_sc_hd__fill_2
X_4746_ _4794_/B _5687_/B vssd1 vssd1 vccd1 vccd1 _4748_/B sky130_fd_sc_hd__and2_1
XFILLER_0_22_91 vssd1 vssd1 vccd1 vccd1 sky130_fd_sc_hd__fill_2
XFILLER_0_113_130 vssd1 vssd1 vccd1 vccd1 sky130_fd_sc_hd__decap_4
X_4677_ _4678_/A _4678_/D vssd1 vssd1 vccd1 vccd1 _4680_/B sky130_fd_sc_hd__nand2_1
X_6416_ _6416_/A _6416_/B _6416_/C _6416_/D vssd1 vssd1 vccd1 vccd1 _6427_/B sky130_fd_sc_hd__or4_1
XFILLER_0_113_163 vssd1 vssd1 vccd1 vccd1 sky130_fd_sc_hd__fill_1
X_3628_ _5308_/B _5277_/B _5115_/D _5118_/B vssd1 vssd1 vccd1 vccd1 _3628_/X sky130_fd_sc_hd__and4_1
X_6347_ _6346_/B _6346_/C _6555_/Q vssd1 vssd1 vccd1 vccd1 _6348_/B sky130_fd_sc_hd__a21oi_1
XFILLER_0_113_196 vssd1 vssd1 vccd1 vccd1 sky130_fd_sc_hd__decap_3
XFILLER_0_113_185 vssd1 vssd1 vccd1 vccd1 sky130_fd_sc_hd__decap_3
XFILLER_0_11_161 vssd1 vssd1 vccd1 vccd1 sky130_fd_sc_hd__decap_4
X_3559_ _3560_/A _3559_/B _3559_/C vssd1 vssd1 vccd1 vccd1 _3560_/B sky130_fd_sc_hd__nor3_1
X_6278_ _6234_/X _6243_/X _6271_/X _6277_/X vssd1 vssd1 vccd1 vccd1 _6289_/A sky130_fd_sc_hd__o2bb2a_1
X_5229_ _5229_/A _5229_/B _5229_/C vssd1 vssd1 vccd1 vccd1 _5234_/A sky130_fd_sc_hd__nand3_1
XANTENNA__4527__B _4527_/B vssd1 vssd1 vccd1 vccd1 sky130_fd_sc_hd__diode_2
XANTENNA__4252__A2 _4527_/B vssd1 vssd1 vccd1 vccd1 sky130_fd_sc_hd__diode_2
XFILLER_0_78_150 vssd1 vssd1 vccd1 vccd1 sky130_fd_sc_hd__fill_2
XANTENNA__4788__B1 _5064_/B vssd1 vssd1 vccd1 vccd1 sky130_fd_sc_hd__diode_2
XFILLER_0_78_194 vssd1 vssd1 vccd1 vccd1 sky130_fd_sc_hd__fill_2
XFILLER_0_78_183 vssd1 vssd1 vccd1 vccd1 sky130_fd_sc_hd__fill_2
XPHY_134 vssd1 vssd1 vccd1 vccd1 sky130_fd_sc_hd__decap_3
XPHY_101 vssd1 vssd1 vccd1 vccd1 sky130_fd_sc_hd__decap_3
XPHY_112 vssd1 vssd1 vccd1 vccd1 sky130_fd_sc_hd__decap_3
XPHY_123 vssd1 vssd1 vccd1 vccd1 sky130_fd_sc_hd__decap_3
XPHY_167 vssd1 vssd1 vccd1 vccd1 sky130_fd_sc_hd__decap_3
XPHY_156 vssd1 vssd1 vccd1 vccd1 sky130_fd_sc_hd__decap_3
XPHY_145 vssd1 vssd1 vccd1 vccd1 sky130_fd_sc_hd__decap_3
XFILLER_0_66_389 vssd1 vssd1 vccd1 vccd1 sky130_ef_sc_hd__decap_12
XPHY_189 vssd1 vssd1 vccd1 vccd1 sky130_fd_sc_hd__decap_3
XPHY_178 vssd1 vssd1 vccd1 vccd1 sky130_fd_sc_hd__decap_3
XANTENNA_90 sstream_i[3] vssd1 vssd1 vccd1 vccd1 sky130_fd_sc_hd__diode_2
XFILLER_0_34_264 vssd1 vssd1 vccd1 vccd1 sky130_fd_sc_hd__fill_2
XFILLER_0_104_185 vssd1 vssd1 vccd1 vccd1 sky130_fd_sc_hd__decap_3
XANTENNA__5093__B _5273_/B vssd1 vssd1 vccd1 vccd1 sky130_fd_sc_hd__diode_2
XFILLER_0_118_38 vssd1 vssd1 vccd1 vccd1 sky130_fd_sc_hd__fill_2
XANTENNA__4156__C _4774_/B vssd1 vssd1 vccd1 vccd1 sky130_fd_sc_hd__diode_2
XFILLER_0_134_37 vssd1 vssd1 vccd1 vccd1 sky130_fd_sc_hd__decap_3
XFILLER_0_69_161 vssd1 vssd1 vccd1 vccd1 sky130_fd_sc_hd__decap_6
XPHY_3 vssd1 vssd1 vccd1 vccd1 sky130_fd_sc_hd__decap_3
XFILLER_0_84_120 vssd1 vssd1 vccd1 vccd1 sky130_fd_sc_hd__fill_1
Xclkbuf_leaf_19_clk_i clkbuf_2_3__f_clk_i/X vssd1 vssd1 vccd1 vccd1 _6633_/CLK sky130_fd_sc_hd__clkbuf_16
X_4600_ _4600_/A _4600_/B vssd1 vssd1 vccd1 vccd1 _4628_/B sky130_fd_sc_hd__xnor2_1
XFILLER_0_84_197 vssd1 vssd1 vccd1 vccd1 sky130_fd_sc_hd__fill_2
XFILLER_0_84_175 vssd1 vssd1 vccd1 vccd1 sky130_fd_sc_hd__fill_2
XFILLER_0_127_299 vssd1 vssd1 vccd1 vccd1 sky130_fd_sc_hd__fill_2
XFILLER_0_111_3 vssd1 vssd1 vccd1 vccd1 sky130_fd_sc_hd__decap_6
X_5580_ _5408_/B tex_mport_o[47] _5601_/S vssd1 vssd1 vccd1 vccd1 _6604_/D sky130_fd_sc_hd__mux2_1
X_4531_ _5666_/A _4582_/D _4532_/A vssd1 vssd1 vccd1 vccd1 _4531_/X sky130_fd_sc_hd__and3_1
XFILLER_0_25_286 vssd1 vssd1 vccd1 vccd1 sky130_fd_sc_hd__fill_2
X_4462_ _4418_/B _4418_/C _4418_/A vssd1 vssd1 vccd1 vccd1 _4709_/B sky130_fd_sc_hd__a21oi_1
XFILLER_0_80_381 vssd1 vssd1 vccd1 vccd1 sky130_ef_sc_hd__decap_12
XFILLER_0_40_212 vssd1 vssd1 vccd1 vccd1 sky130_fd_sc_hd__fill_2
X_6201_ _6202_/A _6202_/B vssd1 vssd1 vccd1 vccd1 _6208_/B sky130_fd_sc_hd__or2_1
X_3413_ _5308_/A _3870_/A _5273_/A _5272_/A vssd1 vssd1 vccd1 vccd1 _3415_/A sky130_fd_sc_hd__nand4_1
XFILLER_0_7_57 vssd1 vssd1 vccd1 vccd1 sky130_ef_sc_hd__decap_12
XFILLER_0_110_155 vssd1 vssd1 vccd1 vccd1 sky130_fd_sc_hd__decap_3
X_4393_ _4392_/A _4392_/C _4423_/A vssd1 vssd1 vccd1 vccd1 _4394_/C sky130_fd_sc_hd__a21o_1
XFILLER_0_68_76 vssd1 vssd1 vccd1 vccd1 sky130_fd_sc_hd__fill_2
X_6132_ pix_mport_o[38] _6207_/B _6130_/X _6131_/Y vssd1 vssd1 vccd1 vccd1 _6766_/D
+ sky130_fd_sc_hd__a22o_1
X_3344_ _3425_/A _5272_/B _5320_/A _3344_/D vssd1 vssd1 vccd1 vccd1 _3425_/B sky130_fd_sc_hd__and4b_1
XTAP_610 vssd1 vccd1 sky130_fd_sc_hd__tapvpwrvgnd_1
XTAP_621 vssd1 vccd1 sky130_fd_sc_hd__tapvpwrvgnd_1
XTAP_632 vssd1 vccd1 sky130_fd_sc_hd__tapvpwrvgnd_1
XTAP_643 vssd1 vccd1 sky130_fd_sc_hd__tapvpwrvgnd_1
X_6063_ hold11/X _6546_/Q _6072_/S vssd1 vssd1 vccd1 vccd1 hold12/A sky130_fd_sc_hd__mux2_1
XANTENNA__6319__S _6319_/S vssd1 vssd1 vccd1 vccd1 sky130_fd_sc_hd__diode_2
X_3275_ _6511_/Q vssd1 vssd1 vccd1 vccd1 _3275_/Y sky130_fd_sc_hd__inv_2
XTAP_654 vssd1 vccd1 sky130_fd_sc_hd__tapvpwrvgnd_1
XTAP_665 vssd1 vccd1 sky130_fd_sc_hd__tapvpwrvgnd_1
XTAP_676 vssd1 vccd1 sky130_fd_sc_hd__tapvpwrvgnd_1
X_5014_ _5015_/B _5015_/A vssd1 vssd1 vccd1 vccd1 _5014_/X sky130_fd_sc_hd__and2b_1
XTAP_687 vssd1 vccd1 sky130_fd_sc_hd__tapvpwrvgnd_1
XTAP_698 vssd1 vccd1 sky130_fd_sc_hd__tapvpwrvgnd_1
XFILLER_0_108_93 vssd1 vssd1 vccd1 vccd1 sky130_fd_sc_hd__fill_1
XFILLER_0_16_3 vssd1 vssd1 vccd1 vccd1 sky130_ef_sc_hd__decap_12
XFILLER_0_17_80 vssd1 vssd1 vccd1 vccd1 sky130_fd_sc_hd__decap_3
X_6965_ vssd1 vssd1 vccd1 vccd1 _6965_/HI tex_mport_o[18] sky130_fd_sc_hd__conb_1
X_5916_ _5916_/A _5916_/B _5916_/C vssd1 vssd1 vccd1 vccd1 _5916_/X sky130_fd_sc_hd__or3_1
XFILLER_0_48_334 vssd1 vssd1 vccd1 vccd1 sky130_fd_sc_hd__fill_1
X_6896_ vssd1 vssd1 vccd1 vccd1 _6896_/HI depth_mport_o[55] sky130_fd_sc_hd__conb_1
XFILLER_0_63_304 vssd1 vssd1 vccd1 vccd1 sky130_fd_sc_hd__fill_2
XFILLER_0_63_337 vssd1 vssd1 vccd1 vccd1 sky130_fd_sc_hd__decap_3
XANTENNA__5893__S _5922_/S vssd1 vssd1 vccd1 vccd1 sky130_fd_sc_hd__diode_2
X_5847_ _5863_/B _5847_/B vssd1 vssd1 vccd1 vccd1 _5847_/Y sky130_fd_sc_hd__xnor2_1
XFILLER_0_133_225 vssd1 vssd1 vccd1 vccd1 sky130_fd_sc_hd__decap_4
XFILLER_0_118_299 vssd1 vssd1 vccd1 vccd1 sky130_fd_sc_hd__fill_2
XFILLER_0_90_145 vssd1 vssd1 vccd1 vccd1 sky130_fd_sc_hd__fill_2
X_5778_ _5777_/Y _6519_/Q _5802_/B vssd1 vssd1 vccd1 vccd1 _5780_/B sky130_fd_sc_hd__mux2_1
XFILLER_0_16_231 vssd1 vssd1 vccd1 vccd1 sky130_fd_sc_hd__fill_2
XANTENNA__3745__B2 _5290_/A vssd1 vssd1 vccd1 vccd1 sky130_fd_sc_hd__diode_2
XANTENNA__3745__A1 _5327_/A vssd1 vssd1 vccd1 vccd1 sky130_fd_sc_hd__diode_2
XANTENNA__4810__B _4822_/B vssd1 vssd1 vccd1 vccd1 sky130_fd_sc_hd__diode_2
X_4729_ _4774_/B _4816_/B _4784_/A _4728_/D vssd1 vssd1 vccd1 vccd1 _4729_/X sky130_fd_sc_hd__a22o_1
XFILLER_0_31_267 vssd1 vssd1 vccd1 vccd1 sky130_fd_sc_hd__fill_2
XFILLER_0_31_278 vssd1 vssd1 vccd1 vccd1 sky130_fd_sc_hd__fill_2
XFILLER_0_101_144 vssd1 vssd1 vccd1 vccd1 sky130_fd_sc_hd__decap_3
XFILLER_0_31_289 vssd1 vssd1 vccd1 vccd1 sky130_fd_sc_hd__fill_2
XANTENNA__4273__A _4816_/A vssd1 vssd1 vccd1 vccd1 sky130_fd_sc_hd__diode_2
XFILLER_0_104_29 vssd1 vssd1 vccd1 vccd1 sky130_fd_sc_hd__fill_1
XFILLER_0_13_27 vssd1 vssd1 vccd1 vccd1 sky130_ef_sc_hd__decap_12
XFILLER_0_54_304 vssd1 vssd1 vccd1 vccd1 sky130_fd_sc_hd__fill_2
XFILLER_0_81_101 vssd1 vssd1 vccd1 vccd1 sky130_fd_sc_hd__fill_2
XFILLER_0_22_223 vssd1 vssd1 vccd1 vccd1 sky130_fd_sc_hd__fill_2
XFILLER_0_132_280 vssd1 vssd1 vccd1 vccd1 sky130_fd_sc_hd__decap_3
XANTENNA__3336__B _3961_/A vssd1 vssd1 vccd1 vccd1 sky130_fd_sc_hd__diode_2
XFILLER_0_1_139 vssd1 vssd1 vccd1 vccd1 sky130_fd_sc_hd__fill_2
XFILLER_0_22_289 vssd1 vssd1 vccd1 vccd1 sky130_fd_sc_hd__fill_1
XFILLER_0_89_201 vssd1 vssd1 vccd1 vccd1 sky130_fd_sc_hd__fill_2
XFILLER_0_89_245 vssd1 vssd1 vccd1 vccd1 sky130_fd_sc_hd__fill_2
XFILLER_0_54_45 vssd1 vssd1 vccd1 vccd1 sky130_fd_sc_hd__decap_4
XFILLER_0_89_278 vssd1 vssd1 vccd1 vccd1 sky130_fd_sc_hd__fill_2
XFILLER_0_54_67 vssd1 vssd1 vccd1 vccd1 sky130_fd_sc_hd__fill_2
XFILLER_0_9_206 vssd1 vssd1 vccd1 vccd1 sky130_fd_sc_hd__fill_1
X_6750_ _6751_/CLK _6750_/D fanout140/X vssd1 vssd1 vccd1 vccd1 _6750_/Q sky130_fd_sc_hd__dfstp_1
XANTENNA__4183__A _4842_/A vssd1 vssd1 vccd1 vccd1 sky130_fd_sc_hd__diode_2
XANTENNA__4614__C _4614_/C vssd1 vssd1 vccd1 vccd1 sky130_fd_sc_hd__diode_2
X_5701_ _5701_/A _5701_/B vssd1 vssd1 vccd1 vccd1 _5702_/B sky130_fd_sc_hd__nand2_1
XFILLER_0_70_33 vssd1 vssd1 vccd1 vccd1 sky130_fd_sc_hd__fill_2
XFILLER_0_9_217 vssd1 vssd1 vccd1 vccd1 sky130_fd_sc_hd__fill_1
XANTENNA__3975__A1 _5051_/A vssd1 vssd1 vccd1 vccd1 sky130_fd_sc_hd__diode_2
X_3962_ _3962_/A _5121_/A vssd1 vssd1 vccd1 vccd1 _3970_/A sky130_fd_sc_hd__nand2_1
XANTENNA__4333__D _4776_/A vssd1 vssd1 vccd1 vccd1 sky130_fd_sc_hd__diode_2
X_6681_ _6683_/CLK _6681_/D vssd1 vssd1 vccd1 vccd1 _6681_/Q sky130_fd_sc_hd__dfxtp_1
X_3893_ _3925_/A _3925_/B _3892_/A vssd1 vssd1 vccd1 vccd1 _3901_/A sky130_fd_sc_hd__a21o_1
X_5632_ hold72/A hold59/A hold21/A hold37/A vssd1 vssd1 vccd1 vccd1 _5636_/A sky130_fd_sc_hd__or4_1
XFILLER_0_72_123 vssd1 vssd1 vccd1 vccd1 sky130_fd_sc_hd__fill_2
X_5563_ _5796_/A _5563_/B vssd1 vssd1 vccd1 vccd1 _5563_/X sky130_fd_sc_hd__and2_1
XANTENNA__3727__A1 _5320_/A vssd1 vssd1 vccd1 vccd1 sky130_fd_sc_hd__diode_2
XFILLER_0_60_329 vssd1 vssd1 vccd1 vccd1 sky130_fd_sc_hd__fill_2
X_4514_ _4942_/B _5687_/B _4688_/C _4841_/C vssd1 vssd1 vccd1 vccd1 _4563_/A sky130_fd_sc_hd__and4_1
XFILLER_0_79_53 vssd1 vssd1 vccd1 vccd1 sky130_fd_sc_hd__decap_3
XFILLER_0_79_42 vssd1 vssd1 vccd1 vccd1 sky130_fd_sc_hd__fill_2
Xhold124 _6838_/Q vssd1 vssd1 vccd1 vccd1 hold124/X sky130_fd_sc_hd__dlygate4sd3_1
X_5494_ hold8/X sstream_i[85] _5502_/S vssd1 vssd1 vccd1 vccd1 _6527_/D sky130_fd_sc_hd__mux2_1
Xhold135 _6518_/Q vssd1 vssd1 vccd1 vccd1 hold135/X sky130_fd_sc_hd__dlygate4sd3_1
Xhold102 _6503_/Q vssd1 vssd1 vccd1 vccd1 hold102/X sky130_fd_sc_hd__dlygate4sd3_1
XFILLER_0_13_267 vssd1 vssd1 vccd1 vccd1 sky130_fd_sc_hd__fill_2
Xhold113 _6865_/Q vssd1 vssd1 vccd1 vccd1 hold113/X sky130_fd_sc_hd__dlygate4sd3_1
Xhold168 _6549_/Q vssd1 vssd1 vccd1 vccd1 hold168/X sky130_fd_sc_hd__dlygate4sd3_1
Xhold146 _6548_/Q vssd1 vssd1 vccd1 vccd1 hold146/X sky130_fd_sc_hd__dlygate4sd3_1
X_4445_ _4488_/A _4518_/D vssd1 vssd1 vccd1 vccd1 _4446_/B sky130_fd_sc_hd__nand2_1
Xhold157 _6690_/Q vssd1 vssd1 vccd1 vccd1 hold157/X sky130_fd_sc_hd__dlygate4sd3_1
Xhold179 hold75/A vssd1 vssd1 vccd1 vccd1 hold179/X sky130_fd_sc_hd__dlygate4sd3_1
X_4376_ _4376_/A _4376_/B _4376_/C vssd1 vssd1 vccd1 vccd1 _4431_/A sky130_fd_sc_hd__nand3_1
X_3327_ _6834_/Q vssd1 vssd1 vccd1 vccd1 _6259_/B sky130_fd_sc_hd__inv_2
X_6115_ hold39/A _6805_/Q vssd1 vssd1 vccd1 vccd1 _6115_/Y sky130_fd_sc_hd__nand2b_1
XFILLER_0_0_183 vssd1 vssd1 vccd1 vccd1 sky130_fd_sc_hd__fill_1
XTAP_440 vssd1 vccd1 sky130_fd_sc_hd__tapvpwrvgnd_1
XTAP_451 vssd1 vccd1 sky130_fd_sc_hd__tapvpwrvgnd_1
XTAP_462 vssd1 vccd1 sky130_fd_sc_hd__tapvpwrvgnd_1
XTAP_473 vssd1 vccd1 sky130_fd_sc_hd__tapvpwrvgnd_1
XTAP_484 vssd1 vccd1 sky130_fd_sc_hd__tapvpwrvgnd_1
XANTENNA__4077__B _4488_/A vssd1 vssd1 vccd1 vccd1 sky130_fd_sc_hd__diode_2
X_6046_ _5276_/B _6038_/B _6054_/B1 vssd1 vssd1 vccd1 vccd1 _6685_/D sky130_fd_sc_hd__a21o_1
XTAP_495 vssd1 vccd1 sky130_fd_sc_hd__tapvpwrvgnd_1
X_3258_ _6739_/Q vssd1 vssd1 vccd1 vccd1 _3258_/Y sky130_fd_sc_hd__inv_2
XANTENNA__4093__A _4822_/B vssd1 vssd1 vccd1 vccd1 sky130_fd_sc_hd__diode_2
XFILLER_0_48_120 vssd1 vssd1 vccd1 vccd1 sky130_fd_sc_hd__decap_3
X_6948_ vssd1 vssd1 vccd1 vccd1 _6948_/HI tex_mport_o[1] sky130_fd_sc_hd__conb_1
XFILLER_0_48_153 vssd1 vssd1 vccd1 vccd1 sky130_fd_sc_hd__decap_3
XFILLER_0_36_304 vssd1 vssd1 vccd1 vccd1 sky130_fd_sc_hd__fill_2
X_6879_ _6892_/CLK _6879_/D vssd1 vssd1 vccd1 vccd1 _6879_/Q sky130_fd_sc_hd__dfxtp_1
XFILLER_0_106_214 vssd1 vssd1 vccd1 vccd1 sky130_fd_sc_hd__decap_4
XFILLER_0_63_145 vssd1 vssd1 vccd1 vccd1 sky130_fd_sc_hd__fill_1
XFILLER_0_8_250 vssd1 vssd1 vccd1 vccd1 sky130_fd_sc_hd__fill_2
XFILLER_0_48_197 vssd1 vssd1 vccd1 vccd1 sky130_fd_sc_hd__fill_2
XFILLER_0_106_247 vssd1 vssd1 vccd1 vccd1 sky130_fd_sc_hd__fill_2
XFILLER_0_5_3 vssd1 vssd1 vccd1 vccd1 sky130_ef_sc_hd__decap_12
XANTENNA__5371__B _5559_/B vssd1 vssd1 vccd1 vccd1 sky130_fd_sc_hd__diode_2
XANTENNA__5798__S _5844_/S vssd1 vssd1 vccd1 vccd1 sky130_fd_sc_hd__diode_2
XFILLER_0_86_204 vssd1 vssd1 vccd1 vccd1 sky130_fd_sc_hd__fill_1
XFILLER_0_24_15 vssd1 vssd1 vccd1 vccd1 sky130_ef_sc_hd__decap_12
XFILLER_0_24_48 vssd1 vssd1 vccd1 vccd1 sky130_fd_sc_hd__fill_2
XFILLER_0_129_328 vssd1 vssd1 vccd1 vccd1 sky130_fd_sc_hd__fill_2
XFILLER_0_54_101 vssd1 vssd1 vccd1 vccd1 sky130_fd_sc_hd__fill_2
XFILLER_0_94_292 vssd1 vssd1 vccd1 vccd1 sky130_fd_sc_hd__decap_4
XFILLER_0_27_337 vssd1 vssd1 vccd1 vccd1 sky130_fd_sc_hd__decap_8
XANTENNA__3709__A1 _5801_/A vssd1 vssd1 vccd1 vccd1 sky130_fd_sc_hd__diode_2
XANTENNA__3709__B2 _4832_/C vssd1 vssd1 vccd1 vccd1 sky130_fd_sc_hd__diode_2
XFILLER_0_40_47 vssd1 vssd1 vccd1 vccd1 sky130_fd_sc_hd__fill_2
XFILLER_0_54_167 vssd1 vssd1 vccd1 vccd1 sky130_fd_sc_hd__fill_2
XANTENNA__4382__A1 _4774_/B vssd1 vssd1 vccd1 vccd1 sky130_fd_sc_hd__diode_2
XFILLER_0_49_12 vssd1 vssd1 vccd1 vccd1 sky130_fd_sc_hd__fill_2
XFILLER_0_10_215 vssd1 vssd1 vccd1 vccd1 sky130_fd_sc_hd__decap_4
XFILLER_0_50_362 vssd1 vssd1 vccd1 vccd1 sky130_fd_sc_hd__fill_2
XANTENNA_clkbuf_leaf_13_clk_i_A clkbuf_2_3__f_clk_i/X vssd1 vssd1 vccd1 vccd1 sky130_fd_sc_hd__diode_2
X_4230_ _4230_/A _4230_/B _4230_/C vssd1 vssd1 vccd1 vccd1 _4230_/X sky130_fd_sc_hd__or3_1
XFILLER_0_10_248 vssd1 vssd1 vccd1 vccd1 sky130_fd_sc_hd__fill_2
X_4161_ _4161_/A _4161_/B _4161_/C vssd1 vssd1 vccd1 vccd1 _4895_/A sky130_fd_sc_hd__nand3_1
X_4092_ _4966_/A _5754_/A _4527_/B _4841_/C vssd1 vssd1 vccd1 vccd1 _4092_/X sky130_fd_sc_hd__and4_1
X_6802_ _6802_/CLK _6802_/D vssd1 vssd1 vccd1 vccd1 hold69/A sky130_fd_sc_hd__dfxtp_1
X_4994_ _4993_/B _4993_/C _4993_/A vssd1 vssd1 vccd1 vccd1 _4994_/Y sky130_fd_sc_hd__a21oi_1
X_6733_ _6734_/CLK _6733_/D fanout144/X vssd1 vssd1 vccd1 vccd1 _6733_/Q sky130_fd_sc_hd__dfstp_1
X_3945_ tex_width_i[13] _4966_/B vssd1 vssd1 vccd1 vccd1 _3947_/B sky130_fd_sc_hd__and2_1
XFILLER_0_128_350 vssd1 vssd1 vccd1 vccd1 sky130_fd_sc_hd__fill_2
XFILLER_0_85_281 vssd1 vssd1 vccd1 vccd1 sky130_fd_sc_hd__decap_4
XFILLER_0_45_145 vssd1 vssd1 vccd1 vccd1 sky130_fd_sc_hd__decap_4
X_6664_ _6892_/CLK _6664_/D vssd1 vssd1 vccd1 vccd1 _6664_/Q sky130_fd_sc_hd__dfxtp_1
XFILLER_0_128_394 vssd1 vssd1 vccd1 vccd1 sky130_ef_sc_hd__decap_12
X_5615_ tex_width_i[15] _6521_/Q vssd1 vssd1 vccd1 vccd1 _5615_/X sky130_fd_sc_hd__and2b_1
X_3876_ _3891_/A _3891_/B _3891_/C vssd1 vssd1 vccd1 vccd1 _3892_/A sky130_fd_sc_hd__o21a_1
XANTENNA_fanout137_A _4789_/B vssd1 vssd1 vccd1 vccd1 sky130_fd_sc_hd__diode_2
X_6595_ _6802_/CLK _6595_/D fanout150/X vssd1 vssd1 vccd1 vccd1 tex_mport_o[38] sky130_fd_sc_hd__dfrtp_4
XFILLER_0_83_3 vssd1 vssd1 vccd1 vccd1 sky130_fd_sc_hd__decap_4
XFILLER_0_5_264 vssd1 vssd1 vccd1 vccd1 sky130_fd_sc_hd__decap_3
XFILLER_0_33_329 vssd1 vssd1 vccd1 vccd1 sky130_fd_sc_hd__fill_2
X_5546_ depth_mport_o[21] hold182/X _5556_/S vssd1 vssd1 vccd1 vccd1 _6577_/D sky130_fd_sc_hd__mux2_1
XANTENNA__5570__A0 _5384_/B vssd1 vssd1 vccd1 vccd1 sky130_fd_sc_hd__diode_2
X_5477_ hold161/X sstream_i[68] _6501_/S vssd1 vssd1 vccd1 vccd1 _6510_/D sky130_fd_sc_hd__mux2_1
X_4428_ _4942_/A _6663_/Q _4637_/D _4942_/B vssd1 vssd1 vccd1 vccd1 _4429_/C sky130_fd_sc_hd__a22o_1
XANTENNA__6758__RESET_B fanout149/X vssd1 vssd1 vccd1 vccd1 sky130_fd_sc_hd__diode_2
X_4359_ _4359_/A _4359_/B vssd1 vssd1 vccd1 vccd1 _4362_/B sky130_fd_sc_hd__xnor2_1
XTAP_281 vssd1 vccd1 sky130_fd_sc_hd__tapvpwrvgnd_1
XTAP_292 vssd1 vccd1 sky130_fd_sc_hd__tapvpwrvgnd_1
XANTENNA__4428__A2 _6663_/Q vssd1 vssd1 vccd1 vccd1 sky130_fd_sc_hd__diode_2
XANTENNA__5625__A1 _5754_/B vssd1 vssd1 vccd1 vccd1 sky130_fd_sc_hd__diode_2
X_6029_ _3959_/B _6028_/Y _6037_/S vssd1 vssd1 vccd1 vccd1 _6675_/D sky130_fd_sc_hd__mux2_1
XANTENNA__4816__A _4816_/A vssd1 vssd1 vccd1 vccd1 sky130_fd_sc_hd__diode_2
XFILLER_0_138_147 vssd1 vssd1 vccd1 vccd1 sky130_fd_sc_hd__decap_3
XFILLER_0_83_229 vssd1 vssd1 vccd1 vccd1 sky130_fd_sc_hd__fill_2
Xfanout30 _6098_/S vssd1 vssd1 vccd1 vccd1 _6113_/S sky130_fd_sc_hd__clkbuf_8
XFILLER_0_138_169 vssd1 vssd1 vccd1 vccd1 sky130_fd_sc_hd__fill_2
XFILLER_0_126_309 vssd1 vssd1 vccd1 vccd1 sky130_fd_sc_hd__fill_2
Xfanout52 _6675_/Q vssd1 vssd1 vccd1 vccd1 _5083_/A sky130_fd_sc_hd__buf_4
Xfanout41 _5064_/B vssd1 vssd1 vccd1 vccd1 _5300_/B sky130_fd_sc_hd__buf_4
Xfanout74 _6664_/Q vssd1 vssd1 vccd1 vccd1 _4841_/D sky130_fd_sc_hd__buf_4
Xfanout63 _4966_/B vssd1 vssd1 vccd1 vccd1 _4476_/D sky130_fd_sc_hd__clkbuf_8
Xfanout96 tex_width_i[5] vssd1 vssd1 vccd1 vccd1 _5049_/B sky130_fd_sc_hd__buf_4
Xfanout85 tex_width_i[8] vssd1 vssd1 vccd1 vccd1 _5081_/D sky130_fd_sc_hd__buf_4
XFILLER_0_24_307 vssd1 vssd1 vccd1 vccd1 sky130_fd_sc_hd__fill_1
XFILLER_0_36_156 vssd1 vssd1 vccd1 vccd1 sky130_fd_sc_hd__fill_2
XFILLER_0_51_126 vssd1 vssd1 vccd1 vccd1 sky130_fd_sc_hd__decap_4
XFILLER_0_32_351 vssd1 vssd1 vccd1 vccd1 sky130_fd_sc_hd__fill_1
XFILLER_0_19_15 vssd1 vssd1 vccd1 vccd1 sky130_ef_sc_hd__decap_12
XANTENNA__4726__A _4966_/B vssd1 vssd1 vccd1 vccd1 sky130_fd_sc_hd__diode_2
XANTENNA__4445__B _4518_/D vssd1 vssd1 vccd1 vccd1 sky130_fd_sc_hd__diode_2
XFILLER_0_129_169 vssd1 vssd1 vccd1 vccd1 sky130_fd_sc_hd__fill_2
X_3730_ _3645_/X _3727_/Y _3729_/B vssd1 vssd1 vccd1 vccd1 _3731_/B sky130_fd_sc_hd__o21ba_1
XANTENNA__5276__B _5276_/B vssd1 vssd1 vccd1 vccd1 sky130_fd_sc_hd__diode_2
XFILLER_0_27_145 vssd1 vssd1 vccd1 vccd1 sky130_fd_sc_hd__fill_2
XFILLER_0_82_295 vssd1 vssd1 vccd1 vccd1 sky130_fd_sc_hd__fill_2
X_3661_ _3659_/X _3661_/B vssd1 vssd1 vccd1 vccd1 _3738_/A sky130_fd_sc_hd__nand2b_1
X_6380_ depth_mport_o[45] _6333_/S _6378_/Y _6379_/X vssd1 vssd1 vccd1 vccd1 _6823_/D
+ sky130_fd_sc_hd__a22o_1
X_5400_ _5400_/A _5400_/B vssd1 vssd1 vccd1 vccd1 _5401_/B sky130_fd_sc_hd__xnor2_2
X_3592_ _3592_/A _3592_/B vssd1 vssd1 vccd1 vccd1 _3593_/B sky130_fd_sc_hd__and2_1
X_5331_ _5331_/A _5331_/B vssd1 vssd1 vccd1 vccd1 _5332_/B sky130_fd_sc_hd__xnor2_1
XFILLER_0_23_384 vssd1 vssd1 vccd1 vccd1 sky130_fd_sc_hd__decap_8
XANTENNA__3805__A _5051_/B vssd1 vssd1 vccd1 vccd1 sky130_fd_sc_hd__diode_2
X_5262_ _5340_/A _5258_/B _5256_/X vssd1 vssd1 vccd1 vccd1 _5336_/C sky130_fd_sc_hd__a21o_1
X_4213_ _4213_/A _4213_/B vssd1 vssd1 vccd1 vccd1 _4219_/B sky130_fd_sc_hd__xor2_2
XANTENNA__5855__B2 _5588_/B vssd1 vssd1 vccd1 vccd1 sky130_fd_sc_hd__diode_2
X_5193_ _5194_/B _5194_/A vssd1 vssd1 vccd1 vccd1 _5193_/Y sky130_fd_sc_hd__nand2b_1
X_4144_ _4476_/D _5718_/B _4170_/A _4143_/D vssd1 vssd1 vccd1 vccd1 _4144_/X sky130_fd_sc_hd__a22o_1
X_4075_ _4058_/X _4240_/A vssd1 vssd1 vccd1 vccd1 _4089_/A sky130_fd_sc_hd__and2b_1
XFILLER_0_116_71 vssd1 vssd1 vccd1 vccd1 sky130_fd_sc_hd__fill_2
XFILLER_0_65_229 vssd1 vssd1 vccd1 vccd1 sky130_fd_sc_hd__fill_2
XFILLER_0_65_207 vssd1 vssd1 vccd1 vccd1 sky130_fd_sc_hd__fill_1
X_6716_ _6853_/CLK _6716_/D vssd1 vssd1 vccd1 vccd1 hold79/A sky130_fd_sc_hd__dfxtp_1
XANTENNA__6062__S _6072_/S vssd1 vssd1 vccd1 vccd1 sky130_fd_sc_hd__diode_2
XFILLER_0_108_309 vssd1 vssd1 vccd1 vccd1 sky130_fd_sc_hd__fill_2
X_4977_ _4976_/A _4976_/B _4976_/C vssd1 vssd1 vccd1 vccd1 _4978_/C sky130_fd_sc_hd__a21o_1
XFILLER_0_135_139 vssd1 vssd1 vccd1 vccd1 sky130_fd_sc_hd__fill_2
XFILLER_0_73_251 vssd1 vssd1 vccd1 vccd1 sky130_fd_sc_hd__decap_3
X_3928_ _3927_/A _3927_/Y _3838_/Y _3905_/X vssd1 vssd1 vccd1 vccd1 _3932_/A sky130_fd_sc_hd__o211a_2
XFILLER_0_73_273 vssd1 vssd1 vccd1 vccd1 sky130_fd_sc_hd__fill_2
X_3859_ _5266_/A _5266_/B vssd1 vssd1 vccd1 vccd1 _5438_/A sky130_fd_sc_hd__nor2_1
X_6647_ _6747_/CLK _6647_/D _5937_/A vssd1 vssd1 vccd1 vccd1 _6647_/Q sky130_fd_sc_hd__dfstp_1
X_6578_ _6812_/CLK _6578_/D fanout149/X vssd1 vssd1 vccd1 vccd1 depth_mport_o[22]
+ sky130_fd_sc_hd__dfrtp_4
X_5529_ depth_mport_o[4] hold130/X _5541_/S vssd1 vssd1 vccd1 vccd1 _6560_/D sky130_fd_sc_hd__mux2_1
XANTENNA__3715__A _5081_/B vssd1 vssd1 vccd1 vccd1 sky130_fd_sc_hd__diode_2
XANTENNA__3422__A2_N _5286_/B vssd1 vssd1 vccd1 vccd1 sky130_fd_sc_hd__diode_2
XANTENNA__5846__B2 _5919_/B vssd1 vssd1 vccd1 vccd1 sky130_fd_sc_hd__diode_2
XTAP_1222 vssd1 vccd1 sky130_fd_sc_hd__tapvpwrvgnd_1
XTAP_1211 vssd1 vccd1 sky130_fd_sc_hd__tapvpwrvgnd_1
XTAP_1200 vssd1 vccd1 sky130_fd_sc_hd__tapvpwrvgnd_1
XFILLER_0_96_365 vssd1 vssd1 vccd1 vccd1 sky130_ef_sc_hd__decap_12
XTAP_1255 vssd1 vccd1 sky130_fd_sc_hd__tapvpwrvgnd_1
XTAP_1244 vssd1 vccd1 sky130_fd_sc_hd__tapvpwrvgnd_1
XTAP_1233 vssd1 vccd1 sky130_fd_sc_hd__tapvpwrvgnd_1
XFILLER_0_56_207 vssd1 vssd1 vccd1 vccd1 sky130_fd_sc_hd__fill_2
XFILLER_0_49_281 vssd1 vssd1 vccd1 vccd1 sky130_fd_sc_hd__fill_2
XFILLER_0_126_139 vssd1 vssd1 vccd1 vccd1 sky130_fd_sc_hd__fill_1
XFILLER_0_21_27 vssd1 vssd1 vccd1 vccd1 sky130_fd_sc_hd__decap_8
XFILLER_0_107_331 vssd1 vssd1 vccd1 vccd1 sky130_fd_sc_hd__decap_3
XFILLER_0_122_334 vssd1 vssd1 vccd1 vccd1 sky130_fd_sc_hd__fill_2
XFILLER_0_32_192 vssd1 vssd1 vccd1 vccd1 sky130_fd_sc_hd__fill_2
XANTENNA__6609__RESET_B fanout153/X vssd1 vssd1 vccd1 vccd1 sky130_fd_sc_hd__diode_2
XFILLER_0_20_365 vssd1 vssd1 vccd1 vccd1 sky130_fd_sc_hd__decap_6
XANTENNA__3344__B _5272_/B vssd1 vssd1 vccd1 vccd1 sky130_fd_sc_hd__diode_2
XFILLER_0_137_26 vssd1 vssd1 vccd1 vccd1 sky130_fd_sc_hd__fill_1
XFILLER_0_1_15 vssd1 vssd1 vccd1 vccd1 sky130_ef_sc_hd__decap_12
X_4900_ _4900_/A _4912_/A _4900_/C vssd1 vssd1 vccd1 vccd1 _4912_/B sky130_fd_sc_hd__nand3_1
X_5880_ hold283/X _5879_/X _5923_/S vssd1 vssd1 vccd1 vccd1 _6646_/D sky130_fd_sc_hd__mux2_1
XFILLER_0_47_207 vssd1 vssd1 vccd1 vccd1 sky130_fd_sc_hd__decap_3
X_4831_ _4830_/B _4830_/C _4830_/A vssd1 vssd1 vccd1 vccd1 _4837_/B sky130_fd_sc_hd__a21o_1
XFILLER_0_7_315 vssd1 vssd1 vccd1 vccd1 sky130_fd_sc_hd__fill_2
XFILLER_0_117_117 vssd1 vssd1 vccd1 vccd1 sky130_fd_sc_hd__fill_2
X_4762_ _4760_/A _4898_/A _4761_/Y _4754_/X vssd1 vssd1 vccd1 vccd1 _4884_/A sky130_fd_sc_hd__a211o_1
XANTENNA_hold75_A hold75/A vssd1 vssd1 vccd1 vccd1 sky130_fd_sc_hd__diode_2
X_4693_ _4679_/X _4693_/B vssd1 vssd1 vccd1 vccd1 _5368_/B sky130_fd_sc_hd__nand2b_1
X_6501_ hold103/X sstream_i[59] _6501_/S vssd1 vssd1 vccd1 vccd1 _6892_/D sky130_fd_sc_hd__mux2_1
XANTENNA__3519__B _5300_/A vssd1 vssd1 vccd1 vccd1 sky130_fd_sc_hd__diode_2
X_3713_ _3713_/A _3713_/B vssd1 vssd1 vccd1 vccd1 _3783_/A sky130_fd_sc_hd__xor2_1
XFILLER_0_55_295 vssd1 vssd1 vccd1 vccd1 sky130_fd_sc_hd__fill_2
X_6432_ _6432_/A vssd1 vssd1 vccd1 vccd1 _6432_/Y sky130_fd_sc_hd__inv_2
XFILLER_0_125_150 vssd1 vssd1 vccd1 vccd1 sky130_fd_sc_hd__fill_1
X_3644_ _5051_/B _5296_/A _5276_/A _5277_/A vssd1 vssd1 vccd1 vccd1 _3645_/D sky130_fd_sc_hd__a22o_1
XFILLER_0_113_345 vssd1 vssd1 vccd1 vccd1 sky130_fd_sc_hd__fill_2
XFILLER_0_11_93 vssd1 vssd1 vccd1 vccd1 sky130_ef_sc_hd__decap_12
X_6363_ hold98/A hold53/A vssd1 vssd1 vccd1 vccd1 _6363_/Y sky130_fd_sc_hd__nand2_1
X_3575_ _3592_/A _3592_/B vssd1 vssd1 vccd1 vccd1 _3593_/A sky130_fd_sc_hd__nor2_1
XFILLER_0_11_332 vssd1 vssd1 vccd1 vccd1 sky130_fd_sc_hd__decap_4
XFILLER_0_11_310 vssd1 vssd1 vccd1 vccd1 sky130_fd_sc_hd__decap_3
X_6294_ _6284_/X _6292_/X _6293_/Y _6289_/X vssd1 vssd1 vccd1 vccd1 _6294_/X sky130_fd_sc_hd__o211a_1
XFILLER_0_87_86 vssd1 vssd1 vccd1 vccd1 sky130_fd_sc_hd__fill_1
X_5314_ _3487_/A _3487_/B _3486_/A vssd1 vssd1 vccd1 vccd1 _5316_/A sky130_fd_sc_hd__o21ai_1
X_5245_ _4013_/A _4013_/C _4013_/B vssd1 vssd1 vccd1 vccd1 _5245_/Y sky130_fd_sc_hd__o21ai_2
Xhold17 hold17/A vssd1 vssd1 vccd1 vccd1 hold17/X sky130_fd_sc_hd__dlygate4sd3_1
Xhold28 hold28/A vssd1 vssd1 vccd1 vccd1 hold28/X sky130_fd_sc_hd__dlygate4sd3_1
XFILLER_0_46_3 vssd1 vssd1 vccd1 vccd1 sky130_fd_sc_hd__fill_2
Xhold39 hold39/A vssd1 vssd1 vccd1 vccd1 hold39/X sky130_fd_sc_hd__dlygate4sd3_1
X_5176_ _5160_/Y _5166_/X _5173_/B _5172_/Y vssd1 vssd1 vccd1 vccd1 _5177_/C sky130_fd_sc_hd__a211oi_2
XANTENNA__6057__S _6072_/S vssd1 vssd1 vccd1 vccd1 sky130_fd_sc_hd__diode_2
X_4127_ _4794_/B _4488_/A vssd1 vssd1 vccd1 vccd1 _4128_/B sky130_fd_sc_hd__nand2_1
X_4058_ _4058_/A _4122_/B _4058_/C vssd1 vssd1 vccd1 vccd1 _4058_/X sky130_fd_sc_hd__and3_1
XANTENNA__3420__D _5272_/B vssd1 vssd1 vccd1 vccd1 sky130_fd_sc_hd__diode_2
XFILLER_0_38_207 vssd1 vssd1 vccd1 vccd1 sky130_fd_sc_hd__decap_3
XFILLER_0_136_404 vssd1 vssd1 vccd1 vccd1 sky130_fd_sc_hd__decap_3
XFILLER_0_93_346 vssd1 vssd1 vccd1 vccd1 sky130_ef_sc_hd__decap_12
XFILLER_0_93_335 vssd1 vssd1 vccd1 vccd1 sky130_fd_sc_hd__fill_1
XFILLER_0_46_251 vssd1 vssd1 vccd1 vccd1 sky130_fd_sc_hd__fill_1
XANTENNA_hold214_A _6546_/Q vssd1 vssd1 vccd1 vccd1 sky130_fd_sc_hd__diode_2
XFILLER_0_116_172 vssd1 vssd1 vccd1 vccd1 sky130_fd_sc_hd__fill_2
XFILLER_0_116_150 vssd1 vssd1 vccd1 vccd1 sky130_fd_sc_hd__fill_2
XFILLER_0_131_164 vssd1 vssd1 vccd1 vccd1 sky130_fd_sc_hd__fill_2
XFILLER_0_131_142 vssd1 vssd1 vccd1 vccd1 sky130_fd_sc_hd__decap_3
XFILLER_0_104_389 vssd1 vssd1 vccd1 vccd1 sky130_ef_sc_hd__decap_12
XFILLER_0_107_29 vssd1 vssd1 vccd1 vccd1 sky130_fd_sc_hd__decap_3
XFILLER_0_16_27 vssd1 vssd1 vccd1 vccd1 sky130_fd_sc_hd__fill_1
XTAP_1030 vssd1 vccd1 sky130_fd_sc_hd__tapvpwrvgnd_1
XFILLER_0_84_302 vssd1 vssd1 vccd1 vccd1 sky130_fd_sc_hd__fill_2
XFILLER_0_69_365 vssd1 vssd1 vccd1 vccd1 sky130_fd_sc_hd__fill_2
XTAP_1074 vssd1 vccd1 sky130_fd_sc_hd__tapvpwrvgnd_1
XTAP_1063 vssd1 vccd1 sky130_fd_sc_hd__tapvpwrvgnd_1
XTAP_1052 vssd1 vccd1 sky130_fd_sc_hd__tapvpwrvgnd_1
XTAP_1041 vssd1 vccd1 sky130_fd_sc_hd__tapvpwrvgnd_1
XFILLER_0_84_324 vssd1 vssd1 vccd1 vccd1 sky130_fd_sc_hd__fill_1
XFILLER_0_29_229 vssd1 vssd1 vccd1 vccd1 sky130_fd_sc_hd__fill_2
XTAP_1096 vssd1 vccd1 sky130_fd_sc_hd__tapvpwrvgnd_1
XTAP_1085 vssd1 vccd1 sky130_fd_sc_hd__tapvpwrvgnd_1
XANTENNA__3339__B _5286_/A vssd1 vssd1 vccd1 vccd1 sky130_fd_sc_hd__diode_2
XANTENNA__5507__A0 hold98/X vssd1 vssd1 vccd1 vccd1 sky130_fd_sc_hd__diode_2
XFILLER_0_52_221 vssd1 vssd1 vccd1 vccd1 sky130_ef_sc_hd__decap_12
XFILLER_0_52_243 vssd1 vssd1 vccd1 vccd1 sky130_fd_sc_hd__decap_8
X_3360_ _3360_/A _3397_/B vssd1 vssd1 vccd1 vccd1 _3375_/A sky130_fd_sc_hd__or2_1
XFILLER_0_20_151 vssd1 vssd1 vccd1 vccd1 sky130_fd_sc_hd__fill_1
XTAP_825 vssd1 vccd1 sky130_fd_sc_hd__tapvpwrvgnd_1
XTAP_814 vssd1 vccd1 sky130_fd_sc_hd__tapvpwrvgnd_1
XTAP_803 vssd1 vccd1 sky130_fd_sc_hd__tapvpwrvgnd_1
XFILLER_0_20_162 vssd1 vssd1 vccd1 vccd1 sky130_fd_sc_hd__fill_2
XTAP_858 vssd1 vccd1 sky130_fd_sc_hd__tapvpwrvgnd_1
XTAP_847 vssd1 vccd1 sky130_fd_sc_hd__tapvpwrvgnd_1
XTAP_836 vssd1 vccd1 sky130_fd_sc_hd__tapvpwrvgnd_1
X_5030_ _4132_/Y _4134_/X _5028_/Y _5029_/X vssd1 vssd1 vccd1 vccd1 _5030_/Y sky130_fd_sc_hd__o211ai_4
X_3291_ tex_height_i[2] vssd1 vssd1 vccd1 vccd1 _3291_/Y sky130_fd_sc_hd__inv_2
XTAP_869 vssd1 vccd1 sky130_fd_sc_hd__tapvpwrvgnd_1
XANTENNA__3802__B _3961_/A vssd1 vssd1 vccd1 vccd1 sky130_fd_sc_hd__diode_2
X_6981_ vssd1 vssd1 vccd1 vccd1 _6981_/HI tex_mport_o[67] sky130_fd_sc_hd__conb_1
X_5932_ hold38/X tex_mport_i[7] _5932_/S vssd1 vssd1 vccd1 vccd1 _6660_/D sky130_fd_sc_hd__mux2_1
XFILLER_0_73_88 vssd1 vssd1 vccd1 vccd1 sky130_fd_sc_hd__fill_2
XFILLER_0_87_173 vssd1 vssd1 vccd1 vccd1 sky130_fd_sc_hd__fill_2
X_5863_ _5863_/A _5863_/B _5863_/C _5863_/D vssd1 vssd1 vccd1 vccd1 _5864_/A sky130_fd_sc_hd__or4_2
XFILLER_0_90_305 vssd1 vssd1 vccd1 vccd1 sky130_fd_sc_hd__decap_3
X_5794_ _5794_/A _5794_/B vssd1 vssd1 vccd1 vccd1 _5794_/X sky130_fd_sc_hd__or2_1
XFILLER_0_28_251 vssd1 vssd1 vccd1 vccd1 sky130_fd_sc_hd__fill_1
X_4814_ _5115_/D _4958_/B _5118_/B _4814_/D vssd1 vssd1 vccd1 vccd1 _4956_/A sky130_fd_sc_hd__nand4_2
X_4745_ _6673_/Q _4942_/A _4942_/B _4776_/A vssd1 vssd1 vccd1 vccd1 _4748_/A sky130_fd_sc_hd__nand4_1
XFILLER_0_43_210 vssd1 vssd1 vccd1 vccd1 sky130_fd_sc_hd__decap_3
X_4676_ _6623_/Q _4676_/B vssd1 vssd1 vccd1 vccd1 _4678_/D sky130_fd_sc_hd__or2_1
XFILLER_0_31_405 vssd1 vssd1 vccd1 vccd1 sky130_fd_sc_hd__fill_2
X_6415_ _6415_/A _6415_/B vssd1 vssd1 vccd1 vccd1 _6427_/A sky130_fd_sc_hd__or2_1
XFILLER_0_98_85 vssd1 vssd1 vccd1 vccd1 sky130_fd_sc_hd__fill_2
XFILLER_0_3_351 vssd1 vssd1 vccd1 vccd1 sky130_fd_sc_hd__fill_1
X_3627_ _3627_/A _3627_/B vssd1 vssd1 vccd1 vccd1 _3634_/A sky130_fd_sc_hd__xnor2_1
X_6346_ _6555_/Q _6346_/B _6346_/C vssd1 vssd1 vccd1 vccd1 _6348_/A sky130_fd_sc_hd__and3_1
XFILLER_0_113_175 vssd1 vssd1 vccd1 vccd1 sky130_fd_sc_hd__fill_1
X_3558_ _3558_/A _3558_/B vssd1 vssd1 vccd1 vccd1 _3559_/C sky130_fd_sc_hd__xnor2_1
XFILLER_0_11_173 vssd1 vssd1 vccd1 vccd1 sky130_fd_sc_hd__fill_1
X_6277_ _6277_/A _6277_/B _6277_/C _6277_/D vssd1 vssd1 vccd1 vccd1 _6277_/X sky130_fd_sc_hd__or4_1
X_3489_ _3489_/A _3489_/B _3489_/C vssd1 vssd1 vccd1 vccd1 _3489_/Y sky130_fd_sc_hd__nor3_1
X_5228_ _5196_/X _5225_/Y _4993_/B _4993_/Y vssd1 vssd1 vccd1 vccd1 _5229_/C sky130_fd_sc_hd__o211ai_2
XFILLER_0_98_405 vssd1 vssd1 vccd1 vccd1 sky130_fd_sc_hd__fill_2
X_5159_ _5145_/X _5150_/Y _5156_/A _5156_/Y vssd1 vssd1 vccd1 vccd1 _5160_/D sky130_fd_sc_hd__a211o_1
XANTENNA__5985__A0 _4842_/A vssd1 vssd1 vccd1 vccd1 sky130_fd_sc_hd__diode_2
XANTENNA__4788__A1 _5071_/A vssd1 vssd1 vccd1 vccd1 sky130_fd_sc_hd__diode_2
XFILLER_0_78_162 vssd1 vssd1 vccd1 vccd1 sky130_fd_sc_hd__decap_4
XANTENNA__4824__A _4970_/B vssd1 vssd1 vccd1 vccd1 sky130_fd_sc_hd__diode_2
XANTENNA__4788__B2 _4789_/B vssd1 vssd1 vccd1 vccd1 sky130_fd_sc_hd__diode_2
XANTENNA_fanout32_A _3261_/Y vssd1 vssd1 vccd1 vccd1 sky130_fd_sc_hd__diode_2
XPHY_102 vssd1 vssd1 vccd1 vccd1 sky130_fd_sc_hd__decap_3
XPHY_113 vssd1 vssd1 vccd1 vccd1 sky130_fd_sc_hd__decap_3
XPHY_124 vssd1 vssd1 vccd1 vccd1 sky130_fd_sc_hd__decap_3
XFILLER_0_136_212 vssd1 vssd1 vccd1 vccd1 sky130_fd_sc_hd__decap_3
XFILLER_0_93_132 vssd1 vssd1 vccd1 vccd1 sky130_fd_sc_hd__fill_2
XPHY_157 vssd1 vssd1 vccd1 vccd1 sky130_fd_sc_hd__decap_3
XPHY_146 vssd1 vssd1 vccd1 vccd1 sky130_fd_sc_hd__decap_3
XPHY_135 vssd1 vssd1 vccd1 vccd1 sky130_fd_sc_hd__decap_3
XPHY_179 vssd1 vssd1 vccd1 vccd1 sky130_fd_sc_hd__decap_3
XPHY_168 vssd1 vssd1 vccd1 vccd1 sky130_fd_sc_hd__decap_3
XFILLER_0_19_262 vssd1 vssd1 vccd1 vccd1 sky130_fd_sc_hd__fill_2
XANTENNA__5655__A _5656_/A vssd1 vssd1 vccd1 vccd1 sky130_fd_sc_hd__diode_2
XANTENNA_91 sstream_i[3] vssd1 vssd1 vccd1 vccd1 sky130_fd_sc_hd__diode_2
XANTENNA_80 sstream_i[2] vssd1 vssd1 vccd1 vccd1 sky130_fd_sc_hd__diode_2
XFILLER_0_104_197 vssd1 vssd1 vccd1 vccd1 sky130_fd_sc_hd__decap_3
XANTENNA__6652__SET_B _5937_/A vssd1 vssd1 vccd1 vccd1 sky130_fd_sc_hd__diode_2
XFILLER_0_27_15 vssd1 vssd1 vccd1 vccd1 sky130_ef_sc_hd__decap_12
XFILLER_0_89_405 vssd1 vssd1 vccd1 vccd1 sky130_fd_sc_hd__fill_2
XFILLER_0_27_48 vssd1 vssd1 vccd1 vccd1 sky130_fd_sc_hd__fill_2
XANTENNA__4156__D _4776_/A vssd1 vssd1 vccd1 vccd1 sky130_fd_sc_hd__diode_2
XPHY_4 vssd1 vssd1 vccd1 vccd1 sky130_fd_sc_hd__decap_3
XFILLER_0_57_335 vssd1 vssd1 vccd1 vccd1 sky130_fd_sc_hd__fill_1
XFILLER_0_84_132 vssd1 vssd1 vccd1 vccd1 sky130_fd_sc_hd__fill_2
XFILLER_0_72_305 vssd1 vssd1 vccd1 vccd1 sky130_fd_sc_hd__decap_3
XFILLER_0_57_346 vssd1 vssd1 vccd1 vccd1 sky130_fd_sc_hd__fill_1
XANTENNA__5565__A _5796_/A vssd1 vssd1 vccd1 vccd1 sky130_fd_sc_hd__diode_2
XFILLER_0_25_210 vssd1 vssd1 vccd1 vccd1 sky130_fd_sc_hd__fill_2
X_4530_ _5666_/A _4582_/D vssd1 vssd1 vccd1 vccd1 _4532_/B sky130_fd_sc_hd__nand2_1
XFILLER_0_13_405 vssd1 vssd1 vccd1 vccd1 sky130_fd_sc_hd__fill_2
XFILLER_0_25_265 vssd1 vssd1 vccd1 vccd1 sky130_fd_sc_hd__decap_3
XFILLER_0_25_276 vssd1 vssd1 vccd1 vccd1 sky130_fd_sc_hd__fill_1
X_4461_ _4458_/Y _4460_/Y _4418_/C _4419_/X vssd1 vssd1 vccd1 vccd1 _4707_/A sky130_fd_sc_hd__o211a_1
XFILLER_0_80_393 vssd1 vssd1 vccd1 vccd1 sky130_ef_sc_hd__decap_12
XFILLER_0_25_298 vssd1 vssd1 vccd1 vccd1 sky130_ef_sc_hd__decap_12
X_6200_ hold22/A _6792_/Q _6191_/A vssd1 vssd1 vccd1 vccd1 _6202_/B sky130_fd_sc_hd__a21oi_1
XFILLER_0_7_69 vssd1 vssd1 vccd1 vccd1 sky130_ef_sc_hd__decap_12
XFILLER_0_0_321 vssd1 vssd1 vccd1 vccd1 sky130_fd_sc_hd__fill_2
X_3412_ _3999_/A _6688_/Q _3399_/A _3402_/A vssd1 vssd1 vccd1 vccd1 _3457_/A sky130_fd_sc_hd__a31o_1
X_6131_ hold61/X _6136_/B _6207_/B vssd1 vssd1 vccd1 vccd1 _6131_/Y sky130_fd_sc_hd__a21oi_1
XFILLER_0_110_145 vssd1 vssd1 vccd1 vccd1 sky130_fd_sc_hd__fill_2
X_4392_ _4392_/A _4423_/A _4392_/C vssd1 vssd1 vccd1 vccd1 _4394_/B sky130_fd_sc_hd__nand3_1
XTAP_600 vssd1 vccd1 sky130_fd_sc_hd__tapvpwrvgnd_1
X_3343_ _5296_/A _5276_/A _5064_/B _5273_/B vssd1 vssd1 vccd1 vccd1 _3425_/A sky130_fd_sc_hd__and4_1
XFILLER_0_0_365 vssd1 vssd1 vccd1 vccd1 sky130_fd_sc_hd__fill_2
XTAP_611 vssd1 vccd1 sky130_fd_sc_hd__tapvpwrvgnd_1
XTAP_622 vssd1 vccd1 sky130_fd_sc_hd__tapvpwrvgnd_1
XTAP_633 vssd1 vccd1 sky130_fd_sc_hd__tapvpwrvgnd_1
X_6062_ hold29/X hold70/X _6072_/S vssd1 vssd1 vccd1 vccd1 _6701_/D sky130_fd_sc_hd__mux2_1
X_3274_ _6512_/Q vssd1 vssd1 vccd1 vccd1 _3274_/Y sky130_fd_sc_hd__inv_2
XTAP_644 vssd1 vccd1 sky130_fd_sc_hd__tapvpwrvgnd_1
XTAP_655 vssd1 vccd1 sky130_fd_sc_hd__tapvpwrvgnd_1
XTAP_666 vssd1 vccd1 sky130_fd_sc_hd__tapvpwrvgnd_1
XTAP_677 vssd1 vccd1 sky130_fd_sc_hd__tapvpwrvgnd_1
XFILLER_0_84_54 vssd1 vssd1 vccd1 vccd1 sky130_fd_sc_hd__fill_2
X_5013_ _5013_/A _5013_/B vssd1 vssd1 vccd1 vccd1 _5015_/B sky130_fd_sc_hd__xnor2_1
XANTENNA__3532__B _5300_/A vssd1 vssd1 vccd1 vccd1 sky130_fd_sc_hd__diode_2
XTAP_688 vssd1 vccd1 sky130_fd_sc_hd__tapvpwrvgnd_1
XTAP_699 vssd1 vccd1 sky130_fd_sc_hd__tapvpwrvgnd_1
X_6964_ vssd1 vssd1 vccd1 vccd1 _6964_/HI tex_mport_o[17] sky130_fd_sc_hd__conb_1
X_6895_ vssd1 vssd1 vccd1 vccd1 _6895_/HI depth_mport_o[54] sky130_fd_sc_hd__conb_1
XFILLER_0_75_110 vssd1 vssd1 vccd1 vccd1 sky130_fd_sc_hd__fill_2
X_5915_ _5916_/A _5916_/B _5916_/C vssd1 vssd1 vccd1 vccd1 _5915_/Y sky130_fd_sc_hd__o21ai_1
XFILLER_0_124_82 vssd1 vssd1 vccd1 vccd1 sky130_fd_sc_hd__fill_2
X_5846_ _5863_/A _5851_/B tex_addr_i[20] _5919_/B vssd1 vssd1 vccd1 vccd1 _5847_/B
+ sky130_fd_sc_hd__a2bb2o_1
XFILLER_0_90_113 vssd1 vssd1 vccd1 vccd1 sky130_fd_sc_hd__fill_2
XFILLER_0_118_267 vssd1 vssd1 vccd1 vccd1 sky130_fd_sc_hd__fill_2
X_5777_ _5787_/B _5787_/C vssd1 vssd1 vccd1 vccd1 _5777_/Y sky130_fd_sc_hd__xnor2_1
XANTENNA__6070__S _6072_/S vssd1 vssd1 vccd1 vccd1 sky130_fd_sc_hd__diode_2
XFILLER_0_16_243 vssd1 vssd1 vccd1 vccd1 sky130_fd_sc_hd__fill_2
X_4728_ _4774_/B _4816_/B _4784_/A _4728_/D vssd1 vssd1 vccd1 vccd1 _4784_/B sky130_fd_sc_hd__nand4_1
X_4659_ _6623_/Q _4676_/B vssd1 vssd1 vccd1 vccd1 _4678_/A sky130_fd_sc_hd__nand2_2
XFILLER_0_71_393 vssd1 vssd1 vccd1 vccd1 sky130_ef_sc_hd__decap_12
XFILLER_0_16_287 vssd1 vssd1 vccd1 vccd1 sky130_fd_sc_hd__decap_4
XFILLER_0_31_235 vssd1 vssd1 vccd1 vccd1 sky130_fd_sc_hd__fill_1
X_6329_ hold87/X depth_mport_o[34] _6440_/B vssd1 vssd1 vccd1 vccd1 _6812_/D sky130_fd_sc_hd__mux2_1
XFILLER_0_98_257 vssd1 vssd1 vccd1 vccd1 sky130_fd_sc_hd__fill_1
XFILLER_0_98_246 vssd1 vssd1 vccd1 vccd1 sky130_fd_sc_hd__decap_6
XANTENNA__4273__B _4736_/B vssd1 vssd1 vccd1 vccd1 sky130_fd_sc_hd__diode_2
XFILLER_0_39_313 vssd1 vssd1 vccd1 vccd1 sky130_fd_sc_hd__decap_3
XFILLER_0_39_324 vssd1 vssd1 vccd1 vccd1 sky130_fd_sc_hd__decap_3
XFILLER_0_13_39 vssd1 vssd1 vccd1 vccd1 sky130_ef_sc_hd__decap_12
XFILLER_0_109_234 vssd1 vssd1 vccd1 vccd1 sky130_fd_sc_hd__fill_1
XFILLER_0_81_113 vssd1 vssd1 vccd1 vccd1 sky130_fd_sc_hd__fill_2
XFILLER_0_54_338 vssd1 vssd1 vccd1 vccd1 sky130_fd_sc_hd__decap_3
XFILLER_0_124_259 vssd1 vssd1 vccd1 vccd1 sky130_fd_sc_hd__fill_2
XFILLER_0_62_382 vssd1 vssd1 vccd1 vccd1 sky130_ef_sc_hd__decap_12
XANTENNA__3336__C _5273_/A vssd1 vssd1 vccd1 vccd1 sky130_fd_sc_hd__diode_2
XFILLER_0_22_268 vssd1 vssd1 vccd1 vccd1 sky130_fd_sc_hd__fill_2
XFILLER_0_38_14 vssd1 vssd1 vccd1 vccd1 sky130_fd_sc_hd__decap_3
X_3961_ _3961_/A _5083_/B _3962_/A _3961_/D vssd1 vssd1 vccd1 vccd1 _5121_/A sky130_fd_sc_hd__nand4_1
XANTENNA__4183__B _4971_/B vssd1 vssd1 vccd1 vccd1 sky130_fd_sc_hd__diode_2
XFILLER_0_57_110 vssd1 vssd1 vccd1 vccd1 sky130_fd_sc_hd__fill_2
X_5700_ _5701_/A _5701_/B vssd1 vssd1 vccd1 vccd1 _5718_/C sky130_fd_sc_hd__or2_1
X_6680_ _6683_/CLK _6680_/D vssd1 vssd1 vccd1 vccd1 _6680_/Q sky130_fd_sc_hd__dfxtp_1
X_3892_ _3892_/A _3892_/B vssd1 vssd1 vccd1 vccd1 _3925_/B sky130_fd_sc_hd__nor2_1
XANTENNA__3975__A2 _5064_/B vssd1 vssd1 vccd1 vccd1 sky130_fd_sc_hd__diode_2
X_5631_ _5614_/X _5621_/X _5626_/X _5629_/X vssd1 vssd1 vccd1 vccd1 _5800_/B sky130_fd_sc_hd__o31ai_1
XFILLER_0_70_89 vssd1 vssd1 vccd1 vccd1 sky130_fd_sc_hd__decap_4
X_5562_ tex_mport_o[33] _5576_/S _5561_/X _5588_/C vssd1 vssd1 vccd1 vccd1 _6590_/D
+ sky130_fd_sc_hd__a22o_1
XFILLER_0_60_319 vssd1 vssd1 vccd1 vccd1 sky130_fd_sc_hd__fill_1
X_4513_ _4471_/A _4471_/C _4471_/B vssd1 vssd1 vccd1 vccd1 _4515_/B sky130_fd_sc_hd__a21o_1
XFILLER_0_53_382 vssd1 vssd1 vccd1 vccd1 sky130_fd_sc_hd__decap_8
XFILLER_0_53_393 vssd1 vssd1 vccd1 vccd1 sky130_ef_sc_hd__decap_12
Xhold114 _6809_/Q vssd1 vssd1 vccd1 vccd1 _3266_/A sky130_fd_sc_hd__dlygate4sd3_1
X_5493_ hold26/X sstream_i[84] _5502_/S vssd1 vssd1 vccd1 vccd1 _6526_/D sky130_fd_sc_hd__mux2_1
Xhold103 _6892_/Q vssd1 vssd1 vccd1 vccd1 hold103/X sky130_fd_sc_hd__dlygate4sd3_1
Xhold125 _6867_/Q vssd1 vssd1 vccd1 vccd1 hold125/X sky130_fd_sc_hd__dlygate4sd3_1
XFILLER_0_123_292 vssd1 vssd1 vccd1 vccd1 sky130_fd_sc_hd__fill_2
Xhold158 _6848_/Q vssd1 vssd1 vccd1 vccd1 hold158/X sky130_fd_sc_hd__dlygate4sd3_1
Xhold147 _6846_/Q vssd1 vssd1 vccd1 vccd1 hold147/X sky130_fd_sc_hd__dlygate4sd3_1
X_4444_ _4432_/A _4518_/D _4435_/B _4433_/X vssd1 vssd1 vccd1 vccd1 _4446_/A sky130_fd_sc_hd__a31o_1
XFILLER_0_79_98 vssd1 vssd1 vccd1 vccd1 sky130_fd_sc_hd__fill_2
XFILLER_0_13_279 vssd1 vssd1 vccd1 vccd1 sky130_fd_sc_hd__fill_1
Xhold136 _6870_/Q vssd1 vssd1 vccd1 vccd1 hold136/X sky130_fd_sc_hd__dlygate4sd3_1
X_4375_ _5687_/A _4614_/C _4637_/D _5701_/A vssd1 vssd1 vccd1 vccd1 _4376_/C sky130_fd_sc_hd__a22o_1
Xhold169 _6686_/Q vssd1 vssd1 vccd1 vccd1 hold169/X sky130_fd_sc_hd__dlygate4sd3_1
X_3326_ _6835_/Q vssd1 vssd1 vccd1 vccd1 _3326_/Y sky130_fd_sc_hd__inv_2
X_6114_ hold39/A _6805_/Q vssd1 vssd1 vccd1 vccd1 _6224_/B sky130_fd_sc_hd__and2b_4
XTAP_430 vssd1 vccd1 sky130_fd_sc_hd__tapvpwrvgnd_1
XTAP_441 vssd1 vccd1 sky130_fd_sc_hd__tapvpwrvgnd_1
X_6045_ _5296_/B _6038_/B _6038_/Y vssd1 vssd1 vccd1 vccd1 _6684_/D sky130_fd_sc_hd__a21o_1
XTAP_452 vssd1 vccd1 sky130_fd_sc_hd__tapvpwrvgnd_1
XTAP_463 vssd1 vccd1 sky130_fd_sc_hd__tapvpwrvgnd_1
XTAP_474 vssd1 vccd1 sky130_fd_sc_hd__tapvpwrvgnd_1
XTAP_485 vssd1 vccd1 sky130_fd_sc_hd__tapvpwrvgnd_1
XTAP_496 vssd1 vccd1 sky130_fd_sc_hd__tapvpwrvgnd_1
X_3257_ _6738_/Q vssd1 vssd1 vccd1 vccd1 _5358_/A sky130_fd_sc_hd__inv_2
XANTENNA__3663__A1 _5051_/A vssd1 vssd1 vccd1 vccd1 sky130_fd_sc_hd__diode_2
XANTENNA__6065__S _6072_/S vssd1 vssd1 vccd1 vccd1 sky130_fd_sc_hd__diode_2
XANTENNA__4374__A _5311_/A vssd1 vssd1 vccd1 vccd1 sky130_fd_sc_hd__diode_2
XFILLER_0_95_216 vssd1 vssd1 vccd1 vccd1 sky130_fd_sc_hd__fill_2
XFILLER_0_48_110 vssd1 vssd1 vccd1 vccd1 sky130_fd_sc_hd__decap_3
X_6947_ vssd1 vssd1 vccd1 vccd1 _6947_/HI tex_mport_o[0] sky130_fd_sc_hd__conb_1
XANTENNA__4093__B _4841_/D vssd1 vssd1 vccd1 vccd1 sky130_fd_sc_hd__diode_2
XFILLER_0_48_165 vssd1 vssd1 vccd1 vccd1 sky130_fd_sc_hd__fill_2
XFILLER_0_48_176 vssd1 vssd1 vccd1 vccd1 sky130_fd_sc_hd__fill_2
X_6878_ _6892_/CLK _6878_/D vssd1 vssd1 vccd1 vccd1 _6878_/Q sky130_fd_sc_hd__dfxtp_1
X_5829_ _5827_/Y _5828_/X _5599_/A _5583_/B vssd1 vssd1 vccd1 vccd1 _5829_/X sky130_fd_sc_hd__a2bb2o_1
XFILLER_0_8_284 vssd1 vssd1 vccd1 vccd1 sky130_fd_sc_hd__fill_2
Xclkbuf_leaf_18_clk_i _6684_/CLK vssd1 vssd1 vccd1 vccd1 _6734_/CLK sky130_fd_sc_hd__clkbuf_16
XFILLER_0_129_307 vssd1 vssd1 vccd1 vccd1 sky130_fd_sc_hd__fill_2
XFILLER_0_24_27 vssd1 vssd1 vccd1 vccd1 sky130_fd_sc_hd__fill_1
XFILLER_0_79_290 vssd1 vssd1 vccd1 vccd1 sky130_fd_sc_hd__fill_1
XANTENNA__4906__A1 _5083_/A vssd1 vssd1 vccd1 vccd1 sky130_fd_sc_hd__diode_2
XANTENNA__3709__A2 _5115_/C vssd1 vssd1 vccd1 vccd1 sky130_fd_sc_hd__diode_2
XFILLER_0_40_37 vssd1 vssd1 vccd1 vccd1 sky130_fd_sc_hd__fill_2
XFILLER_0_2_405 vssd1 vssd1 vccd1 vccd1 sky130_fd_sc_hd__fill_2
XFILLER_0_35_393 vssd1 vssd1 vccd1 vccd1 sky130_ef_sc_hd__decap_12
XFILLER_0_50_352 vssd1 vssd1 vccd1 vccd1 sky130_fd_sc_hd__decap_3
XFILLER_0_120_262 vssd1 vssd1 vccd1 vccd1 sky130_fd_sc_hd__fill_2
XFILLER_0_49_79 vssd1 vssd1 vccd1 vccd1 sky130_fd_sc_hd__fill_1
X_4160_ _4114_/A _4114_/C _4114_/B vssd1 vssd1 vccd1 vccd1 _4161_/C sky130_fd_sc_hd__a21bo_1
XFILLER_0_4_15 vssd1 vssd1 vccd1 vccd1 sky130_ef_sc_hd__decap_12
X_4091_ _4816_/A _4488_/A _4078_/A _4081_/A vssd1 vssd1 vccd1 vccd1 _4135_/A sky130_fd_sc_hd__a31o_1
X_6801_ _6802_/CLK hold2/X vssd1 vssd1 vccd1 vccd1 _6801_/Q sky130_fd_sc_hd__dfxtp_1
XFILLER_0_77_249 vssd1 vssd1 vccd1 vccd1 sky130_fd_sc_hd__fill_2
X_4993_ _4993_/A _4993_/B _4993_/C vssd1 vssd1 vccd1 vccd1 _4993_/Y sky130_fd_sc_hd__nand3_1
XFILLER_0_105_73 vssd1 vssd1 vccd1 vccd1 sky130_fd_sc_hd__fill_2
X_6732_ _6732_/CLK _6732_/D fanout143/X vssd1 vssd1 vccd1 vccd1 _6732_/Q sky130_fd_sc_hd__dfstp_1
X_3944_ _5801_/A _5787_/A _4971_/D _4970_/B vssd1 vssd1 vccd1 vccd1 _3947_/A sky130_fd_sc_hd__nand4_2
XANTENNA__6347__B1 _6555_/Q vssd1 vssd1 vccd1 vccd1 sky130_fd_sc_hd__diode_2
X_3875_ _3875_/A _3875_/B vssd1 vssd1 vccd1 vccd1 _3891_/C sky130_fd_sc_hd__xor2_1
XFILLER_0_45_135 vssd1 vssd1 vccd1 vccd1 sky130_fd_sc_hd__decap_4
X_6663_ _6884_/CLK _6663_/D vssd1 vssd1 vccd1 vccd1 _6663_/Q sky130_fd_sc_hd__dfxtp_1
X_5614_ _5611_/X _5612_/X _5613_/X _5607_/Y _5603_/Y vssd1 vssd1 vccd1 vccd1 _5614_/X
+ sky130_fd_sc_hd__o32a_1
XFILLER_0_121_61 vssd1 vssd1 vccd1 vccd1 sky130_fd_sc_hd__decap_3
X_6594_ _6802_/CLK _6594_/D fanout150/X vssd1 vssd1 vccd1 vccd1 tex_mport_o[37] sky130_fd_sc_hd__dfrtp_4
XFILLER_0_26_360 vssd1 vssd1 vccd1 vccd1 sky130_fd_sc_hd__decap_4
XFILLER_0_60_138 vssd1 vssd1 vccd1 vccd1 sky130_fd_sc_hd__fill_2
X_5545_ depth_mport_o[20] hold219/X _5556_/S vssd1 vssd1 vccd1 vccd1 _6576_/D sky130_fd_sc_hd__mux2_1
XFILLER_0_5_287 vssd1 vssd1 vccd1 vccd1 sky130_fd_sc_hd__fill_2
X_5476_ hold156/X sstream_i[67] _6501_/S vssd1 vssd1 vccd1 vccd1 _6509_/D sky130_fd_sc_hd__mux2_1
XFILLER_0_76_3 vssd1 vssd1 vccd1 vccd1 sky130_fd_sc_hd__fill_1
X_4427_ _5687_/B _4614_/C vssd1 vssd1 vccd1 vccd1 _4429_/B sky130_fd_sc_hd__and2_1
XANTENNA__5322__A1 _5051_/A vssd1 vssd1 vccd1 vccd1 sky130_fd_sc_hd__diode_2
X_4358_ _4359_/A _4359_/B vssd1 vssd1 vccd1 vccd1 _4358_/Y sky130_fd_sc_hd__nand2_1
X_3309_ _6851_/Q vssd1 vssd1 vccd1 vccd1 _3309_/Y sky130_fd_sc_hd__inv_2
X_4289_ _4432_/A _4774_/B _4276_/A _4274_/B vssd1 vssd1 vccd1 vccd1 _4292_/A sky130_fd_sc_hd__a31o_1
XTAP_282 vssd1 vccd1 sky130_fd_sc_hd__tapvpwrvgnd_1
XTAP_293 vssd1 vccd1 sky130_fd_sc_hd__tapvpwrvgnd_1
X_6028_ _5947_/A _6038_/C _6027_/X vssd1 vssd1 vccd1 vccd1 _6028_/Y sky130_fd_sc_hd__a21oi_1
XANTENNA__4816__B _4816_/B vssd1 vssd1 vccd1 vccd1 sky130_fd_sc_hd__diode_2
Xfanout20 _6073_/X vssd1 vssd1 vccd1 vccd1 _6315_/S sky130_fd_sc_hd__buf_4
Xfanout31 _6095_/S vssd1 vssd1 vccd1 vccd1 _6098_/S sky130_fd_sc_hd__buf_8
XFILLER_0_64_400 vssd1 vssd1 vccd1 vccd1 sky130_fd_sc_hd__decap_6
XANTENNA__6050__A2 _6038_/B vssd1 vssd1 vccd1 vccd1 sky130_fd_sc_hd__diode_2
XANTENNA__4832__A _4842_/A vssd1 vssd1 vccd1 vccd1 sky130_fd_sc_hd__diode_2
Xfanout42 _6680_/Q vssd1 vssd1 vccd1 vccd1 _5064_/B sky130_fd_sc_hd__clkbuf_8
Xfanout53 _4794_/B vssd1 vssd1 vccd1 vccd1 _5081_/B sky130_fd_sc_hd__buf_4
Xfanout64 hold298/X vssd1 vssd1 vccd1 vccd1 _4966_/B sky130_fd_sc_hd__buf_4
XFILLER_0_36_124 vssd1 vssd1 vccd1 vccd1 sky130_fd_sc_hd__decap_4
XFILLER_0_119_373 vssd1 vssd1 vccd1 vccd1 sky130_ef_sc_hd__decap_12
Xfanout75 _4841_/C vssd1 vssd1 vccd1 vccd1 _4658_/D sky130_fd_sc_hd__buf_4
Xfanout86 _4814_/D vssd1 vssd1 vccd1 vccd1 _5718_/A sky130_fd_sc_hd__buf_4
Xfanout97 tex_width_i[5] vssd1 vssd1 vccd1 vccd1 _5292_/A sky130_fd_sc_hd__buf_2
XFILLER_0_36_168 vssd1 vssd1 vccd1 vccd1 sky130_fd_sc_hd__fill_2
XFILLER_0_134_365 vssd1 vssd1 vccd1 vccd1 sky130_ef_sc_hd__decap_12
XFILLER_0_10_29 vssd1 vssd1 vccd1 vccd1 sky130_ef_sc_hd__decap_12
XFILLER_0_17_393 vssd1 vssd1 vccd1 vccd1 sky130_ef_sc_hd__decap_12
XFILLER_0_51_149 vssd1 vssd1 vccd1 vccd1 sky130_fd_sc_hd__decap_3
XFILLER_0_32_374 vssd1 vssd1 vccd1 vccd1 sky130_fd_sc_hd__fill_2
XFILLER_0_19_27 vssd1 vssd1 vccd1 vccd1 sky130_ef_sc_hd__decap_12
XFILLER_0_35_26 vssd1 vssd1 vccd1 vccd1 sky130_fd_sc_hd__fill_2
XANTENNA__4726__B _5115_/C vssd1 vssd1 vccd1 vccd1 sky130_fd_sc_hd__diode_2
XFILLER_0_59_238 vssd1 vssd1 vccd1 vccd1 sky130_fd_sc_hd__fill_2
XANTENNA__6041__A2 _6038_/B vssd1 vssd1 vccd1 vccd1 sky130_fd_sc_hd__diode_2
XFILLER_0_82_230 vssd1 vssd1 vccd1 vccd1 sky130_fd_sc_hd__fill_1
XFILLER_0_67_271 vssd1 vssd1 vccd1 vccd1 sky130_fd_sc_hd__fill_1
X_3660_ _5049_/A _5273_/B _5272_/B _5049_/B vssd1 vssd1 vccd1 vccd1 _3661_/B sky130_fd_sc_hd__a22o_1
X_3591_ _3580_/A _3580_/B _3580_/C vssd1 vssd1 vccd1 vccd1 _3591_/Y sky130_fd_sc_hd__o21ai_1
X_5330_ _5330_/A _5330_/B vssd1 vssd1 vccd1 vccd1 _5331_/B sky130_fd_sc_hd__xnor2_1
XFILLER_0_2_235 vssd1 vssd1 vccd1 vccd1 sky130_fd_sc_hd__fill_1
XANTENNA__3805__B _5083_/B vssd1 vssd1 vccd1 vccd1 sky130_fd_sc_hd__diode_2
X_5261_ _5410_/A _5410_/B _5410_/C _5259_/X _5263_/A vssd1 vssd1 vccd1 vccd1 _5441_/A
+ sky130_fd_sc_hd__a311o_1
XFILLER_0_50_193 vssd1 vssd1 vccd1 vccd1 sky130_fd_sc_hd__decap_3
X_4212_ _4212_/A _4212_/B vssd1 vssd1 vccd1 vccd1 _4219_/A sky130_fd_sc_hd__xor2_4
XANTENNA__4189__A _5801_/A vssd1 vssd1 vccd1 vccd1 sky130_fd_sc_hd__diode_2
XANTENNA__3866__A1 _5051_/B vssd1 vssd1 vccd1 vccd1 sky130_fd_sc_hd__diode_2
X_5192_ _5192_/A _5192_/B vssd1 vssd1 vccd1 vccd1 _5194_/B sky130_fd_sc_hd__nand2_1
XFILLER_0_76_77 vssd1 vssd1 vccd1 vccd1 sky130_fd_sc_hd__fill_2
X_4143_ _4476_/D _5718_/B _4170_/A _4143_/D vssd1 vssd1 vccd1 vccd1 _4170_/B sky130_fd_sc_hd__nand4_2
X_4074_ _4072_/A _4281_/A _4073_/Y _4058_/X vssd1 vssd1 vccd1 vccd1 _4240_/A sky130_fd_sc_hd__a211o_1
XANTENNA__4815__B1 _5118_/B vssd1 vssd1 vccd1 vccd1 sky130_fd_sc_hd__diode_2
XFILLER_0_116_94 vssd1 vssd1 vccd1 vccd1 sky130_fd_sc_hd__fill_2
XFILLER_0_116_83 vssd1 vssd1 vccd1 vccd1 sky130_fd_sc_hd__fill_1
XFILLER_0_92_98 vssd1 vssd1 vccd1 vccd1 sky130_fd_sc_hd__fill_1
XFILLER_0_25_92 vssd1 vssd1 vccd1 vccd1 sky130_fd_sc_hd__fill_2
XFILLER_0_46_400 vssd1 vssd1 vccd1 vccd1 sky130_fd_sc_hd__decap_6
X_6715_ _6853_/CLK hold65/X vssd1 vssd1 vccd1 vccd1 hold64/A sky130_fd_sc_hd__dfxtp_1
X_4976_ _4976_/A _4976_/B _4976_/C vssd1 vssd1 vccd1 vccd1 _4978_/B sky130_fd_sc_hd__nand3_1
X_3927_ _3927_/A _3927_/B _3925_/X vssd1 vssd1 vccd1 vccd1 _3927_/Y sky130_fd_sc_hd__nor3b_4
X_3858_ _3858_/A _3858_/B vssd1 vssd1 vccd1 vccd1 _5266_/B sky130_fd_sc_hd__nor2_1
XFILLER_0_33_105 vssd1 vssd1 vccd1 vccd1 sky130_fd_sc_hd__fill_2
XFILLER_0_41_91 vssd1 vssd1 vccd1 vccd1 sky130_fd_sc_hd__decap_3
X_6646_ _6745_/CLK _6646_/D fanout139/X vssd1 vssd1 vccd1 vccd1 _6646_/Q sky130_fd_sc_hd__dfstp_1
X_6577_ _6812_/CLK _6577_/D _6320_/C vssd1 vssd1 vccd1 vccd1 depth_mport_o[21] sky130_fd_sc_hd__dfrtp_4
XFILLER_0_26_190 vssd1 vssd1 vccd1 vccd1 sky130_fd_sc_hd__decap_4
X_3789_ _3788_/B _3788_/C _3788_/A vssd1 vssd1 vccd1 vccd1 _3791_/C sky130_fd_sc_hd__a21bo_1
XFILLER_0_131_346 vssd1 vssd1 vccd1 vccd1 sky130_fd_sc_hd__fill_1
X_5528_ depth_mport_o[3] hold118/X _5541_/S vssd1 vssd1 vccd1 vccd1 _6559_/D sky130_fd_sc_hd__mux2_1
XFILLER_0_14_363 vssd1 vssd1 vccd1 vccd1 sky130_fd_sc_hd__fill_1
XANTENNA__4099__A _4970_/B vssd1 vssd1 vccd1 vccd1 sky130_fd_sc_hd__diode_2
X_5459_ _5458_/A _5458_/B _5922_/S vssd1 vssd1 vccd1 vccd1 _5459_/X sky130_fd_sc_hd__a21o_1
XANTENNA_hold194_A _6834_/Q vssd1 vssd1 vccd1 vccd1 sky130_fd_sc_hd__diode_2
XANTENNA__4827__A _4971_/D vssd1 vssd1 vccd1 vccd1 sky130_fd_sc_hd__diode_2
XANTENNA_fanout62_A _6670_/Q vssd1 vssd1 vccd1 vccd1 sky130_fd_sc_hd__diode_2
XTAP_1223 vssd1 vccd1 sky130_fd_sc_hd__tapvpwrvgnd_1
XTAP_1212 vssd1 vccd1 sky130_fd_sc_hd__tapvpwrvgnd_1
XTAP_1201 vssd1 vccd1 sky130_fd_sc_hd__tapvpwrvgnd_1
XTAP_1256 vssd1 vccd1 sky130_fd_sc_hd__tapvpwrvgnd_1
XTAP_1245 vssd1 vccd1 sky130_fd_sc_hd__tapvpwrvgnd_1
XTAP_1234 vssd1 vccd1 sky130_fd_sc_hd__tapvpwrvgnd_1
XFILLER_0_96_377 vssd1 vssd1 vccd1 vccd1 sky130_ef_sc_hd__decap_12
XANTENNA__6023__A2 _6038_/C vssd1 vssd1 vccd1 vccd1 sky130_fd_sc_hd__diode_2
XFILLER_0_134_151 vssd1 vssd1 vccd1 vccd1 sky130_fd_sc_hd__fill_2
XFILLER_0_122_313 vssd1 vssd1 vccd1 vccd1 sky130_fd_sc_hd__fill_2
XFILLER_0_17_190 vssd1 vssd1 vccd1 vccd1 sky130_fd_sc_hd__decap_8
XFILLER_0_122_346 vssd1 vssd1 vccd1 vccd1 sky130_fd_sc_hd__fill_2
XFILLER_0_122_324 vssd1 vssd1 vccd1 vccd1 sky130_fd_sc_hd__fill_1
XFILLER_0_32_160 vssd1 vssd1 vccd1 vccd1 sky130_fd_sc_hd__fill_2
XFILLER_0_20_344 vssd1 vssd1 vccd1 vccd1 sky130_fd_sc_hd__fill_2
XANTENNA__3344__C _5320_/A vssd1 vssd1 vccd1 vccd1 sky130_fd_sc_hd__diode_2
XFILLER_0_20_377 vssd1 vssd1 vccd1 vccd1 sky130_fd_sc_hd__fill_1
XFILLER_0_46_25 vssd1 vssd1 vccd1 vccd1 sky130_fd_sc_hd__fill_1
XFILLER_0_99_160 vssd1 vssd1 vccd1 vccd1 sky130_fd_sc_hd__decap_3
XFILLER_0_1_27 vssd1 vssd1 vccd1 vccd1 sky130_ef_sc_hd__decap_12
XFILLER_0_87_366 vssd1 vssd1 vccd1 vccd1 sky130_ef_sc_hd__decap_12
X_4830_ _4830_/A _4830_/B _4830_/C vssd1 vssd1 vccd1 vccd1 _4837_/A sky130_fd_sc_hd__nand3_1
XFILLER_0_134_3 vssd1 vssd1 vccd1 vccd1 sky130_fd_sc_hd__decap_3
X_4761_ _4754_/B _4754_/C _4754_/A vssd1 vssd1 vccd1 vccd1 _4761_/Y sky130_fd_sc_hd__a21oi_1
X_4692_ _4692_/A _4692_/B vssd1 vssd1 vccd1 vccd1 _4693_/B sky130_fd_sc_hd__or2_1
X_6500_ hold111/X sstream_i[58] _6501_/S vssd1 vssd1 vccd1 vccd1 _6891_/D sky130_fd_sc_hd__mux2_1
X_3712_ _3713_/A _3713_/B vssd1 vssd1 vccd1 vccd1 _3721_/B sky130_fd_sc_hd__and2b_1
X_6431_ _6422_/A _6433_/B _6546_/Q vssd1 vssd1 vccd1 vccd1 _6432_/A sky130_fd_sc_hd__o21a_1
XANTENNA__6399__A _6543_/Q vssd1 vssd1 vccd1 vccd1 sky130_fd_sc_hd__diode_2
XANTENNA__5525__A1 hold206/X vssd1 vssd1 vccd1 vccd1 sky130_fd_sc_hd__diode_2
XFILLER_0_113_302 vssd1 vssd1 vccd1 vccd1 sky130_fd_sc_hd__fill_2
X_3643_ _5277_/A _5308_/A _5296_/A _5276_/A vssd1 vssd1 vccd1 vccd1 _3645_/C sky130_fd_sc_hd__nand4_1
XFILLER_0_125_184 vssd1 vssd1 vccd1 vccd1 sky130_fd_sc_hd__fill_2
X_6362_ hold98/A hold53/A vssd1 vssd1 vccd1 vccd1 _6376_/A sky130_fd_sc_hd__and2_1
X_3574_ _3574_/A _3574_/B vssd1 vssd1 vccd1 vccd1 _3592_/B sky130_fd_sc_hd__xnor2_1
XFILLER_0_11_300 vssd1 vssd1 vccd1 vccd1 sky130_fd_sc_hd__fill_2
X_5313_ _5313_/A _5313_/B vssd1 vssd1 vccd1 vccd1 _5317_/A sky130_fd_sc_hd__xnor2_1
X_6293_ _6864_/Q _3293_/Y _6782_/Q _5524_/B vssd1 vssd1 vccd1 vccd1 _6293_/Y sky130_fd_sc_hd__a211oi_1
XFILLER_0_11_355 vssd1 vssd1 vccd1 vccd1 sky130_fd_sc_hd__fill_2
X_5244_ _5210_/A _5210_/B _5208_/Y vssd1 vssd1 vccd1 vccd1 _5251_/A sky130_fd_sc_hd__a21oi_1
Xhold29 hold29/A vssd1 vssd1 vccd1 vccd1 hold29/X sky130_fd_sc_hd__dlygate4sd3_1
Xhold18 hold18/A vssd1 vssd1 vccd1 vccd1 hold18/X sky130_fd_sc_hd__dlygate4sd3_1
X_5175_ _5175_/A _5175_/B vssd1 vssd1 vccd1 vccd1 _5177_/B sky130_fd_sc_hd__xor2_1
X_4126_ _4794_/B _4432_/A _4110_/A _4108_/B vssd1 vssd1 vccd1 vccd1 _4128_/A sky130_fd_sc_hd__a31o_1
XFILLER_0_97_119 vssd1 vssd1 vccd1 vccd1 sky130_fd_sc_hd__decap_3
X_4057_ _4122_/A _4056_/C _4056_/A vssd1 vssd1 vccd1 vccd1 _4058_/C sky130_fd_sc_hd__a21o_1
XFILLER_0_78_322 vssd1 vssd1 vccd1 vccd1 sky130_fd_sc_hd__decap_6
XFILLER_0_38_219 vssd1 vssd1 vccd1 vccd1 sky130_fd_sc_hd__decap_3
XANTENNA__4813__C _4966_/B vssd1 vssd1 vccd1 vccd1 sky130_fd_sc_hd__diode_2
XFILLER_0_93_358 vssd1 vssd1 vccd1 vccd1 sky130_ef_sc_hd__decap_12
XANTENNA__5764__A1 _5763_/X vssd1 vssd1 vccd1 vccd1 sky130_fd_sc_hd__diode_2
X_4959_ _4958_/B _5118_/B _4814_/D _4816_/A vssd1 vssd1 vccd1 vccd1 _4960_/D sky130_fd_sc_hd__a22o_1
XFILLER_0_61_200 vssd1 vssd1 vccd1 vccd1 sky130_fd_sc_hd__fill_2
X_6629_ _6802_/CLK _6629_/D fanout142/X vssd1 vssd1 vccd1 vccd1 _6629_/Q sky130_fd_sc_hd__dfstp_1
XFILLER_0_104_335 vssd1 vssd1 vccd1 vccd1 sky130_ef_sc_hd__decap_12
XANTENNA__3461__A _5286_/A vssd1 vssd1 vccd1 vccd1 sky130_fd_sc_hd__diode_2
XFILLER_0_107_19 vssd1 vssd1 vccd1 vccd1 sky130_fd_sc_hd__fill_1
XFILLER_0_69_322 vssd1 vssd1 vccd1 vccd1 sky130_fd_sc_hd__decap_4
XTAP_1031 vssd1 vccd1 sky130_fd_sc_hd__tapvpwrvgnd_1
XTAP_1020 vssd1 vccd1 sky130_fd_sc_hd__tapvpwrvgnd_1
XFILLER_0_96_141 vssd1 vssd1 vccd1 vccd1 sky130_fd_sc_hd__fill_1
XFILLER_0_29_208 vssd1 vssd1 vccd1 vccd1 sky130_fd_sc_hd__fill_1
XFILLER_0_127_405 vssd1 vssd1 vccd1 vccd1 sky130_fd_sc_hd__fill_2
XTAP_1064 vssd1 vccd1 sky130_fd_sc_hd__tapvpwrvgnd_1
XTAP_1053 vssd1 vccd1 sky130_fd_sc_hd__tapvpwrvgnd_1
XTAP_1042 vssd1 vccd1 sky130_fd_sc_hd__tapvpwrvgnd_1
XFILLER_0_32_16 vssd1 vssd1 vccd1 vccd1 sky130_fd_sc_hd__fill_2
XTAP_1097 vssd1 vccd1 sky130_fd_sc_hd__tapvpwrvgnd_1
XTAP_1086 vssd1 vccd1 sky130_fd_sc_hd__tapvpwrvgnd_1
XTAP_1075 vssd1 vccd1 sky130_fd_sc_hd__tapvpwrvgnd_1
XFILLER_0_84_369 vssd1 vssd1 vccd1 vccd1 sky130_ef_sc_hd__decap_12
XFILLER_0_37_241 vssd1 vssd1 vccd1 vccd1 sky130_fd_sc_hd__fill_1
XFILLER_0_12_108 vssd1 vssd1 vccd1 vccd1 sky130_fd_sc_hd__decap_4
XFILLER_0_20_141 vssd1 vssd1 vccd1 vccd1 sky130_fd_sc_hd__decap_4
XTAP_826 vssd1 vccd1 sky130_fd_sc_hd__tapvpwrvgnd_1
XTAP_815 vssd1 vccd1 sky130_fd_sc_hd__tapvpwrvgnd_1
XTAP_804 vssd1 vccd1 sky130_fd_sc_hd__tapvpwrvgnd_1
X_3290_ tex_height_i[3] vssd1 vssd1 vccd1 vccd1 _3290_/Y sky130_fd_sc_hd__inv_2
XTAP_859 vssd1 vccd1 sky130_fd_sc_hd__tapvpwrvgnd_1
XTAP_848 vssd1 vccd1 sky130_fd_sc_hd__tapvpwrvgnd_1
XTAP_837 vssd1 vccd1 sky130_fd_sc_hd__tapvpwrvgnd_1
XFILLER_0_57_57 vssd1 vssd1 vccd1 vccd1 sky130_fd_sc_hd__fill_1
X_6980_ vssd1 vssd1 vccd1 vccd1 _6980_/HI tex_mport_o[66] sky130_fd_sc_hd__conb_1
XANTENNA__3521__D _5277_/B vssd1 vssd1 vccd1 vccd1 sky130_fd_sc_hd__diode_2
X_5931_ hold108/X tex_mport_i[6] _5932_/S vssd1 vssd1 vccd1 vccd1 _6659_/D sky130_fd_sc_hd__mux2_1
XFILLER_0_118_405 vssd1 vssd1 vccd1 vccd1 sky130_fd_sc_hd__fill_2
X_5862_ tex_addr_i[24] _5913_/B vssd1 vssd1 vccd1 vccd1 _5867_/A sky130_fd_sc_hd__xnor2_1
X_5793_ _5782_/A _5782_/B _5779_/X _5781_/B vssd1 vssd1 vccd1 vccd1 _5794_/B sky130_fd_sc_hd__o31a_1
XFILLER_0_7_113 vssd1 vssd1 vccd1 vccd1 sky130_ef_sc_hd__decap_12
X_4813_ _4809_/X _4813_/B _4966_/B _4822_/B vssd1 vssd1 vccd1 vccd1 _4813_/X sky130_fd_sc_hd__and4b_1
X_4744_ _4743_/B _4743_/C _4743_/A vssd1 vssd1 vccd1 vccd1 _4750_/B sky130_fd_sc_hd__a21o_1
XFILLER_0_83_391 vssd1 vssd1 vccd1 vccd1 sky130_fd_sc_hd__fill_1
XFILLER_0_43_233 vssd1 vssd1 vccd1 vccd1 sky130_ef_sc_hd__decap_12
X_4675_ _4675_/A _4675_/B vssd1 vssd1 vccd1 vccd1 _4680_/A sky130_fd_sc_hd__xnor2_2
XANTENNA__3546__A _5081_/B vssd1 vssd1 vccd1 vccd1 sky130_fd_sc_hd__diode_2
X_6414_ _6416_/A _6416_/B _6416_/C _6416_/D vssd1 vssd1 vccd1 vccd1 _6415_/B sky130_fd_sc_hd__o31a_1
XANTENNA_fanout112_A _5091_/B vssd1 vssd1 vccd1 vccd1 sky130_fd_sc_hd__diode_2
X_3626_ _3626_/A _3626_/B vssd1 vssd1 vccd1 vccd1 _3642_/A sky130_fd_sc_hd__xor2_1
X_6345_ hold98/A hold75/A vssd1 vssd1 vccd1 vccd1 _6346_/C sky130_fd_sc_hd__or2_1
X_3557_ _3557_/A _3557_/B _3557_/C vssd1 vssd1 vccd1 vccd1 _3559_/B sky130_fd_sc_hd__nor3_1
XFILLER_0_3_385 vssd1 vssd1 vccd1 vccd1 sky130_fd_sc_hd__decap_6
X_6276_ _6276_/A _6276_/B _6234_/X vssd1 vssd1 vccd1 vccd1 _6277_/D sky130_fd_sc_hd__or3b_1
X_3488_ _3489_/A _3489_/B _3489_/C vssd1 vssd1 vccd1 vccd1 _3488_/X sky130_fd_sc_hd__o21a_1
X_5227_ _4933_/A _4933_/B _4934_/X vssd1 vssd1 vccd1 vccd1 _5229_/B sky130_fd_sc_hd__o21bai_1
XANTENNA__6068__S _6072_/S vssd1 vssd1 vccd1 vccd1 sky130_fd_sc_hd__diode_2
X_5158_ _5100_/X _5102_/Y _5101_/Y vssd1 vssd1 vccd1 vccd1 _5160_/C sky130_fd_sc_hd__o21bai_2
X_4109_ _4794_/B _4432_/A vssd1 vssd1 vccd1 vccd1 _4110_/B sky130_fd_sc_hd__nand2_1
X_5089_ _5154_/A _5088_/B _5085_/X vssd1 vssd1 vccd1 vccd1 _5100_/A sky130_fd_sc_hd__a21o_1
XFILLER_0_78_141 vssd1 vssd1 vccd1 vccd1 sky130_fd_sc_hd__fill_2
XANTENNA__4824__B _4966_/A vssd1 vssd1 vccd1 vccd1 sky130_fd_sc_hd__diode_2
XANTENNA__4788__A2 _4789_/C vssd1 vssd1 vccd1 vccd1 sky130_fd_sc_hd__diode_2
XFILLER_0_109_405 vssd1 vssd1 vccd1 vccd1 sky130_fd_sc_hd__fill_2
XPHY_125 vssd1 vssd1 vccd1 vccd1 sky130_fd_sc_hd__decap_3
XANTENNA__3460__A2 _5273_/A vssd1 vssd1 vccd1 vccd1 sky130_fd_sc_hd__diode_2
XPHY_103 vssd1 vssd1 vccd1 vccd1 sky130_fd_sc_hd__decap_3
XPHY_114 vssd1 vssd1 vccd1 vccd1 sky130_fd_sc_hd__decap_3
XPHY_158 vssd1 vssd1 vccd1 vccd1 sky130_fd_sc_hd__decap_3
XPHY_147 vssd1 vssd1 vccd1 vccd1 sky130_fd_sc_hd__decap_3
XPHY_136 vssd1 vssd1 vccd1 vccd1 sky130_fd_sc_hd__decap_3
XFILLER_0_19_241 vssd1 vssd1 vccd1 vccd1 sky130_fd_sc_hd__fill_1
XPHY_169 vssd1 vssd1 vccd1 vccd1 sky130_fd_sc_hd__decap_3
XFILLER_0_19_296 vssd1 vssd1 vccd1 vccd1 sky130_fd_sc_hd__fill_2
XANTENNA_70 sstream_i[23] vssd1 vssd1 vccd1 vccd1 sky130_fd_sc_hd__diode_2
XANTENNA_92 sstream_i[3] vssd1 vssd1 vccd1 vccd1 sky130_fd_sc_hd__diode_2
XANTENNA_81 sstream_i[2] vssd1 vssd1 vccd1 vccd1 sky130_fd_sc_hd__diode_2
XFILLER_0_22_406 vssd1 vssd1 vccd1 vccd1 sky130_fd_sc_hd__fill_1
XFILLER_0_34_277 vssd1 vssd1 vccd1 vccd1 sky130_fd_sc_hd__decap_6
XFILLER_0_104_132 vssd1 vssd1 vccd1 vccd1 sky130_fd_sc_hd__fill_2
XFILLER_0_34_288 vssd1 vssd1 vccd1 vccd1 sky130_fd_sc_hd__fill_1
XANTENNA__5390__B _5574_/B vssd1 vssd1 vccd1 vccd1 sky130_fd_sc_hd__diode_2
XFILLER_0_27_27 vssd1 vssd1 vccd1 vccd1 sky130_fd_sc_hd__fill_1
XFILLER_0_69_152 vssd1 vssd1 vccd1 vccd1 sky130_fd_sc_hd__decap_3
XPHY_5 vssd1 vssd1 vccd1 vccd1 sky130_fd_sc_hd__decap_3
XFILLER_0_84_188 vssd1 vssd1 vccd1 vccd1 sky130_fd_sc_hd__fill_2
XFILLER_0_127_279 vssd1 vssd1 vccd1 vccd1 sky130_fd_sc_hd__fill_1
XANTENNA__4400__B2 _4774_/B vssd1 vssd1 vccd1 vccd1 sky130_fd_sc_hd__diode_2
XANTENNA__4400__A1 _4432_/A vssd1 vssd1 vccd1 vccd1 sky130_fd_sc_hd__diode_2
XFILLER_0_25_222 vssd1 vssd1 vccd1 vccd1 sky130_fd_sc_hd__fill_2
XFILLER_0_80_361 vssd1 vssd1 vccd1 vccd1 sky130_fd_sc_hd__decap_3
XFILLER_0_135_290 vssd1 vssd1 vccd1 vccd1 sky130_fd_sc_hd__decap_3
X_4460_ _4451_/Y _4455_/A _4458_/Y _4459_/X vssd1 vssd1 vccd1 vccd1 _4460_/Y sky130_fd_sc_hd__a211oi_4
XFILLER_0_7_15 vssd1 vssd1 vccd1 vccd1 sky130_ef_sc_hd__decap_12
X_4391_ _4338_/A _4337_/C _4337_/B vssd1 vssd1 vccd1 vccd1 _4392_/C sky130_fd_sc_hd__a21o_1
XFILLER_0_0_300 vssd1 vssd1 vccd1 vccd1 sky130_fd_sc_hd__fill_2
X_3411_ _3411_/A _3411_/B vssd1 vssd1 vccd1 vccd1 _3622_/A sky130_fd_sc_hd__nor2_1
X_6130_ hold61/X _6136_/B vssd1 vssd1 vccd1 vccd1 _6130_/X sky130_fd_sc_hd__or2_1
XFILLER_0_68_67 vssd1 vssd1 vccd1 vccd1 sky130_fd_sc_hd__decap_3
X_3342_ _3344_/D vssd1 vssd1 vccd1 vccd1 _3342_/Y sky130_fd_sc_hd__inv_2
XFILLER_0_0_333 vssd1 vssd1 vccd1 vccd1 sky130_fd_sc_hd__decap_3
XANTENNA__3911__B1 _4966_/B vssd1 vssd1 vccd1 vccd1 sky130_fd_sc_hd__diode_2
XFILLER_0_0_377 vssd1 vssd1 vccd1 vccd1 sky130_fd_sc_hd__fill_2
XTAP_601 vssd1 vccd1 sky130_fd_sc_hd__tapvpwrvgnd_1
XTAP_612 vssd1 vccd1 sky130_fd_sc_hd__tapvpwrvgnd_1
XTAP_623 vssd1 vccd1 sky130_fd_sc_hd__tapvpwrvgnd_1
XTAP_634 vssd1 vccd1 sky130_fd_sc_hd__tapvpwrvgnd_1
X_6061_ hold5/X hold7/X _6061_/S vssd1 vssd1 vccd1 vccd1 _6700_/D sky130_fd_sc_hd__mux2_1
X_3273_ _6513_/Q vssd1 vssd1 vccd1 vccd1 _5603_/B sky130_fd_sc_hd__inv_2
XTAP_645 vssd1 vccd1 sky130_fd_sc_hd__tapvpwrvgnd_1
XTAP_656 vssd1 vccd1 sky130_fd_sc_hd__tapvpwrvgnd_1
XTAP_667 vssd1 vccd1 sky130_fd_sc_hd__tapvpwrvgnd_1
X_5012_ _5013_/A _5013_/B vssd1 vssd1 vccd1 vccd1 _5012_/Y sky130_fd_sc_hd__nor2_1
XTAP_678 vssd1 vccd1 sky130_fd_sc_hd__tapvpwrvgnd_1
XTAP_689 vssd1 vccd1 sky130_fd_sc_hd__tapvpwrvgnd_1
X_6963_ vssd1 vssd1 vccd1 vccd1 _6963_/HI tex_mport_o[16] sky130_fd_sc_hd__conb_1
X_6894_ vssd1 vssd1 vccd1 vccd1 _6894_/HI depth_mport_o[33] sky130_fd_sc_hd__conb_1
X_5914_ _5902_/A _5902_/B _5909_/A _5907_/B _5897_/B vssd1 vssd1 vccd1 vccd1 _5916_/C
+ sky130_fd_sc_hd__o311a_1
XFILLER_0_48_303 vssd1 vssd1 vccd1 vccd1 sky130_fd_sc_hd__decap_4
XANTENNA__5719__A1 _5718_/B vssd1 vssd1 vccd1 vccd1 sky130_fd_sc_hd__diode_2
XFILLER_0_75_122 vssd1 vssd1 vccd1 vccd1 sky130_fd_sc_hd__decap_3
X_5845_ tex_addr_i[21] _5913_/B vssd1 vssd1 vccd1 vccd1 _5863_/B sky130_fd_sc_hd__xnor2_1
XFILLER_0_63_317 vssd1 vssd1 vccd1 vccd1 sky130_fd_sc_hd__fill_1
XFILLER_0_133_216 vssd1 vssd1 vccd1 vccd1 sky130_fd_sc_hd__decap_8
X_5776_ hold196/X _5775_/X _5844_/S vssd1 vssd1 vccd1 vccd1 _6633_/D sky130_fd_sc_hd__mux2_1
XFILLER_0_90_136 vssd1 vssd1 vccd1 vccd1 sky130_fd_sc_hd__fill_2
XFILLER_0_90_125 vssd1 vssd1 vccd1 vccd1 sky130_fd_sc_hd__decap_3
X_4727_ _4476_/D _4958_/B _4814_/D _5115_/C vssd1 vssd1 vccd1 vccd1 _4728_/D sky130_fd_sc_hd__a22o_1
X_4658_ _5645_/A _5645_/B _4688_/C _4658_/D vssd1 vssd1 vccd1 vccd1 _4682_/B sky130_fd_sc_hd__nand4_1
XFILLER_0_71_372 vssd1 vssd1 vccd1 vccd1 sky130_fd_sc_hd__fill_2
XFILLER_0_16_299 vssd1 vssd1 vccd1 vccd1 sky130_fd_sc_hd__fill_1
XFILLER_0_31_225 vssd1 vssd1 vccd1 vccd1 sky130_fd_sc_hd__fill_2
X_3609_ _3608_/A _3607_/Y _3580_/X _3591_/Y vssd1 vssd1 vccd1 vccd1 _3612_/A sky130_fd_sc_hd__o211a_2
XFILLER_0_101_124 vssd1 vssd1 vccd1 vccd1 sky130_fd_sc_hd__fill_2
X_4589_ _6626_/Q _4613_/B vssd1 vssd1 vccd1 vccd1 _4589_/X sky130_fd_sc_hd__and2_1
X_6328_ _6328_/A _6328_/B vssd1 vssd1 vccd1 vccd1 _6806_/D sky130_fd_sc_hd__nor2_1
X_6259_ depth_mport_i[1] _6259_/B vssd1 vssd1 vccd1 vccd1 _6259_/X sky130_fd_sc_hd__or2_1
XANTENNA__3723__B _4944_/B vssd1 vssd1 vccd1 vccd1 sky130_fd_sc_hd__diode_2
XANTENNA__4273__C _4736_/D vssd1 vssd1 vccd1 vccd1 sky130_fd_sc_hd__diode_2
XFILLER_0_66_122 vssd1 vssd1 vccd1 vccd1 sky130_fd_sc_hd__fill_2
XANTENNA__5666__A _5666_/A vssd1 vssd1 vccd1 vccd1 sky130_fd_sc_hd__diode_2
XFILLER_0_54_317 vssd1 vssd1 vccd1 vccd1 sky130_ef_sc_hd__decap_12
XFILLER_0_81_169 vssd1 vssd1 vccd1 vccd1 sky130_fd_sc_hd__fill_1
XFILLER_0_81_158 vssd1 vssd1 vccd1 vccd1 sky130_fd_sc_hd__fill_1
XFILLER_0_62_394 vssd1 vssd1 vccd1 vccd1 sky130_ef_sc_hd__decap_12
XFILLER_0_120_400 vssd1 vssd1 vccd1 vccd1 sky130_fd_sc_hd__decap_6
XFILLER_0_89_225 vssd1 vssd1 vccd1 vccd1 sky130_fd_sc_hd__fill_2
XANTENNA__4745__A _6673_/Q vssd1 vssd1 vccd1 vccd1 sky130_fd_sc_hd__diode_2
X_3960_ _5081_/B _5081_/C _5081_/D _5083_/A vssd1 vssd1 vccd1 vccd1 _3961_/D sky130_fd_sc_hd__a22o_1
XANTENNA__4183__C _4966_/A vssd1 vssd1 vccd1 vccd1 sky130_fd_sc_hd__diode_2
XFILLER_0_57_133 vssd1 vssd1 vccd1 vccd1 sky130_fd_sc_hd__decap_4
XFILLER_0_72_103 vssd1 vssd1 vccd1 vccd1 sky130_fd_sc_hd__fill_1
XFILLER_0_70_57 vssd1 vssd1 vccd1 vccd1 sky130_fd_sc_hd__fill_1
X_3891_ _3891_/A _3891_/B _3891_/C vssd1 vssd1 vccd1 vccd1 _3892_/B sky130_fd_sc_hd__nor3_1
X_5630_ _5614_/X _5621_/X _5626_/X _5629_/X vssd1 vssd1 vccd1 vccd1 _5647_/A sky130_fd_sc_hd__o31a_1
X_5561_ _5796_/A _5561_/B vssd1 vssd1 vccd1 vccd1 _5561_/X sky130_fd_sc_hd__and2_1
XFILLER_0_60_309 vssd1 vssd1 vccd1 vccd1 sky130_fd_sc_hd__fill_1
X_5492_ hold31/X sstream_i[83] _6450_/S vssd1 vssd1 vccd1 vccd1 _6525_/D sky130_fd_sc_hd__mux2_1
X_4512_ _4480_/A _4480_/C _4480_/B vssd1 vssd1 vccd1 vccd1 _4524_/B sky130_fd_sc_hd__a21o_1
Xhold104 _6695_/Q vssd1 vssd1 vccd1 vccd1 hold104/X sky130_fd_sc_hd__dlygate4sd3_1
XFILLER_0_80_191 vssd1 vssd1 vccd1 vccd1 sky130_fd_sc_hd__fill_2
Xhold115 _6506_/Q vssd1 vssd1 vccd1 vccd1 hold115/X sky130_fd_sc_hd__dlygate4sd3_1
Xhold126 _6519_/Q vssd1 vssd1 vccd1 vccd1 hold126/X sky130_fd_sc_hd__dlygate4sd3_1
XFILLER_0_110_85 vssd1 vssd1 vccd1 vccd1 sky130_fd_sc_hd__decap_4
XFILLER_0_110_63 vssd1 vssd1 vccd1 vccd1 sky130_fd_sc_hd__fill_2
X_4443_ _4443_/A _4443_/B _4485_/A vssd1 vssd1 vccd1 vccd1 _4457_/A sky130_fd_sc_hd__or3_2
Xhold148 _6515_/Q vssd1 vssd1 vccd1 vccd1 hold148/X sky130_fd_sc_hd__dlygate4sd3_1
Xhold159 _6691_/Q vssd1 vssd1 vccd1 vccd1 hold159/X sky130_fd_sc_hd__dlygate4sd3_1
Xhold137 _6868_/Q vssd1 vssd1 vccd1 vccd1 hold137/X sky130_fd_sc_hd__dlygate4sd3_1
X_4374_ _5311_/A _4582_/D vssd1 vssd1 vccd1 vccd1 _4376_/B sky130_fd_sc_hd__and2_1
XFILLER_0_0_141 vssd1 vssd1 vccd1 vccd1 sky130_fd_sc_hd__fill_2
XANTENNA__3896__C1 _6683_/Q vssd1 vssd1 vccd1 vccd1 sky130_fd_sc_hd__diode_2
X_3325_ _6836_/Q vssd1 vssd1 vccd1 vccd1 _3325_/Y sky130_fd_sc_hd__inv_2
XTAP_420 vssd1 vccd1 sky130_fd_sc_hd__tapvpwrvgnd_1
XTAP_431 vssd1 vccd1 sky130_fd_sc_hd__tapvpwrvgnd_1
XTAP_442 vssd1 vccd1 sky130_fd_sc_hd__tapvpwrvgnd_1
X_6113_ hold186/X _6751_/Q _6113_/S vssd1 vssd1 vccd1 vccd1 _6113_/X sky130_fd_sc_hd__mux2_1
XFILLER_0_119_50 vssd1 vssd1 vccd1 vccd1 sky130_fd_sc_hd__decap_4
XFILLER_0_95_98 vssd1 vssd1 vccd1 vccd1 sky130_fd_sc_hd__fill_2
X_3256_ _5754_/A vssd1 vssd1 vccd1 vccd1 _3256_/Y sky130_fd_sc_hd__inv_2
X_6044_ _5286_/B _6038_/B _6038_/Y vssd1 vssd1 vccd1 vccd1 _6683_/D sky130_fd_sc_hd__a21o_1
XTAP_453 vssd1 vccd1 sky130_fd_sc_hd__tapvpwrvgnd_1
XTAP_464 vssd1 vccd1 sky130_fd_sc_hd__tapvpwrvgnd_1
XTAP_475 vssd1 vccd1 sky130_fd_sc_hd__tapvpwrvgnd_1
XTAP_486 vssd1 vccd1 sky130_fd_sc_hd__tapvpwrvgnd_1
XTAP_497 vssd1 vccd1 sky130_fd_sc_hd__tapvpwrvgnd_1
XFILLER_0_21_3 vssd1 vssd1 vccd1 vccd1 sky130_ef_sc_hd__decap_12
XANTENNA__3663__A2 _6683_/Q vssd1 vssd1 vccd1 vccd1 sky130_fd_sc_hd__diode_2
X_6946_ vssd1 vssd1 vccd1 vccd1 _6946_/HI pix_mport_o[67] sky130_fd_sc_hd__conb_1
XFILLER_0_8_230 vssd1 vssd1 vccd1 vccd1 sky130_fd_sc_hd__decap_3
XFILLER_0_36_317 vssd1 vssd1 vccd1 vccd1 sky130_fd_sc_hd__fill_2
X_6877_ _6892_/CLK _6877_/D vssd1 vssd1 vccd1 vccd1 _6877_/Q sky130_fd_sc_hd__dfxtp_1
XANTENNA__6081__S _6315_/S vssd1 vssd1 vccd1 vccd1 sky130_fd_sc_hd__diode_2
XFILLER_0_63_136 vssd1 vssd1 vccd1 vccd1 sky130_fd_sc_hd__fill_2
X_5828_ _5837_/A _5825_/X _5826_/Y _5599_/A vssd1 vssd1 vccd1 vccd1 _5828_/X sky130_fd_sc_hd__a31o_1
X_5759_ _5772_/A _5759_/B vssd1 vssd1 vccd1 vccd1 _5759_/Y sky130_fd_sc_hd__nand2_1
XANTENNA__3437__C _5311_/A vssd1 vssd1 vccd1 vccd1 sky130_fd_sc_hd__diode_2
XFILLER_0_86_228 vssd1 vssd1 vccd1 vccd1 sky130_fd_sc_hd__fill_1
XFILLER_0_39_122 vssd1 vssd1 vccd1 vccd1 sky130_fd_sc_hd__fill_1
XFILLER_0_94_250 vssd1 vssd1 vccd1 vccd1 sky130_fd_sc_hd__fill_2
XFILLER_0_82_401 vssd1 vssd1 vccd1 vccd1 sky130_fd_sc_hd__decap_6
XANTENNA__3909__A _5801_/A vssd1 vssd1 vccd1 vccd1 sky130_fd_sc_hd__diode_2
XANTENNA__4198__A1_N _4971_/B vssd1 vssd1 vccd1 vccd1 sky130_fd_sc_hd__diode_2
XFILLER_0_40_27 vssd1 vssd1 vccd1 vccd1 sky130_fd_sc_hd__fill_1
XFILLER_0_137_374 vssd1 vssd1 vccd1 vccd1 sky130_ef_sc_hd__decap_12
XANTENNA__4906__A2 _4432_/A vssd1 vssd1 vccd1 vccd1 sky130_fd_sc_hd__diode_2
XANTENNA__3628__B _5277_/B vssd1 vssd1 vccd1 vccd1 sky130_fd_sc_hd__diode_2
XFILLER_0_35_350 vssd1 vssd1 vccd1 vccd1 sky130_fd_sc_hd__fill_2
XFILLER_0_42_309 vssd1 vssd1 vccd1 vccd1 sky130_fd_sc_hd__fill_2
XFILLER_0_54_147 vssd1 vssd1 vccd1 vccd1 sky130_fd_sc_hd__fill_2
XFILLER_0_62_180 vssd1 vssd1 vccd1 vccd1 sky130_fd_sc_hd__fill_2
XFILLER_0_10_206 vssd1 vssd1 vccd1 vccd1 sky130_fd_sc_hd__decap_6
XFILLER_0_49_36 vssd1 vssd1 vccd1 vccd1 sky130_fd_sc_hd__fill_2
XFILLER_0_49_47 vssd1 vssd1 vccd1 vccd1 sky130_fd_sc_hd__decap_3
XFILLER_0_120_296 vssd1 vssd1 vccd1 vccd1 sky130_fd_sc_hd__fill_2
XANTENNA__3363__B _5049_/B vssd1 vssd1 vccd1 vccd1 sky130_fd_sc_hd__diode_2
XFILLER_0_4_27 vssd1 vssd1 vccd1 vccd1 sky130_fd_sc_hd__fill_1
X_4090_ _4243_/B _4243_/A vssd1 vssd1 vccd1 vccd1 _4090_/Y sky130_fd_sc_hd__nand2b_1
XFILLER_0_65_35 vssd1 vssd1 vccd1 vccd1 sky130_fd_sc_hd__fill_2
XANTENNA__5095__A1 _5051_/A vssd1 vssd1 vccd1 vccd1 sky130_fd_sc_hd__diode_2
XFILLER_0_65_68 vssd1 vssd1 vccd1 vccd1 sky130_fd_sc_hd__fill_2
X_6800_ _6818_/CLK _6800_/D vssd1 vssd1 vccd1 vccd1 hold61/A sky130_fd_sc_hd__dfxtp_1
X_4992_ _4993_/A _4993_/B _4993_/C vssd1 vssd1 vccd1 vccd1 _4992_/X sky130_fd_sc_hd__and3_1
XANTENNA_hold98_A hold98/A vssd1 vssd1 vccd1 vccd1 sky130_fd_sc_hd__diode_2
X_6731_ _6732_/CLK _6731_/D fanout142/X vssd1 vssd1 vccd1 vccd1 _6731_/Q sky130_fd_sc_hd__dfstp_1
XFILLER_0_81_89 vssd1 vssd1 vccd1 vccd1 sky130_fd_sc_hd__fill_2
XFILLER_0_14_72 vssd1 vssd1 vccd1 vccd1 sky130_fd_sc_hd__fill_2
X_3943_ _3912_/A _3912_/C _3912_/B vssd1 vssd1 vccd1 vccd1 _3949_/B sky130_fd_sc_hd__a21o_1
XFILLER_0_128_363 vssd1 vssd1 vccd1 vccd1 sky130_fd_sc_hd__fill_1
XFILLER_0_85_272 vssd1 vssd1 vccd1 vccd1 sky130_fd_sc_hd__decap_6
X_6662_ _6892_/CLK _6662_/D vssd1 vssd1 vccd1 vccd1 _6662_/Q sky130_fd_sc_hd__dfxtp_1
X_3874_ _3920_/A _3920_/B vssd1 vssd1 vccd1 vccd1 _3891_/B sky130_fd_sc_hd__and2_1
X_5613_ _3249_/Y _6510_/Q _6509_/Q _3253_/Y _5603_/Y vssd1 vssd1 vccd1 vccd1 _5613_/X
+ sky130_fd_sc_hd__a221o_1
XFILLER_0_45_169 vssd1 vssd1 vccd1 vccd1 sky130_fd_sc_hd__decap_4
X_6593_ _6863_/CLK _6593_/D _6073_/A vssd1 vssd1 vccd1 vccd1 tex_mport_o[36] sky130_fd_sc_hd__dfrtp_4
XFILLER_0_5_244 vssd1 vssd1 vccd1 vccd1 sky130_fd_sc_hd__fill_2
X_5544_ depth_mport_o[19] hold229/X _5556_/S vssd1 vssd1 vccd1 vccd1 _6575_/D sky130_fd_sc_hd__mux2_1
X_5475_ hold145/X sstream_i[66] _6501_/S vssd1 vssd1 vccd1 vccd1 _6508_/D sky130_fd_sc_hd__mux2_1
XFILLER_0_30_93 vssd1 vssd1 vccd1 vccd1 sky130_fd_sc_hd__decap_3
XFILLER_0_41_364 vssd1 vssd1 vccd1 vccd1 sky130_fd_sc_hd__fill_2
X_4426_ _4942_/A _4942_/B _6663_/Q _4637_/D vssd1 vssd1 vccd1 vccd1 _4429_/A sky130_fd_sc_hd__nand4_1
XFILLER_0_69_3 vssd1 vssd1 vccd1 vccd1 sky130_fd_sc_hd__fill_2
XANTENNA__3345__A1_N _5320_/A vssd1 vssd1 vccd1 vccd1 sky130_fd_sc_hd__diode_2
X_4357_ _4357_/A _4357_/B vssd1 vssd1 vccd1 vccd1 _4359_/B sky130_fd_sc_hd__xnor2_1
X_3308_ depth_mport_i[18] vssd1 vssd1 vccd1 vccd1 _3308_/Y sky130_fd_sc_hd__inv_2
X_4288_ _4264_/X _4287_/X _4241_/B _4251_/X vssd1 vssd1 vccd1 vccd1 _4301_/A sky130_fd_sc_hd__o211a_1
XTAP_283 vssd1 vccd1 sky130_fd_sc_hd__tapvpwrvgnd_1
XANTENNA__6076__S _6315_/S vssd1 vssd1 vccd1 vccd1 sky130_fd_sc_hd__diode_2
X_6027_ _6038_/C _6031_/B _6027_/C vssd1 vssd1 vccd1 vccd1 _6027_/X sky130_fd_sc_hd__and3b_1
XTAP_294 vssd1 vccd1 sky130_fd_sc_hd__tapvpwrvgnd_1
XFILLER_0_68_217 vssd1 vssd1 vccd1 vccd1 sky130_fd_sc_hd__fill_1
XFILLER_0_68_206 vssd1 vssd1 vccd1 vccd1 sky130_fd_sc_hd__decap_4
X_6929_ vssd1 vssd1 vccd1 vccd1 _6929_/HI pix_mport_o[30] sky130_fd_sc_hd__conb_1
XFILLER_0_138_138 vssd1 vssd1 vccd1 vccd1 sky130_fd_sc_hd__fill_2
Xfanout10 _6486_/S vssd1 vssd1 vccd1 vccd1 _6501_/S sky130_fd_sc_hd__clkbuf_8
XFILLER_0_76_250 vssd1 vssd1 vccd1 vccd1 sky130_fd_sc_hd__fill_2
Xfanout21 _5937_/Y vssd1 vssd1 vccd1 vccd1 _6038_/B sky130_fd_sc_hd__clkbuf_8
Xfanout65 _4970_/B vssd1 vssd1 vccd1 vccd1 _4518_/D sky130_fd_sc_hd__clkbuf_8
Xfanout32 _3261_/Y vssd1 vssd1 vccd1 vccd1 _5922_/S sky130_fd_sc_hd__clkbuf_8
Xfanout43 _5071_/A vssd1 vssd1 vccd1 vccd1 _5277_/A sky130_fd_sc_hd__buf_4
Xfanout54 _6674_/Q vssd1 vssd1 vccd1 vccd1 _4794_/B sky130_fd_sc_hd__buf_4
XFILLER_0_119_385 vssd1 vssd1 vccd1 vccd1 sky130_fd_sc_hd__decap_6
XFILLER_0_91_231 vssd1 vssd1 vccd1 vccd1 sky130_fd_sc_hd__fill_2
XFILLER_0_24_309 vssd1 vssd1 vccd1 vccd1 sky130_fd_sc_hd__decap_4
Xfanout87 tex_width_i[8] vssd1 vssd1 vccd1 vccd1 _4814_/D sky130_fd_sc_hd__buf_4
Xfanout98 _5687_/A vssd1 vssd1 vccd1 vccd1 _4942_/B sky130_fd_sc_hd__buf_4
Xfanout76 _6663_/Q vssd1 vssd1 vccd1 vccd1 _4841_/C sky130_fd_sc_hd__clkbuf_8
XFILLER_0_91_297 vssd1 vssd1 vccd1 vccd1 sky130_fd_sc_hd__fill_2
XFILLER_0_134_377 vssd1 vssd1 vccd1 vccd1 sky130_ef_sc_hd__decap_12
XANTENNA__3464__A _5296_/A vssd1 vssd1 vccd1 vccd1 sky130_fd_sc_hd__diode_2
XFILLER_0_19_39 vssd1 vssd1 vccd1 vccd1 sky130_fd_sc_hd__decap_4
XFILLER_0_35_16 vssd1 vssd1 vccd1 vccd1 sky130_fd_sc_hd__fill_2
XANTENNA__4726__C _4958_/B vssd1 vssd1 vccd1 vccd1 sky130_fd_sc_hd__diode_2
XFILLER_0_129_105 vssd1 vssd1 vccd1 vccd1 sky130_fd_sc_hd__fill_1
XFILLER_0_129_149 vssd1 vssd1 vccd1 vccd1 sky130_fd_sc_hd__decap_4
XFILLER_0_74_209 vssd1 vssd1 vccd1 vccd1 sky130_fd_sc_hd__fill_2
XFILLER_0_27_125 vssd1 vssd1 vccd1 vccd1 sky130_fd_sc_hd__decap_3
XFILLER_0_82_253 vssd1 vssd1 vccd1 vccd1 sky130_fd_sc_hd__fill_1
XFILLER_0_27_169 vssd1 vssd1 vccd1 vccd1 sky130_fd_sc_hd__fill_2
XFILLER_0_82_286 vssd1 vssd1 vccd1 vccd1 sky130_fd_sc_hd__decap_3
X_3590_ _3585_/A _3585_/C _3585_/B vssd1 vssd1 vccd1 vccd1 _3590_/Y sky130_fd_sc_hd__o21ai_1
XFILLER_0_50_161 vssd1 vssd1 vccd1 vccd1 sky130_fd_sc_hd__fill_1
X_5260_ _5410_/A _5410_/B _5410_/C _5259_/X vssd1 vssd1 vccd1 vccd1 _5336_/B sky130_fd_sc_hd__a31o_1
X_4211_ _4213_/A _4213_/B vssd1 vssd1 vccd1 vccd1 _4211_/Y sky130_fd_sc_hd__nor2_1
XANTENNA__4189__B _5787_/A vssd1 vssd1 vccd1 vccd1 sky130_fd_sc_hd__diode_2
XANTENNA__3866__A2 _5083_/B vssd1 vssd1 vccd1 vccd1 sky130_fd_sc_hd__diode_2
X_5191_ _5191_/A _5191_/B _5191_/C vssd1 vssd1 vccd1 vccd1 _5192_/B sky130_fd_sc_hd__nand3_1
X_4142_ _4551_/D _5732_/A _5718_/A _4518_/D vssd1 vssd1 vccd1 vccd1 _4143_/D sky130_fd_sc_hd__a22o_1
X_4073_ _4122_/B _4058_/C _4058_/A vssd1 vssd1 vccd1 vccd1 _4073_/Y sky130_fd_sc_hd__a21oi_1
XANTENNA__4815__B2 _4814_/D vssd1 vssd1 vccd1 vccd1 sky130_fd_sc_hd__diode_2
XANTENNA__4815__A1 _5115_/D vssd1 vssd1 vccd1 vccd1 sky130_fd_sc_hd__diode_2
XFILLER_0_116_62 vssd1 vssd1 vccd1 vccd1 sky130_fd_sc_hd__decap_3
X_4975_ _4830_/A _4830_/C _4830_/B vssd1 vssd1 vccd1 vccd1 _4976_/C sky130_fd_sc_hd__a21bo_1
X_6714_ _6864_/CLK hold4/X vssd1 vssd1 vccd1 vccd1 hold3/A sky130_fd_sc_hd__dfxtp_1
XANTENNA_fanout142_A fanout144/X vssd1 vssd1 vccd1 vccd1 sky130_fd_sc_hd__diode_2
XFILLER_0_73_220 vssd1 vssd1 vccd1 vccd1 sky130_fd_sc_hd__decap_4
XANTENNA__3549__A _3961_/A vssd1 vssd1 vccd1 vccd1 sky130_fd_sc_hd__diode_2
X_3926_ _3815_/X _3906_/Y _3923_/A _3922_/Y vssd1 vssd1 vccd1 vccd1 _3927_/B sky130_fd_sc_hd__a211oi_2
XFILLER_0_116_300 vssd1 vssd1 vccd1 vccd1 sky130_fd_sc_hd__fill_2
XFILLER_0_132_83 vssd1 vssd1 vccd1 vccd1 sky130_fd_sc_hd__fill_1
Xclkbuf_leaf_17_clk_i clkbuf_2_3__f_clk_i/X vssd1 vssd1 vccd1 vccd1 _6732_/CLK sky130_fd_sc_hd__clkbuf_16
XFILLER_0_73_286 vssd1 vssd1 vccd1 vccd1 sky130_fd_sc_hd__fill_2
X_3857_ _3849_/X _3851_/Y _3858_/A _3856_/Y vssd1 vssd1 vccd1 vccd1 _3858_/B sky130_fd_sc_hd__a211oi_2
X_6645_ _6645_/CLK _6645_/D fanout139/X vssd1 vssd1 vccd1 vccd1 _6645_/Q sky130_fd_sc_hd__dfstp_1
X_6576_ _6812_/CLK _6576_/D _6320_/C vssd1 vssd1 vccd1 vccd1 depth_mport_o[20] sky130_fd_sc_hd__dfrtp_4
X_3788_ _3788_/A _3788_/B _3788_/C vssd1 vssd1 vccd1 vccd1 _3914_/A sky130_fd_sc_hd__nand3_1
X_5527_ depth_mport_o[2] hold139/X _5541_/S vssd1 vssd1 vccd1 vccd1 _6558_/D sky130_fd_sc_hd__mux2_1
XANTENNA__3715__C _5273_/A vssd1 vssd1 vccd1 vccd1 sky130_fd_sc_hd__diode_2
XANTENNA__4099__B _5718_/B vssd1 vssd1 vccd1 vccd1 sky130_fd_sc_hd__diode_2
X_5458_ _5458_/A _5458_/B vssd1 vssd1 vccd1 vccd1 _5588_/C sky130_fd_sc_hd__nand2_8
X_5389_ _5389_/A _5389_/B vssd1 vssd1 vccd1 vccd1 _5574_/B sky130_fd_sc_hd__xor2_2
X_4409_ _4409_/A _4410_/A _4409_/C vssd1 vssd1 vccd1 vccd1 _4409_/X sky130_fd_sc_hd__and3_1
XFILLER_0_5_81 vssd1 vssd1 vccd1 vccd1 sky130_ef_sc_hd__decap_12
XANTENNA__4827__B _5787_/B vssd1 vssd1 vccd1 vccd1 sky130_fd_sc_hd__diode_2
XANTENNA_fanout55_A _4816_/A vssd1 vssd1 vccd1 vccd1 sky130_fd_sc_hd__diode_2
XTAP_1213 vssd1 vccd1 sky130_fd_sc_hd__tapvpwrvgnd_1
XTAP_1202 vssd1 vccd1 sky130_fd_sc_hd__tapvpwrvgnd_1
XTAP_1257 vssd1 vccd1 sky130_fd_sc_hd__tapvpwrvgnd_1
XTAP_1246 vssd1 vccd1 sky130_fd_sc_hd__tapvpwrvgnd_1
XTAP_1235 vssd1 vccd1 sky130_fd_sc_hd__tapvpwrvgnd_1
XTAP_1224 vssd1 vccd1 sky130_fd_sc_hd__tapvpwrvgnd_1
XFILLER_0_96_389 vssd1 vssd1 vccd1 vccd1 sky130_ef_sc_hd__decap_12
XFILLER_0_64_220 vssd1 vssd1 vccd1 vccd1 sky130_fd_sc_hd__fill_2
XFILLER_0_64_253 vssd1 vssd1 vccd1 vccd1 sky130_fd_sc_hd__fill_1
XFILLER_0_64_231 vssd1 vssd1 vccd1 vccd1 sky130_fd_sc_hd__fill_2
XANTENNA__3793__A1 _5081_/A vssd1 vssd1 vccd1 vccd1 sky130_fd_sc_hd__diode_2
XFILLER_0_64_264 vssd1 vssd1 vccd1 vccd1 sky130_fd_sc_hd__fill_2
XFILLER_0_9_391 vssd1 vssd1 vccd1 vccd1 sky130_fd_sc_hd__fill_1
XANTENNA__3793__B2 _5081_/B vssd1 vssd1 vccd1 vccd1 sky130_fd_sc_hd__diode_2
XFILLER_0_134_174 vssd1 vssd1 vccd1 vccd1 sky130_fd_sc_hd__fill_2
XFILLER_0_24_128 vssd1 vssd1 vccd1 vccd1 sky130_fd_sc_hd__fill_2
XANTENNA__4742__B1 _4794_/B vssd1 vssd1 vccd1 vccd1 sky130_fd_sc_hd__diode_2
XFILLER_0_122_369 vssd1 vssd1 vccd1 vccd1 sky130_ef_sc_hd__decap_12
XFILLER_0_32_172 vssd1 vssd1 vccd1 vccd1 sky130_fd_sc_hd__fill_1
XANTENNA__6635__SET_B fanout144/X vssd1 vssd1 vccd1 vccd1 sky130_fd_sc_hd__diode_2
XFILLER_0_99_194 vssd1 vssd1 vccd1 vccd1 sky130_fd_sc_hd__decap_3
XFILLER_0_1_39 vssd1 vssd1 vccd1 vccd1 sky130_ef_sc_hd__decap_12
XANTENNA_160 hold168/X vssd1 vssd1 vccd1 vccd1 sky130_fd_sc_hd__diode_2
XFILLER_0_87_378 vssd1 vssd1 vccd1 vccd1 sky130_ef_sc_hd__decap_12
XFILLER_0_127_3 vssd1 vssd1 vccd1 vccd1 sky130_fd_sc_hd__fill_1
XFILLER_0_55_231 vssd1 vssd1 vccd1 vccd1 sky130_fd_sc_hd__fill_2
X_4760_ _4760_/A _4760_/B _4760_/C vssd1 vssd1 vccd1 vccd1 _4898_/A sky130_fd_sc_hd__nand3_2
X_4691_ _4686_/A _4684_/Y _5378_/A _5378_/B vssd1 vssd1 vccd1 vccd1 _5368_/A sky130_fd_sc_hd__a22o_1
XANTENNA__3784__A1 _5300_/A vssd1 vssd1 vccd1 vccd1 sky130_fd_sc_hd__diode_2
X_3711_ _3711_/A _3791_/A vssd1 vssd1 vccd1 vccd1 _3713_/B sky130_fd_sc_hd__nand2_1
XFILLER_0_55_264 vssd1 vssd1 vccd1 vccd1 sky130_fd_sc_hd__decap_6
XFILLER_0_55_275 vssd1 vssd1 vccd1 vccd1 sky130_fd_sc_hd__decap_3
X_6430_ depth_mport_o[49] _6333_/S _6429_/X vssd1 vssd1 vccd1 vccd1 _6827_/D sky130_fd_sc_hd__a21o_1
XFILLER_0_15_139 vssd1 vssd1 vccd1 vccd1 sky130_fd_sc_hd__fill_2
XFILLER_0_11_51 vssd1 vssd1 vccd1 vccd1 sky130_fd_sc_hd__decap_4
X_3642_ _3642_/A _3642_/B _3642_/C vssd1 vssd1 vccd1 vccd1 _3655_/B sky130_fd_sc_hd__nor3_1
X_6361_ depth_mport_o[43] _6441_/B _6360_/X vssd1 vssd1 vccd1 vccd1 _6821_/D sky130_fd_sc_hd__o21a_1
XANTENNA__6399__B hold70/A vssd1 vssd1 vccd1 vccd1 sky130_fd_sc_hd__diode_2
XFILLER_0_113_358 vssd1 vssd1 vccd1 vccd1 sky130_fd_sc_hd__decap_3
X_3573_ _3573_/A _3573_/B vssd1 vssd1 vccd1 vccd1 _3592_/A sky130_fd_sc_hd__xor2_1
X_5312_ _5312_/A _5312_/B vssd1 vssd1 vccd1 vccd1 _5313_/B sky130_fd_sc_hd__xnor2_1
X_6292_ depth_mport_i[30] _3295_/Y _6287_/X _6291_/X vssd1 vssd1 vccd1 vccd1 _6292_/X
+ sky130_fd_sc_hd__o22a_1
XFILLER_0_87_66 vssd1 vssd1 vccd1 vccd1 sky130_fd_sc_hd__decap_4
XFILLER_0_87_55 vssd1 vssd1 vccd1 vccd1 sky130_fd_sc_hd__fill_1
XFILLER_0_60_7 vssd1 vssd1 vccd1 vccd1 sky130_fd_sc_hd__fill_2
XFILLER_0_87_99 vssd1 vssd1 vccd1 vccd1 sky130_fd_sc_hd__fill_1
XANTENNA__4928__A _5051_/B vssd1 vssd1 vccd1 vccd1 sky130_fd_sc_hd__diode_2
X_5243_ _5238_/A _5445_/B _5241_/X _5242_/X vssd1 vssd1 vccd1 vccd1 _5410_/C sky130_fd_sc_hd__o31a_1
X_5174_ _5173_/B _5172_/Y _5160_/Y _5166_/X vssd1 vssd1 vccd1 vccd1 _5177_/A sky130_fd_sc_hd__o211a_2
Xhold19 hold19/A vssd1 vssd1 vccd1 vccd1 hold19/X sky130_fd_sc_hd__dlygate4sd3_1
X_4125_ _4224_/A _4124_/B _4124_/A vssd1 vssd1 vccd1 vccd1 _4133_/A sky130_fd_sc_hd__o21ba_1
X_4056_ _4056_/A _4122_/A _4056_/C vssd1 vssd1 vccd1 vccd1 _4122_/B sky130_fd_sc_hd__nand3_1
XFILLER_0_36_81 vssd1 vssd1 vccd1 vccd1 sky130_fd_sc_hd__decap_3
XANTENNA__4813__D _4822_/B vssd1 vssd1 vccd1 vccd1 sky130_fd_sc_hd__diode_2
X_4958_ _5081_/A _4958_/B _5118_/B _5081_/D vssd1 vssd1 vccd1 vccd1 _5086_/A sky130_fd_sc_hd__nand4_2
XFILLER_0_46_220 vssd1 vssd1 vccd1 vccd1 sky130_ef_sc_hd__decap_12
XANTENNA__4972__B1 _5787_/A vssd1 vssd1 vccd1 vccd1 sky130_fd_sc_hd__diode_2
X_3909_ _5801_/A _4832_/C _4970_/B _4966_/B vssd1 vssd1 vccd1 vccd1 _3912_/A sky130_fd_sc_hd__nand4_1
XFILLER_0_46_264 vssd1 vssd1 vccd1 vccd1 sky130_fd_sc_hd__fill_2
X_4889_ _4890_/A _4890_/B _4890_/C vssd1 vssd1 vccd1 vccd1 _4889_/X sky130_fd_sc_hd__and3_1
X_6628_ _6863_/CLK _6628_/D fanout145/X vssd1 vssd1 vccd1 vccd1 _6628_/Q sky130_fd_sc_hd__dfstp_1
XFILLER_0_61_212 vssd1 vssd1 vccd1 vccd1 sky130_fd_sc_hd__fill_1
XFILLER_0_61_223 vssd1 vssd1 vccd1 vccd1 sky130_fd_sc_hd__fill_1
XFILLER_0_131_122 vssd1 vssd1 vccd1 vccd1 sky130_fd_sc_hd__fill_2
XFILLER_0_6_372 vssd1 vssd1 vccd1 vccd1 sky130_ef_sc_hd__decap_12
XFILLER_0_61_278 vssd1 vssd1 vccd1 vccd1 sky130_fd_sc_hd__fill_2
XFILLER_0_131_133 vssd1 vssd1 vccd1 vccd1 sky130_fd_sc_hd__fill_2
X_6559_ _6853_/CLK _6559_/D fanout149/X vssd1 vssd1 vccd1 vccd1 depth_mport_o[3] sky130_fd_sc_hd__dfrtp_4
XFILLER_0_104_347 vssd1 vssd1 vccd1 vccd1 sky130_ef_sc_hd__decap_12
XFILLER_0_131_199 vssd1 vssd1 vccd1 vccd1 sky130_fd_sc_hd__decap_6
XANTENNA__3742__A _5051_/A vssd1 vssd1 vccd1 vccd1 sky130_fd_sc_hd__diode_2
XFILLER_0_16_29 vssd1 vssd1 vccd1 vccd1 sky130_ef_sc_hd__decap_12
XANTENNA__3463__B1 _5286_/B vssd1 vssd1 vccd1 vccd1 sky130_fd_sc_hd__diode_2
XTAP_1021 vssd1 vccd1 sky130_fd_sc_hd__tapvpwrvgnd_1
XTAP_1010 vssd1 vccd1 sky130_fd_sc_hd__tapvpwrvgnd_1
XTAP_1065 vssd1 vccd1 sky130_fd_sc_hd__tapvpwrvgnd_1
XTAP_1054 vssd1 vccd1 sky130_fd_sc_hd__tapvpwrvgnd_1
XTAP_1043 vssd1 vccd1 sky130_fd_sc_hd__tapvpwrvgnd_1
XTAP_1032 vssd1 vccd1 sky130_fd_sc_hd__tapvpwrvgnd_1
XFILLER_0_96_197 vssd1 vssd1 vccd1 vccd1 sky130_fd_sc_hd__fill_2
XFILLER_0_69_389 vssd1 vssd1 vccd1 vccd1 sky130_fd_sc_hd__decap_3
XANTENNA__5204__A1 _3999_/A vssd1 vssd1 vccd1 vccd1 sky130_fd_sc_hd__diode_2
XTAP_1098 vssd1 vccd1 sky130_fd_sc_hd__tapvpwrvgnd_1
XTAP_1087 vssd1 vccd1 sky130_fd_sc_hd__tapvpwrvgnd_1
XTAP_1076 vssd1 vccd1 sky130_fd_sc_hd__tapvpwrvgnd_1
XFILLER_0_37_264 vssd1 vssd1 vccd1 vccd1 sky130_fd_sc_hd__decap_4
XFILLER_0_4_309 vssd1 vssd1 vccd1 vccd1 sky130_fd_sc_hd__fill_1
XANTENNA__3636__B _3961_/A vssd1 vssd1 vccd1 vccd1 sky130_fd_sc_hd__diode_2
XTAP_816 vssd1 vccd1 sky130_fd_sc_hd__tapvpwrvgnd_1
XTAP_805 vssd1 vccd1 sky130_fd_sc_hd__tapvpwrvgnd_1
XTAP_849 vssd1 vccd1 sky130_fd_sc_hd__tapvpwrvgnd_1
XTAP_838 vssd1 vccd1 sky130_fd_sc_hd__tapvpwrvgnd_1
XTAP_827 vssd1 vccd1 sky130_fd_sc_hd__tapvpwrvgnd_1
XFILLER_0_20_197 vssd1 vssd1 vccd1 vccd1 sky130_fd_sc_hd__fill_1
XANTENNA__3802__D _5081_/D vssd1 vssd1 vccd1 vccd1 sky130_fd_sc_hd__diode_2
XANTENNA__4186__C _4971_/D vssd1 vssd1 vccd1 vccd1 sky130_fd_sc_hd__diode_2
X_5930_ hold78/X tex_mport_i[5] _5932_/S vssd1 vssd1 vccd1 vccd1 _6658_/D sky130_fd_sc_hd__mux2_1
XFILLER_0_75_304 vssd1 vssd1 vccd1 vccd1 sky130_ef_sc_hd__decap_12
X_5861_ hold287/X _5860_/X _5923_/S vssd1 vssd1 vccd1 vccd1 _6644_/D sky130_fd_sc_hd__mux2_1
X_5792_ _5812_/A _5792_/B vssd1 vssd1 vccd1 vccd1 _5794_/A sky130_fd_sc_hd__nor2_1
X_4812_ _4809_/X _4813_/B vssd1 vssd1 vccd1 vccd1 _4848_/B sky130_fd_sc_hd__and2b_1
XFILLER_0_7_125 vssd1 vssd1 vccd1 vccd1 sky130_fd_sc_hd__decap_4
XFILLER_0_28_253 vssd1 vssd1 vccd1 vccd1 sky130_fd_sc_hd__fill_1
XFILLER_0_28_264 vssd1 vssd1 vccd1 vccd1 sky130_fd_sc_hd__fill_2
X_4743_ _4743_/A _4743_/B _4743_/C vssd1 vssd1 vccd1 vccd1 _4750_/A sky130_fd_sc_hd__nand3_1
XFILLER_0_113_85 vssd1 vssd1 vccd1 vccd1 sky130_fd_sc_hd__fill_2
XFILLER_0_7_169 vssd1 vssd1 vccd1 vccd1 sky130_fd_sc_hd__fill_2
XANTENNA__3827__A _5290_/A vssd1 vssd1 vccd1 vccd1 sky130_fd_sc_hd__diode_2
X_6413_ _6413_/A _6413_/B vssd1 vssd1 vccd1 vccd1 _6416_/D sky130_fd_sc_hd__xor2_1
X_4674_ _4674_/A _4674_/B vssd1 vssd1 vccd1 vccd1 _4686_/A sky130_fd_sc_hd__xnor2_2
XFILLER_0_43_256 vssd1 vssd1 vccd1 vccd1 sky130_fd_sc_hd__decap_6
X_3625_ _3608_/A _3608_/B _3608_/C vssd1 vssd1 vccd1 vccd1 _3625_/Y sky130_fd_sc_hd__o21ai_2
X_6344_ hold98/A hold75/A vssd1 vssd1 vccd1 vccd1 _6346_/B sky130_fd_sc_hd__nand2_1
X_3556_ _3557_/B _3557_/C _3557_/A vssd1 vssd1 vccd1 vccd1 _3560_/A sky130_fd_sc_hd__o21a_1
XANTENNA_fanout105_A _5106_/A vssd1 vssd1 vccd1 vccd1 sky130_fd_sc_hd__diode_2
X_6275_ _6849_/Q _6275_/B vssd1 vssd1 vccd1 vccd1 _6276_/B sky130_fd_sc_hd__nor2_1
XFILLER_0_11_197 vssd1 vssd1 vccd1 vccd1 sky130_fd_sc_hd__fill_1
X_3487_ _3487_/A _3487_/B vssd1 vssd1 vccd1 vccd1 _3489_/C sky130_fd_sc_hd__xor2_1
X_5226_ _4993_/B _4993_/Y _5196_/X _5225_/Y vssd1 vssd1 vccd1 vccd1 _5229_/A sky130_fd_sc_hd__a211o_1
XANTENNA__6684__CLK _6684_/CLK vssd1 vssd1 vccd1 vccd1 sky130_fd_sc_hd__diode_2
X_5157_ _5156_/A _5156_/Y _5145_/X _5150_/Y vssd1 vssd1 vccd1 vccd1 _5160_/B sky130_fd_sc_hd__o211ai_4
X_4108_ _4108_/A _4108_/B vssd1 vssd1 vccd1 vccd1 _4110_/A sky130_fd_sc_hd__nor2_1
X_5088_ _5085_/X _5088_/B vssd1 vssd1 vccd1 vccd1 _5154_/B sky130_fd_sc_hd__and2b_1
XANTENNA__6084__S _6098_/S vssd1 vssd1 vccd1 vccd1 sky130_fd_sc_hd__diode_2
X_4039_ _5083_/A _4736_/B _4736_/D _4794_/B vssd1 vssd1 vccd1 vccd1 _4041_/A sky130_fd_sc_hd__a22oi_1
XANTENNA__4824__C _4966_/B vssd1 vssd1 vccd1 vccd1 sky130_fd_sc_hd__diode_2
XFILLER_0_78_197 vssd1 vssd1 vccd1 vccd1 sky130_fd_sc_hd__fill_2
XPHY_104 vssd1 vssd1 vccd1 vccd1 sky130_fd_sc_hd__decap_3
XPHY_115 vssd1 vssd1 vccd1 vccd1 sky130_fd_sc_hd__decap_3
XPHY_148 vssd1 vssd1 vccd1 vccd1 sky130_fd_sc_hd__decap_3
XPHY_137 vssd1 vssd1 vccd1 vccd1 sky130_fd_sc_hd__decap_3
XPHY_126 vssd1 vssd1 vccd1 vccd1 sky130_fd_sc_hd__decap_3
XFILLER_0_19_231 vssd1 vssd1 vccd1 vccd1 sky130_fd_sc_hd__fill_2
XFILLER_0_81_329 vssd1 vssd1 vccd1 vccd1 sky130_fd_sc_hd__fill_1
XPHY_159 vssd1 vssd1 vccd1 vccd1 sky130_fd_sc_hd__decap_3
XANTENNA_71 sstream_i[23] vssd1 vssd1 vccd1 vccd1 sky130_fd_sc_hd__diode_2
XANTENNA_60 sstream_i[19] vssd1 vssd1 vccd1 vccd1 sky130_fd_sc_hd__diode_2
XANTENNA_93 sstream_i[3] vssd1 vssd1 vccd1 vccd1 sky130_fd_sc_hd__diode_2
XANTENNA_82 sstream_i[2] vssd1 vssd1 vccd1 vccd1 sky130_fd_sc_hd__diode_2
XFILLER_0_84_112 vssd1 vssd1 vccd1 vccd1 sky130_fd_sc_hd__fill_2
XFILLER_0_69_175 vssd1 vssd1 vccd1 vccd1 sky130_fd_sc_hd__fill_1
XPHY_6 vssd1 vssd1 vccd1 vccd1 sky130_fd_sc_hd__decap_3
XFILLER_0_127_214 vssd1 vssd1 vccd1 vccd1 sky130_fd_sc_hd__fill_1
XANTENNA__4400__A2 _4476_/D vssd1 vssd1 vccd1 vccd1 sky130_fd_sc_hd__diode_2
XANTENNA__5565__C _5588_/C vssd1 vssd1 vccd1 vccd1 sky130_fd_sc_hd__diode_2
XFILLER_0_4_139 vssd1 vssd1 vccd1 vccd1 sky130_fd_sc_hd__fill_1
XFILLER_0_7_27 vssd1 vssd1 vccd1 vccd1 sky130_ef_sc_hd__decap_12
XFILLER_0_40_204 vssd1 vssd1 vccd1 vccd1 sky130_fd_sc_hd__fill_2
X_4390_ _4422_/A _4422_/B vssd1 vssd1 vccd1 vccd1 _4423_/A sky130_fd_sc_hd__and2_1
X_3410_ _3615_/B _3615_/A vssd1 vssd1 vccd1 vccd1 _3411_/B sky130_fd_sc_hd__and2b_1
XFILLER_0_40_237 vssd1 vssd1 vccd1 vccd1 sky130_fd_sc_hd__fill_2
XFILLER_0_40_248 vssd1 vssd1 vccd1 vccd1 sky130_fd_sc_hd__fill_2
XFILLER_0_110_125 vssd1 vssd1 vccd1 vccd1 sky130_fd_sc_hd__fill_2
X_3341_ _5296_/A _5064_/B _5273_/B _5081_/D vssd1 vssd1 vccd1 vccd1 _3344_/D sky130_fd_sc_hd__a22o_1
XANTENNA__3911__A1 _5801_/A vssd1 vssd1 vccd1 vccd1 sky130_fd_sc_hd__diode_2
XANTENNA__3911__B2 _4832_/C vssd1 vssd1 vccd1 vccd1 sky130_fd_sc_hd__diode_2
XANTENNA__3382__A _5051_/A vssd1 vssd1 vccd1 vccd1 sky130_fd_sc_hd__diode_2
XTAP_602 vssd1 vccd1 sky130_fd_sc_hd__tapvpwrvgnd_1
XTAP_613 vssd1 vccd1 sky130_fd_sc_hd__tapvpwrvgnd_1
XTAP_624 vssd1 vccd1 sky130_fd_sc_hd__tapvpwrvgnd_1
X_6060_ hold9/X _6543_/Q _6072_/S vssd1 vssd1 vccd1 vccd1 hold10/A sky130_fd_sc_hd__mux2_1
X_3272_ _6514_/Q vssd1 vssd1 vccd1 vccd1 _5623_/B sky130_fd_sc_hd__inv_2
XTAP_635 vssd1 vccd1 sky130_fd_sc_hd__tapvpwrvgnd_1
XTAP_646 vssd1 vccd1 sky130_fd_sc_hd__tapvpwrvgnd_1
XTAP_657 vssd1 vccd1 sky130_fd_sc_hd__tapvpwrvgnd_1
XTAP_668 vssd1 vccd1 sky130_fd_sc_hd__tapvpwrvgnd_1
XFILLER_0_84_45 vssd1 vssd1 vccd1 vccd1 sky130_fd_sc_hd__decap_6
X_5011_ _4165_/X _5011_/B vssd1 vssd1 vccd1 vccd1 _5013_/B sky130_fd_sc_hd__and2b_1
XFILLER_0_30_8 vssd1 vssd1 vccd1 vccd1 sky130_fd_sc_hd__fill_2
XTAP_679 vssd1 vccd1 sky130_fd_sc_hd__tapvpwrvgnd_1
XFILLER_0_84_89 vssd1 vssd1 vccd1 vccd1 sky130_fd_sc_hd__fill_2
X_6962_ vssd1 vssd1 vccd1 vccd1 _6962_/HI tex_mport_o[15] sky130_fd_sc_hd__conb_1
X_6893_ vssd1 vssd1 vccd1 vccd1 _6893_/HI depth_mport_o[32] sky130_fd_sc_hd__conb_1
XFILLER_0_75_101 vssd1 vssd1 vccd1 vccd1 sky130_fd_sc_hd__fill_2
X_5913_ tex_addr_i[30] _5913_/B vssd1 vssd1 vccd1 vccd1 _5916_/B sky130_fd_sc_hd__and2_1
XANTENNA__3978__B2 _5049_/A vssd1 vssd1 vccd1 vccd1 sky130_fd_sc_hd__diode_2
XANTENNA__3978__A1 _5049_/B vssd1 vssd1 vccd1 vccd1 sky130_fd_sc_hd__diode_2
XFILLER_0_8_401 vssd1 vssd1 vccd1 vccd1 sky130_fd_sc_hd__decap_6
XFILLER_0_48_348 vssd1 vssd1 vccd1 vccd1 sky130_fd_sc_hd__decap_4
X_5844_ hold282/X _5843_/X _5844_/S vssd1 vssd1 vccd1 vccd1 _6641_/D sky130_fd_sc_hd__mux2_1
X_5775_ _5393_/B _5774_/Y _5784_/S vssd1 vssd1 vccd1 vccd1 _5775_/X sky130_fd_sc_hd__mux2_1
XFILLER_0_75_189 vssd1 vssd1 vccd1 vccd1 sky130_fd_sc_hd__decap_4
XFILLER_0_90_159 vssd1 vssd1 vccd1 vccd1 sky130_fd_sc_hd__fill_2
XFILLER_0_16_267 vssd1 vssd1 vccd1 vccd1 sky130_fd_sc_hd__fill_2
X_4726_ _4966_/B _5115_/C _4958_/B _4814_/D vssd1 vssd1 vccd1 vccd1 _4784_/A sky130_fd_sc_hd__nand4_2
X_4657_ _5645_/A _5645_/B _4688_/C _4658_/D vssd1 vssd1 vccd1 vccd1 _4676_/B sky130_fd_sc_hd__and4_1
X_3608_ _3608_/A _3608_/B _3608_/C vssd1 vssd1 vccd1 vccd1 _3608_/X sky130_fd_sc_hd__or3_2
XANTENNA__6079__S _6315_/S vssd1 vssd1 vccd1 vccd1 sky130_fd_sc_hd__diode_2
X_6327_ _6323_/A pix_mport_i[32] hold39/X vssd1 vssd1 vccd1 vccd1 _6328_/B sky130_fd_sc_hd__a21oi_1
XFILLER_0_101_136 vssd1 vssd1 vccd1 vccd1 sky130_fd_sc_hd__decap_8
X_4588_ _4588_/A _4588_/B vssd1 vssd1 vccd1 vccd1 _4613_/B sky130_fd_sc_hd__xnor2_1
X_3539_ _3540_/B _3540_/C _3540_/A vssd1 vssd1 vccd1 vccd1 _3541_/B sky130_fd_sc_hd__a21o_1
X_6258_ depth_mport_i[6] _6258_/B vssd1 vssd1 vccd1 vccd1 _6258_/X sky130_fd_sc_hd__or2_1
XANTENNA__3723__C _5296_/A vssd1 vssd1 vccd1 vccd1 sky130_fd_sc_hd__diode_2
X_6189_ _6190_/A _6190_/B _6190_/C vssd1 vssd1 vccd1 vccd1 _6191_/A sky130_fd_sc_hd__a21oi_1
X_5209_ _5209_/A _5209_/B vssd1 vssd1 vccd1 vccd1 _5210_/B sky130_fd_sc_hd__xor2_1
XANTENNA__3418__B1 _5272_/B vssd1 vssd1 vccd1 vccd1 sky130_fd_sc_hd__diode_2
XANTENNA__4273__D _4776_/A vssd1 vssd1 vccd1 vccd1 sky130_fd_sc_hd__diode_2
XFILLER_0_66_134 vssd1 vssd1 vccd1 vccd1 sky130_fd_sc_hd__fill_2
XFILLER_0_124_228 vssd1 vssd1 vccd1 vccd1 sky130_fd_sc_hd__fill_2
XFILLER_0_62_362 vssd1 vssd1 vccd1 vccd1 sky130_fd_sc_hd__fill_2
XFILLER_0_22_204 vssd1 vssd1 vccd1 vccd1 sky130_fd_sc_hd__fill_2
XANTENNA__4745__B _4942_/A vssd1 vssd1 vccd1 vccd1 sky130_fd_sc_hd__diode_2
XFILLER_0_97_292 vssd1 vssd1 vccd1 vccd1 sky130_fd_sc_hd__decap_6
XFILLER_0_97_281 vssd1 vssd1 vccd1 vccd1 sky130_fd_sc_hd__decap_4
XANTENNA__4183__D _4966_/C vssd1 vssd1 vccd1 vccd1 sky130_fd_sc_hd__diode_2
X_3890_ _3990_/A _3990_/B _3882_/Y vssd1 vssd1 vccd1 vccd1 _3925_/A sky130_fd_sc_hd__o21ai_1
XFILLER_0_57_156 vssd1 vssd1 vccd1 vccd1 sky130_fd_sc_hd__fill_2
XFILLER_0_38_392 vssd1 vssd1 vccd1 vccd1 sky130_ef_sc_hd__decap_12
X_5560_ tex_mport_o[32] _5576_/S _5559_/X vssd1 vssd1 vccd1 vccd1 _6589_/D sky130_fd_sc_hd__a21o_1
XANTENNA__5582__A0 _5422_/X vssd1 vssd1 vccd1 vccd1 sky130_fd_sc_hd__diode_2
XFILLER_0_72_159 vssd1 vssd1 vccd1 vccd1 sky130_fd_sc_hd__fill_2
XFILLER_0_72_148 vssd1 vssd1 vccd1 vccd1 sky130_fd_sc_hd__fill_2
X_5491_ hold109/X sstream_i[82] _6450_/S vssd1 vssd1 vccd1 vccd1 _6524_/D sky130_fd_sc_hd__mux2_1
X_4511_ _4484_/A _4484_/B _4494_/A _4484_/D vssd1 vssd1 vccd1 vccd1 _4528_/B sky130_fd_sc_hd__a22oi_2
Xhold105 _6056_/X vssd1 vssd1 vccd1 vccd1 _6695_/D sky130_fd_sc_hd__dlygate4sd3_1
X_4442_ _4442_/A _4452_/A _4442_/C vssd1 vssd1 vccd1 vccd1 _4485_/A sky130_fd_sc_hd__or3_1
Xhold116 _6871_/Q vssd1 vssd1 vccd1 vccd1 hold116/X sky130_fd_sc_hd__dlygate4sd3_1
Xhold149 _6513_/Q vssd1 vssd1 vccd1 vccd1 hold149/X sky130_fd_sc_hd__dlygate4sd3_1
Xhold127 _6507_/Q vssd1 vssd1 vccd1 vccd1 hold127/X sky130_fd_sc_hd__dlygate4sd3_1
Xhold138 _6689_/Q vssd1 vssd1 vccd1 vccd1 hold138/X sky130_fd_sc_hd__dlygate4sd3_1
X_4373_ _5701_/A _5687_/A _4614_/C _4637_/D vssd1 vssd1 vccd1 vccd1 _4376_/A sky130_fd_sc_hd__nand4_1
XANTENNA__3896__B1 _5106_/A vssd1 vssd1 vccd1 vccd1 sky130_fd_sc_hd__diode_2
X_3324_ _6837_/Q vssd1 vssd1 vccd1 vccd1 _3324_/Y sky130_fd_sc_hd__inv_2
XTAP_410 vssd1 vccd1 sky130_fd_sc_hd__tapvpwrvgnd_1
XTAP_421 vssd1 vccd1 sky130_fd_sc_hd__tapvpwrvgnd_1
XTAP_432 vssd1 vccd1 sky130_fd_sc_hd__tapvpwrvgnd_1
X_6112_ hold226/X _6750_/Q _6113_/S vssd1 vssd1 vccd1 vccd1 _6112_/X sky130_fd_sc_hd__mux2_1
XFILLER_0_95_88 vssd1 vssd1 vccd1 vccd1 sky130_fd_sc_hd__fill_1
X_3255_ _4966_/A vssd1 vssd1 vccd1 vccd1 _3255_/Y sky130_fd_sc_hd__inv_2
X_6043_ _5272_/B _6038_/B _6038_/Y vssd1 vssd1 vccd1 vccd1 _6682_/D sky130_fd_sc_hd__a21o_1
XTAP_443 vssd1 vccd1 sky130_fd_sc_hd__tapvpwrvgnd_1
XTAP_454 vssd1 vccd1 sky130_fd_sc_hd__tapvpwrvgnd_1
XTAP_465 vssd1 vccd1 sky130_fd_sc_hd__tapvpwrvgnd_1
XTAP_476 vssd1 vccd1 sky130_fd_sc_hd__tapvpwrvgnd_1
XTAP_487 vssd1 vccd1 sky130_fd_sc_hd__tapvpwrvgnd_1
XTAP_498 vssd1 vccd1 sky130_fd_sc_hd__tapvpwrvgnd_1
XFILLER_0_14_3 vssd1 vssd1 vccd1 vccd1 sky130_ef_sc_hd__decap_12
X_6945_ vssd1 vssd1 vccd1 vccd1 _6945_/HI pix_mport_o[66] sky130_fd_sc_hd__conb_1
XANTENNA__6062__A1 hold70/X vssd1 vssd1 vccd1 vccd1 sky130_fd_sc_hd__diode_2
XFILLER_0_48_101 vssd1 vssd1 vccd1 vccd1 sky130_fd_sc_hd__fill_2
XFILLER_0_138_309 vssd1 vssd1 vccd1 vccd1 sky130_fd_sc_hd__decap_4
XFILLER_0_88_292 vssd1 vssd1 vccd1 vccd1 sky130_fd_sc_hd__decap_3
XFILLER_0_63_104 vssd1 vssd1 vccd1 vccd1 sky130_fd_sc_hd__fill_2
XFILLER_0_8_220 vssd1 vssd1 vccd1 vccd1 sky130_fd_sc_hd__decap_3
XANTENNA__3820__B1 _5064_/B vssd1 vssd1 vccd1 vccd1 sky130_fd_sc_hd__diode_2
X_6876_ _6892_/CLK _6876_/D vssd1 vssd1 vccd1 vccd1 _6876_/Q sky130_fd_sc_hd__dfxtp_1
XFILLER_0_29_370 vssd1 vssd1 vccd1 vccd1 sky130_fd_sc_hd__fill_2
X_5827_ _5825_/X _5826_/Y _5837_/A vssd1 vssd1 vccd1 vccd1 _5827_/Y sky130_fd_sc_hd__a21oi_1
X_5758_ tex_addr_i[11] _5758_/B vssd1 vssd1 vccd1 vccd1 _5759_/B sky130_fd_sc_hd__or2_1
XFILLER_0_60_80 vssd1 vssd1 vccd1 vccd1 sky130_fd_sc_hd__fill_2
X_4709_ _4709_/A _4709_/B vssd1 vssd1 vccd1 vccd1 _5400_/A sky130_fd_sc_hd__nor2_2
XFILLER_0_114_261 vssd1 vssd1 vccd1 vccd1 sky130_fd_sc_hd__fill_2
XFILLER_0_114_250 vssd1 vssd1 vccd1 vccd1 sky130_fd_sc_hd__fill_2
XFILLER_0_102_401 vssd1 vssd1 vccd1 vccd1 sky130_fd_sc_hd__decap_6
X_5689_ _5701_/B _5689_/B vssd1 vssd1 vccd1 vccd1 _5689_/Y sky130_fd_sc_hd__nand2_1
XFILLER_0_71_192 vssd1 vssd1 vccd1 vccd1 sky130_fd_sc_hd__fill_1
XFILLER_0_24_29 vssd1 vssd1 vccd1 vccd1 sky130_fd_sc_hd__decap_4
XANTENNA__5677__A _5687_/B vssd1 vssd1 vccd1 vccd1 sky130_fd_sc_hd__diode_2
XFILLER_0_79_281 vssd1 vssd1 vccd1 vccd1 sky130_fd_sc_hd__decap_3
XFILLER_0_94_240 vssd1 vssd1 vccd1 vccd1 sky130_fd_sc_hd__fill_2
XFILLER_0_39_167 vssd1 vssd1 vccd1 vccd1 sky130_fd_sc_hd__fill_1
XFILLER_0_94_273 vssd1 vssd1 vccd1 vccd1 sky130_ef_sc_hd__decap_12
XANTENNA__3909__B _4832_/C vssd1 vssd1 vccd1 vccd1 sky130_fd_sc_hd__diode_2
XFILLER_0_54_126 vssd1 vssd1 vccd1 vccd1 sky130_fd_sc_hd__fill_2
XFILLER_0_137_386 vssd1 vssd1 vccd1 vccd1 sky130_fd_sc_hd__decap_6
XANTENNA__3628__C _5115_/D vssd1 vssd1 vccd1 vccd1 sky130_fd_sc_hd__diode_2
XFILLER_0_35_384 vssd1 vssd1 vccd1 vccd1 sky130_fd_sc_hd__fill_1
XFILLER_0_120_242 vssd1 vssd1 vccd1 vccd1 sky130_fd_sc_hd__decap_3
XFILLER_0_50_387 vssd1 vssd1 vccd1 vccd1 sky130_ef_sc_hd__decap_12
XFILLER_0_120_275 vssd1 vssd1 vccd1 vccd1 sky130_fd_sc_hd__fill_2
XANTENNA__3363__C _5296_/B vssd1 vssd1 vccd1 vccd1 sky130_fd_sc_hd__diode_2
XANTENNA__5619__B2 _5787_/A vssd1 vssd1 vccd1 vccd1 sky130_fd_sc_hd__diode_2
XANTENNA__5095__A2 _5071_/A vssd1 vssd1 vccd1 vccd1 sky130_fd_sc_hd__diode_2
XFILLER_0_77_218 vssd1 vssd1 vccd1 vccd1 sky130_fd_sc_hd__decap_6
XANTENNA__6044__A1 _5286_/B vssd1 vssd1 vccd1 vccd1 sky130_fd_sc_hd__diode_2
XFILLER_0_105_31 vssd1 vssd1 vccd1 vccd1 sky130_fd_sc_hd__fill_2
X_6730_ _6732_/CLK _6730_/D fanout143/X vssd1 vssd1 vccd1 vccd1 _6730_/Q sky130_fd_sc_hd__dfstp_1
X_4991_ _4988_/Y _4989_/X _4872_/C _4872_/Y vssd1 vssd1 vccd1 vccd1 _4993_/C sky130_fd_sc_hd__o211ai_2
XFILLER_0_85_262 vssd1 vssd1 vccd1 vccd1 sky130_fd_sc_hd__decap_4
XFILLER_0_18_307 vssd1 vssd1 vccd1 vccd1 sky130_fd_sc_hd__fill_1
X_3942_ _3917_/A _3917_/C _3917_/B vssd1 vssd1 vccd1 vccd1 _3958_/B sky130_fd_sc_hd__a21o_1
X_6661_ _6863_/CLK _6661_/D _6073_/A vssd1 vssd1 vccd1 vccd1 _6661_/Q sky130_fd_sc_hd__dfrtp_1
XFILLER_0_18_329 vssd1 vssd1 vccd1 vccd1 sky130_fd_sc_hd__fill_1
XANTENNA__3819__B _5049_/B vssd1 vssd1 vccd1 vccd1 sky130_fd_sc_hd__diode_2
X_3873_ _3891_/A _3873_/B vssd1 vssd1 vccd1 vccd1 _3920_/B sky130_fd_sc_hd__nor2_1
X_6592_ _6802_/CLK _6592_/D fanout142/X vssd1 vssd1 vccd1 vccd1 tex_mport_o[35] sky130_fd_sc_hd__dfrtp_4
X_5612_ _5612_/A _5612_/B _5606_/X vssd1 vssd1 vccd1 vccd1 _5612_/X sky130_fd_sc_hd__or3b_1
XFILLER_0_5_212 vssd1 vssd1 vccd1 vccd1 sky130_fd_sc_hd__fill_2
X_5543_ depth_mport_o[18] hold143/X _5556_/S vssd1 vssd1 vccd1 vccd1 _6574_/D sky130_fd_sc_hd__mux2_1
XFILLER_0_5_223 vssd1 vssd1 vccd1 vccd1 sky130_fd_sc_hd__fill_1
XFILLER_0_121_96 vssd1 vssd1 vccd1 vccd1 sky130_fd_sc_hd__decap_4
XFILLER_0_5_278 vssd1 vssd1 vccd1 vccd1 sky130_fd_sc_hd__fill_2
XFILLER_0_5_256 vssd1 vssd1 vccd1 vccd1 sky130_fd_sc_hd__fill_2
XFILLER_0_41_332 vssd1 vssd1 vccd1 vccd1 sky130_fd_sc_hd__fill_2
X_5474_ hold127/X sstream_i[65] _6501_/S vssd1 vssd1 vccd1 vccd1 _6507_/D sky130_fd_sc_hd__mux2_1
X_4425_ _4376_/A _4376_/C _4376_/B vssd1 vssd1 vccd1 vccd1 _4431_/B sky130_fd_sc_hd__a21o_1
XANTENNA__3869__B1 _5081_/D vssd1 vssd1 vccd1 vccd1 sky130_fd_sc_hd__diode_2
X_4356_ _4357_/B _4357_/A vssd1 vssd1 vccd1 vccd1 _4356_/Y sky130_fd_sc_hd__nand2b_1
X_3307_ depth_mport_i[19] vssd1 vssd1 vccd1 vccd1 _3307_/Y sky130_fd_sc_hd__inv_2
X_4287_ _4264_/X _4287_/B _4287_/C _4287_/D vssd1 vssd1 vccd1 vccd1 _4287_/X sky130_fd_sc_hd__and4b_2
XTAP_284 vssd1 vccd1 sky130_fd_sc_hd__tapvpwrvgnd_1
X_6026_ tex_height_i[13] _6026_/B vssd1 vssd1 vccd1 vccd1 _6027_/C sky130_fd_sc_hd__nand2_1
XTAP_295 vssd1 vccd1 sky130_fd_sc_hd__tapvpwrvgnd_1
XFILLER_0_68_229 vssd1 vssd1 vccd1 vccd1 sky130_fd_sc_hd__fill_2
XANTENNA__6092__S _6098_/S vssd1 vssd1 vccd1 vccd1 sky130_fd_sc_hd__diode_2
XANTENNA__4046__B1 _4433_/D vssd1 vssd1 vccd1 vccd1 sky130_fd_sc_hd__diode_2
X_6928_ vssd1 vssd1 vccd1 vccd1 _6928_/HI pix_mport_o[29] sky130_fd_sc_hd__conb_1
Xfanout22 _5554_/S vssd1 vssd1 vccd1 vccd1 _5556_/S sky130_fd_sc_hd__clkbuf_8
Xfanout11 _5468_/X vssd1 vssd1 vccd1 vccd1 _6486_/S sky130_fd_sc_hd__buf_4
XFILLER_0_76_240 vssd1 vssd1 vccd1 vccd1 sky130_fd_sc_hd__fill_2
XANTENNA__4832__C _4832_/C vssd1 vssd1 vccd1 vccd1 sky130_fd_sc_hd__diode_2
X_6859_ _6863_/CLK _6859_/D vssd1 vssd1 vccd1 vccd1 _6859_/Q sky130_fd_sc_hd__dfxtp_1
Xfanout33 _3261_/Y vssd1 vssd1 vccd1 vccd1 _5784_/S sky130_fd_sc_hd__clkbuf_8
Xfanout44 _6679_/Q vssd1 vssd1 vccd1 vccd1 _5071_/A sky130_fd_sc_hd__buf_4
Xfanout55 _4816_/A vssd1 vssd1 vccd1 vccd1 _5081_/A sky130_fd_sc_hd__buf_4
Xfanout77 _4527_/B vssd1 vssd1 vccd1 vccd1 _4688_/C sky130_fd_sc_hd__buf_4
XFILLER_0_91_254 vssd1 vssd1 vccd1 vccd1 sky130_fd_sc_hd__fill_2
XANTENNA__4551__D _4551_/D vssd1 vssd1 vccd1 vccd1 sky130_fd_sc_hd__diode_2
Xfanout88 _5083_/B vssd1 vssd1 vccd1 vccd1 _5320_/A sky130_fd_sc_hd__clkbuf_4
Xfanout66 hold251/X vssd1 vssd1 vccd1 vccd1 _4970_/B sky130_fd_sc_hd__clkbuf_8
Xfanout99 tex_width_i[5] vssd1 vssd1 vccd1 vccd1 _5687_/A sky130_fd_sc_hd__buf_4
XFILLER_0_17_373 vssd1 vssd1 vccd1 vccd1 sky130_fd_sc_hd__fill_1
XFILLER_0_134_389 vssd1 vssd1 vccd1 vccd1 sky130_ef_sc_hd__decap_12
XFILLER_0_44_192 vssd1 vssd1 vccd1 vccd1 sky130_fd_sc_hd__fill_2
XFILLER_0_102_253 vssd1 vssd1 vccd1 vccd1 sky130_fd_sc_hd__fill_2
XANTENNA__3464__B _5276_/A vssd1 vssd1 vccd1 vccd1 sky130_fd_sc_hd__diode_2
XFILLER_0_3_3 vssd1 vssd1 vccd1 vccd1 sky130_ef_sc_hd__decap_12
XANTENNA__4726__D _4814_/D vssd1 vssd1 vccd1 vccd1 sky130_fd_sc_hd__diode_2
XFILLER_0_67_251 vssd1 vssd1 vccd1 vccd1 sky130_fd_sc_hd__fill_1
XFILLER_0_51_27 vssd1 vssd1 vccd1 vccd1 sky130_fd_sc_hd__fill_2
XFILLER_0_27_137 vssd1 vssd1 vccd1 vccd1 sky130_fd_sc_hd__fill_1
XFILLER_0_23_343 vssd1 vssd1 vccd1 vccd1 sky130_fd_sc_hd__fill_2
X_4210_ _4221_/A _4221_/B vssd1 vssd1 vccd1 vccd1 _4213_/B sky130_fd_sc_hd__nand2b_1
XANTENNA__4189__C _4527_/B vssd1 vssd1 vccd1 vccd1 sky130_fd_sc_hd__diode_2
X_5190_ _5191_/A _5191_/B _5191_/C vssd1 vssd1 vccd1 vccd1 _5192_/A sky130_fd_sc_hd__a21o_1
X_4141_ _4551_/D _4518_/D _5732_/A _5718_/A vssd1 vssd1 vccd1 vccd1 _4170_/A sky130_fd_sc_hd__nand4_2
Xclkbuf_0_clk_i clk_i vssd1 vssd1 vccd1 vccd1 clkbuf_0_clk_i/X sky130_fd_sc_hd__clkbuf_16
X_4072_ _4072_/A _4072_/B _4072_/C vssd1 vssd1 vccd1 vccd1 _4281_/A sky130_fd_sc_hd__nand3_2
XANTENNA__4815__A2 _4958_/B vssd1 vssd1 vccd1 vccd1 sky130_fd_sc_hd__diode_2
XFILLER_0_116_41 vssd1 vssd1 vccd1 vccd1 sky130_fd_sc_hd__fill_2
X_4974_ _4973_/B _4973_/C _4973_/A vssd1 vssd1 vccd1 vccd1 _4976_/B sky130_fd_sc_hd__a21o_1
XFILLER_0_58_251 vssd1 vssd1 vccd1 vccd1 sky130_fd_sc_hd__fill_1
X_6713_ _6864_/CLK hold92/X vssd1 vssd1 vccd1 vccd1 hold91/A sky130_fd_sc_hd__dfxtp_1
XFILLER_0_73_210 vssd1 vssd1 vccd1 vccd1 sky130_fd_sc_hd__fill_1
XANTENNA__3549__B _5300_/A vssd1 vssd1 vccd1 vccd1 sky130_fd_sc_hd__diode_2
X_3925_ _3925_/A _3925_/B vssd1 vssd1 vccd1 vccd1 _3925_/X sky130_fd_sc_hd__xor2_1
XFILLER_0_58_284 vssd1 vssd1 vccd1 vccd1 sky130_fd_sc_hd__decap_6
XFILLER_0_18_148 vssd1 vssd1 vccd1 vccd1 sky130_fd_sc_hd__fill_2
X_6644_ _6751_/CLK _6644_/D fanout139/X vssd1 vssd1 vccd1 vccd1 _6644_/Q sky130_fd_sc_hd__dfstp_1
XFILLER_0_73_265 vssd1 vssd1 vccd1 vccd1 sky130_fd_sc_hd__fill_2
X_3856_ _3772_/B _3780_/Y _3854_/A _3853_/Y vssd1 vssd1 vccd1 vccd1 _3856_/Y sky130_fd_sc_hd__a211oi_2
XFILLER_0_61_405 vssd1 vssd1 vccd1 vccd1 sky130_fd_sc_hd__fill_2
X_6575_ _6812_/CLK _6575_/D _6320_/C vssd1 vssd1 vccd1 vccd1 depth_mport_o[19] sky130_fd_sc_hd__dfrtp_4
XFILLER_0_116_356 vssd1 vssd1 vccd1 vccd1 sky130_fd_sc_hd__fill_1
XFILLER_0_81_3 vssd1 vssd1 vccd1 vccd1 sky130_fd_sc_hd__decap_3
XANTENNA__4200__B1 _4841_/C vssd1 vssd1 vccd1 vccd1 sky130_fd_sc_hd__diode_2
X_3787_ _5300_/A _5115_/D vssd1 vssd1 vccd1 vccd1 _3788_/C sky130_fd_sc_hd__and2_1
X_5526_ depth_mport_o[1] hold194/X _5541_/S vssd1 vssd1 vccd1 vccd1 _6557_/D sky130_fd_sc_hd__mux2_1
XFILLER_0_14_365 vssd1 vssd1 vccd1 vccd1 sky130_fd_sc_hd__fill_2
XFILLER_0_14_398 vssd1 vssd1 vccd1 vccd1 sky130_fd_sc_hd__decap_8
XFILLER_0_41_173 vssd1 vssd1 vccd1 vccd1 sky130_fd_sc_hd__fill_1
X_5457_ _6751_/Q _5457_/B vssd1 vssd1 vccd1 vccd1 _5458_/B sky130_fd_sc_hd__xnor2_4
X_4408_ _4409_/A _4409_/C vssd1 vssd1 vccd1 vccd1 _4410_/B sky130_fd_sc_hd__nand2_1
X_5388_ _6729_/Q _5388_/B vssd1 vssd1 vccd1 vccd1 _5388_/Y sky130_fd_sc_hd__xnor2_1
XANTENNA__6087__S _6098_/S vssd1 vssd1 vccd1 vccd1 sky130_fd_sc_hd__diode_2
X_4339_ _4279_/A _4278_/C _4278_/B vssd1 vssd1 vccd1 vccd1 _4340_/C sky130_fd_sc_hd__a21o_1
XFILLER_0_5_93 vssd1 vssd1 vccd1 vccd1 sky130_ef_sc_hd__decap_12
X_6009_ _6016_/C _6009_/B vssd1 vssd1 vccd1 vccd1 _6009_/Y sky130_fd_sc_hd__nand2_1
XTAP_1214 vssd1 vccd1 sky130_fd_sc_hd__tapvpwrvgnd_1
XTAP_1203 vssd1 vccd1 sky130_fd_sc_hd__tapvpwrvgnd_1
XTAP_1247 vssd1 vccd1 sky130_fd_sc_hd__tapvpwrvgnd_1
XTAP_1236 vssd1 vccd1 sky130_fd_sc_hd__tapvpwrvgnd_1
XTAP_1225 vssd1 vccd1 sky130_fd_sc_hd__tapvpwrvgnd_1
XTAP_1258 vssd1 vccd1 sky130_fd_sc_hd__tapvpwrvgnd_1
XFILLER_0_119_150 vssd1 vssd1 vccd1 vccd1 sky130_fd_sc_hd__fill_2
XANTENNA__5519__A0 hold200/X vssd1 vssd1 vccd1 vccd1 sky130_fd_sc_hd__diode_2
XFILLER_0_64_243 vssd1 vssd1 vccd1 vccd1 sky130_fd_sc_hd__fill_2
XFILLER_0_107_323 vssd1 vssd1 vccd1 vccd1 sky130_fd_sc_hd__fill_2
XANTENNA__3793__A2 _5766_/A vssd1 vssd1 vccd1 vccd1 sky130_fd_sc_hd__diode_2
XFILLER_0_17_181 vssd1 vssd1 vccd1 vccd1 sky130_fd_sc_hd__fill_2
XFILLER_0_134_197 vssd1 vssd1 vccd1 vccd1 sky130_fd_sc_hd__decap_4
XFILLER_0_134_186 vssd1 vssd1 vccd1 vccd1 sky130_fd_sc_hd__fill_1
XFILLER_0_32_151 vssd1 vssd1 vccd1 vccd1 sky130_fd_sc_hd__fill_2
XANTENNA__4742__A1 _4816_/A vssd1 vssd1 vccd1 vccd1 sky130_fd_sc_hd__diode_2
XANTENNA__4742__B2 _4942_/B vssd1 vssd1 vccd1 vccd1 sky130_fd_sc_hd__diode_2
XFILLER_0_20_324 vssd1 vssd1 vccd1 vccd1 sky130_fd_sc_hd__fill_2
XFILLER_0_20_335 vssd1 vssd1 vccd1 vccd1 sky130_fd_sc_hd__fill_1
XFILLER_0_46_38 vssd1 vssd1 vccd1 vccd1 sky130_fd_sc_hd__fill_1
XFILLER_0_87_335 vssd1 vssd1 vccd1 vccd1 sky130_fd_sc_hd__fill_1
XANTENNA_161 hold191/X vssd1 vssd1 vccd1 vccd1 sky130_fd_sc_hd__diode_2
XANTENNA_150 hold212/X vssd1 vssd1 vccd1 vccd1 sky130_fd_sc_hd__diode_2
XFILLER_0_7_307 vssd1 vssd1 vccd1 vccd1 sky130_fd_sc_hd__fill_2
X_3710_ _5300_/A _5118_/B _3711_/A _3710_/D vssd1 vssd1 vccd1 vccd1 _3791_/A sky130_fd_sc_hd__nand4_2
X_4690_ _5376_/A _5375_/B vssd1 vssd1 vccd1 vccd1 _5378_/B sky130_fd_sc_hd__nor2_1
XANTENNA__3784__A2 _5118_/B vssd1 vssd1 vccd1 vccd1 sky130_fd_sc_hd__diode_2
XFILLER_0_43_405 vssd1 vssd1 vccd1 vccd1 sky130_fd_sc_hd__fill_2
XFILLER_0_70_213 vssd1 vssd1 vccd1 vccd1 sky130_fd_sc_hd__fill_2
X_3641_ _3642_/B _3642_/C _3642_/A vssd1 vssd1 vccd1 vccd1 _3655_/A sky130_fd_sc_hd__o21a_2
X_6360_ _6440_/B _6381_/A _6369_/A vssd1 vssd1 vccd1 vccd1 _6360_/X sky130_fd_sc_hd__or3b_1
XFILLER_0_102_98 vssd1 vssd1 vccd1 vccd1 sky130_fd_sc_hd__decap_4
XFILLER_0_70_268 vssd1 vssd1 vccd1 vccd1 sky130_fd_sc_hd__fill_2
X_3572_ _3573_/A _3573_/B vssd1 vssd1 vccd1 vccd1 _3578_/B sky130_fd_sc_hd__and2b_1
XFILLER_0_87_23 vssd1 vssd1 vccd1 vccd1 sky130_fd_sc_hd__fill_1
X_5311_ _5311_/A _6689_/Q vssd1 vssd1 vccd1 vccd1 _5312_/B sky130_fd_sc_hd__nand2_1
XFILLER_0_23_173 vssd1 vssd1 vccd1 vccd1 sky130_fd_sc_hd__fill_2
X_6291_ _6283_/B _6290_/Y _6286_/X vssd1 vssd1 vccd1 vccd1 _6291_/X sky130_fd_sc_hd__o21a_1
X_5242_ _5445_/A _5223_/B _5223_/A vssd1 vssd1 vccd1 vccd1 _5242_/X sky130_fd_sc_hd__o21ba_1
XANTENNA__4928__B _5666_/A vssd1 vssd1 vccd1 vccd1 sky130_fd_sc_hd__diode_2
X_5173_ _5173_/A _5173_/B _5173_/C _5171_/Y vssd1 vssd1 vccd1 vccd1 _5173_/X sky130_fd_sc_hd__or4b_2
X_4124_ _4124_/A _4124_/B vssd1 vssd1 vccd1 vccd1 _4224_/B sky130_fd_sc_hd__or2_2
X_4055_ _4054_/A _4054_/B _4054_/C vssd1 vssd1 vccd1 vccd1 _4056_/C sky130_fd_sc_hd__a21o_1
XANTENNA__4944__A _5687_/B vssd1 vssd1 vccd1 vccd1 sky130_fd_sc_hd__diode_2
XFILLER_0_78_335 vssd1 vssd1 vccd1 vccd1 sky130_fd_sc_hd__fill_2
XFILLER_0_78_313 vssd1 vssd1 vccd1 vccd1 sky130_fd_sc_hd__fill_2
XFILLER_0_93_316 vssd1 vssd1 vccd1 vccd1 sky130_fd_sc_hd__fill_1
XFILLER_0_46_232 vssd1 vssd1 vccd1 vccd1 sky130_fd_sc_hd__fill_1
X_4957_ _5115_/C _4822_/B _4823_/X _4824_/X _4966_/C vssd1 vssd1 vccd1 vccd1 _4963_/A
+ sky130_fd_sc_hd__a32o_1
XFILLER_0_52_92 vssd1 vssd1 vccd1 vccd1 sky130_fd_sc_hd__fill_2
X_3908_ _3788_/A _3788_/B _3788_/C vssd1 vssd1 vccd1 vccd1 _3914_/B sky130_fd_sc_hd__a21o_1
XANTENNA__4972__B2 _4971_/D vssd1 vssd1 vccd1 vccd1 sky130_fd_sc_hd__diode_2
XANTENNA__4972__A1 _5801_/A vssd1 vssd1 vccd1 vccd1 sky130_fd_sc_hd__diode_2
X_4888_ _4872_/Y _4873_/X _4886_/A _4886_/Y vssd1 vssd1 vccd1 vccd1 _4890_/C sky130_fd_sc_hd__a211o_1
X_6627_ _6627_/CLK _6627_/D fanout145/X vssd1 vssd1 vccd1 vccd1 _6627_/Q sky130_fd_sc_hd__dfstp_1
XFILLER_0_6_340 vssd1 vssd1 vccd1 vccd1 sky130_fd_sc_hd__fill_2
X_3839_ _3838_/A _3838_/Y _3758_/Y _3781_/X vssd1 vssd1 vccd1 vccd1 _3854_/A sky130_fd_sc_hd__a211oi_4
X_6558_ _6864_/CLK _6558_/D _5468_/A vssd1 vssd1 vccd1 vccd1 depth_mport_o[2] sky130_fd_sc_hd__dfrtp_4
XFILLER_0_116_197 vssd1 vssd1 vccd1 vccd1 sky130_fd_sc_hd__fill_2
XFILLER_0_6_384 vssd1 vssd1 vccd1 vccd1 sky130_ef_sc_hd__decap_12
XFILLER_0_104_359 vssd1 vssd1 vccd1 vccd1 sky130_fd_sc_hd__decap_4
XFILLER_0_14_162 vssd1 vssd1 vccd1 vccd1 sky130_fd_sc_hd__fill_1
XFILLER_0_131_189 vssd1 vssd1 vccd1 vccd1 sky130_fd_sc_hd__fill_2
X_5509_ hold53/X sstream_i[100] _6472_/S vssd1 vssd1 vccd1 vccd1 _6542_/D sky130_fd_sc_hd__mux2_1
XFILLER_0_14_195 vssd1 vssd1 vccd1 vccd1 sky130_fd_sc_hd__fill_1
X_6489_ hold217/X sstream_i[47] _6493_/S vssd1 vssd1 vccd1 vccd1 _6880_/D sky130_fd_sc_hd__mux2_1
XANTENNA__3742__B _5272_/B vssd1 vssd1 vccd1 vccd1 sky130_fd_sc_hd__diode_2
XFILLER_0_96_110 vssd1 vssd1 vccd1 vccd1 sky130_fd_sc_hd__fill_2
XANTENNA__3463__A1 _5296_/A vssd1 vssd1 vccd1 vccd1 sky130_fd_sc_hd__diode_2
XTAP_1022 vssd1 vccd1 sky130_fd_sc_hd__tapvpwrvgnd_1
XTAP_1011 vssd1 vccd1 sky130_fd_sc_hd__tapvpwrvgnd_1
XTAP_1000 vssd1 vccd1 sky130_fd_sc_hd__tapvpwrvgnd_1
XANTENNA__3463__B2 _5276_/A vssd1 vssd1 vccd1 vccd1 sky130_fd_sc_hd__diode_2
XTAP_1055 vssd1 vccd1 sky130_fd_sc_hd__tapvpwrvgnd_1
XTAP_1044 vssd1 vccd1 sky130_fd_sc_hd__tapvpwrvgnd_1
XTAP_1033 vssd1 vccd1 sky130_fd_sc_hd__tapvpwrvgnd_1
XFILLER_0_84_316 vssd1 vssd1 vccd1 vccd1 sky130_fd_sc_hd__fill_2
XFILLER_0_32_29 vssd1 vssd1 vccd1 vccd1 sky130_fd_sc_hd__decap_4
XTAP_1099 vssd1 vccd1 sky130_fd_sc_hd__tapvpwrvgnd_1
XTAP_1088 vssd1 vccd1 sky130_fd_sc_hd__tapvpwrvgnd_1
XTAP_1077 vssd1 vccd1 sky130_fd_sc_hd__tapvpwrvgnd_1
XTAP_1066 vssd1 vccd1 sky130_fd_sc_hd__tapvpwrvgnd_1
XFILLER_0_25_405 vssd1 vssd1 vccd1 vccd1 sky130_fd_sc_hd__fill_2
XFILLER_0_52_213 vssd1 vssd1 vccd1 vccd1 sky130_fd_sc_hd__fill_2
XFILLER_0_107_164 vssd1 vssd1 vccd1 vccd1 sky130_fd_sc_hd__fill_2
XANTENNA__3636__C _5273_/A vssd1 vssd1 vccd1 vccd1 sky130_fd_sc_hd__diode_2
XFILLER_0_110_307 vssd1 vssd1 vccd1 vccd1 sky130_fd_sc_hd__fill_1
XFILLER_0_20_132 vssd1 vssd1 vccd1 vccd1 sky130_fd_sc_hd__fill_2
XTAP_817 vssd1 vccd1 sky130_fd_sc_hd__tapvpwrvgnd_1
XTAP_806 vssd1 vccd1 sky130_fd_sc_hd__tapvpwrvgnd_1
XTAP_839 vssd1 vccd1 sky130_fd_sc_hd__tapvpwrvgnd_1
XTAP_828 vssd1 vccd1 sky130_fd_sc_hd__tapvpwrvgnd_1
XANTENNA__4186__D _5754_/B vssd1 vssd1 vccd1 vccd1 sky130_fd_sc_hd__diode_2
Xclkbuf_leaf_16_clk_i clkbuf_2_3__f_clk_i/X vssd1 vssd1 vccd1 vccd1 _6792_/CLK sky130_fd_sc_hd__clkbuf_16
XFILLER_0_87_110 vssd1 vssd1 vccd1 vccd1 sky130_fd_sc_hd__fill_2
X_5860_ _5447_/X _5859_/Y _5922_/S vssd1 vssd1 vccd1 vccd1 _5860_/X sky130_fd_sc_hd__mux2_1
XFILLER_0_87_187 vssd1 vssd1 vccd1 vccd1 sky130_fd_sc_hd__decap_3
XFILLER_0_75_316 vssd1 vssd1 vccd1 vccd1 sky130_ef_sc_hd__decap_12
X_4811_ _4971_/D _4966_/A _4966_/C _4970_/B vssd1 vssd1 vccd1 vccd1 _4813_/B sky130_fd_sc_hd__a22o_1
XFILLER_0_87_198 vssd1 vssd1 vccd1 vccd1 sky130_fd_sc_hd__decap_3
X_5791_ tex_addr_i[14] _5791_/B vssd1 vssd1 vccd1 vccd1 _5792_/B sky130_fd_sc_hd__nor2_1
XFILLER_0_28_210 vssd1 vssd1 vccd1 vccd1 sky130_fd_sc_hd__fill_2
XFILLER_0_90_319 vssd1 vssd1 vccd1 vccd1 sky130_fd_sc_hd__decap_8
X_4742_ _4816_/A _4942_/A _4794_/B _4942_/B vssd1 vssd1 vccd1 vccd1 _4743_/C sky130_fd_sc_hd__a22o_1
X_4673_ _4666_/A _4672_/Y _4670_/B vssd1 vssd1 vccd1 vccd1 _4692_/A sky130_fd_sc_hd__a21oi_1
XFILLER_0_83_393 vssd1 vssd1 vccd1 vccd1 sky130_ef_sc_hd__decap_12
XFILLER_0_7_159 vssd1 vssd1 vccd1 vccd1 sky130_fd_sc_hd__fill_2
XANTENNA__3827__B _5327_/A vssd1 vssd1 vccd1 vccd1 sky130_fd_sc_hd__diode_2
XFILLER_0_28_287 vssd1 vssd1 vccd1 vccd1 sky130_fd_sc_hd__fill_2
XFILLER_0_43_202 vssd1 vssd1 vccd1 vccd1 sky130_fd_sc_hd__fill_2
X_6412_ _6413_/B _6413_/A vssd1 vssd1 vccd1 vccd1 _6412_/X sky130_fd_sc_hd__and2b_1
XFILLER_0_3_310 vssd1 vssd1 vccd1 vccd1 sky130_fd_sc_hd__fill_1
X_3624_ _3612_/A _3612_/B _3611_/Y vssd1 vssd1 vccd1 vccd1 _3624_/X sky130_fd_sc_hd__o21ba_1
XFILLER_0_22_95 vssd1 vssd1 vccd1 vccd1 sky130_fd_sc_hd__fill_2
XFILLER_0_113_134 vssd1 vssd1 vccd1 vccd1 sky130_fd_sc_hd__fill_1
X_6343_ depth_mport_o[41] _6440_/B _6342_/X vssd1 vssd1 vccd1 vccd1 _6819_/D sky130_fd_sc_hd__a21o_1
X_3555_ _3565_/A _3565_/B vssd1 vssd1 vccd1 vccd1 _3557_/C sky130_fd_sc_hd__nor2_1
X_6274_ _3307_/Y _6852_/Q _3308_/Y _6851_/Q _6236_/X vssd1 vssd1 vccd1 vccd1 _6277_/C
+ sky130_fd_sc_hd__a221o_1
XFILLER_0_11_154 vssd1 vssd1 vccd1 vccd1 sky130_fd_sc_hd__fill_1
X_3486_ _3486_/A _3486_/B vssd1 vssd1 vccd1 vccd1 _3487_/B sky130_fd_sc_hd__nand2_1
X_5225_ _5197_/A _5197_/C _5197_/B vssd1 vssd1 vccd1 vccd1 _5225_/Y sky130_fd_sc_hd__a21oi_1
XFILLER_0_44_3 vssd1 vssd1 vccd1 vccd1 sky130_fd_sc_hd__fill_2
X_5156_ _5156_/A _5156_/B _5156_/C vssd1 vssd1 vccd1 vccd1 _5156_/Y sky130_fd_sc_hd__nor3_4
X_4107_ _5083_/A _4736_/B _4736_/D _5049_/D vssd1 vssd1 vccd1 vccd1 _4108_/B sky130_fd_sc_hd__and4_1
X_5087_ _5122_/B _5085_/C _5085_/A vssd1 vssd1 vccd1 vccd1 _5088_/B sky130_fd_sc_hd__a21o_1
X_4038_ _4037_/B _4037_/C _4037_/A vssd1 vssd1 vccd1 vccd1 _4058_/A sky130_fd_sc_hd__a21bo_1
XFILLER_0_78_121 vssd1 vssd1 vccd1 vccd1 sky130_fd_sc_hd__fill_2
XFILLER_0_2_83 vssd1 vssd1 vccd1 vccd1 sky130_fd_sc_hd__fill_1
XFILLER_0_93_113 vssd1 vssd1 vccd1 vccd1 sky130_fd_sc_hd__fill_2
XFILLER_0_66_305 vssd1 vssd1 vccd1 vccd1 sky130_fd_sc_hd__decap_3
XPHY_105 vssd1 vssd1 vccd1 vccd1 sky130_fd_sc_hd__decap_3
XPHY_116 vssd1 vssd1 vccd1 vccd1 sky130_fd_sc_hd__decap_3
XPHY_149 vssd1 vssd1 vccd1 vccd1 sky130_fd_sc_hd__decap_3
XPHY_138 vssd1 vssd1 vccd1 vccd1 sky130_fd_sc_hd__decap_3
XPHY_127 vssd1 vssd1 vccd1 vccd1 sky130_fd_sc_hd__decap_3
X_5989_ _5988_/Y hold133/X _6000_/S vssd1 vssd1 vccd1 vccd1 _5989_/X sky130_fd_sc_hd__mux2_1
XFILLER_0_19_254 vssd1 vssd1 vccd1 vccd1 sky130_fd_sc_hd__fill_2
XANTENNA__4945__A1 _5687_/B vssd1 vssd1 vccd1 vccd1 sky130_fd_sc_hd__diode_2
XANTENNA_50 sstream_i[17] vssd1 vssd1 vccd1 vccd1 sky130_fd_sc_hd__diode_2
XFILLER_0_74_382 vssd1 vssd1 vccd1 vccd1 sky130_ef_sc_hd__decap_12
XFILLER_0_34_224 vssd1 vssd1 vccd1 vccd1 sky130_fd_sc_hd__fill_2
XANTENNA_83 sstream_i[30] vssd1 vssd1 vccd1 vccd1 sky130_fd_sc_hd__diode_2
XANTENNA_72 sstream_i[25] vssd1 vssd1 vccd1 vccd1 sky130_fd_sc_hd__diode_2
XANTENNA_61 sstream_i[1] vssd1 vssd1 vccd1 vccd1 sky130_fd_sc_hd__diode_2
XFILLER_0_34_268 vssd1 vssd1 vccd1 vccd1 sky130_fd_sc_hd__fill_2
XANTENNA_94 sstream_i[3] vssd1 vssd1 vccd1 vccd1 sky130_fd_sc_hd__diode_2
XFILLER_0_6_192 vssd1 vssd1 vccd1 vccd1 sky130_fd_sc_hd__fill_2
XPHY_7 vssd1 vssd1 vccd1 vccd1 sky130_fd_sc_hd__decap_3
XFILLER_0_43_39 vssd1 vssd1 vccd1 vccd1 sky130_fd_sc_hd__fill_1
XFILLER_0_127_248 vssd1 vssd1 vccd1 vccd1 sky130_fd_sc_hd__fill_2
XFILLER_0_84_179 vssd1 vssd1 vccd1 vccd1 sky130_fd_sc_hd__fill_2
XFILLER_0_65_393 vssd1 vssd1 vccd1 vccd1 sky130_ef_sc_hd__decap_12
XFILLER_0_80_341 vssd1 vssd1 vccd1 vccd1 sky130_ef_sc_hd__decap_12
XFILLER_0_40_216 vssd1 vssd1 vccd1 vccd1 sky130_fd_sc_hd__decap_6
XFILLER_0_7_39 vssd1 vssd1 vccd1 vccd1 sky130_ef_sc_hd__decap_12
XFILLER_0_68_58 vssd1 vssd1 vccd1 vccd1 sky130_fd_sc_hd__decap_3
XFILLER_0_0_313 vssd1 vssd1 vccd1 vccd1 sky130_fd_sc_hd__fill_2
X_3340_ _3602_/A _3602_/B _3338_/A vssd1 vssd1 vccd1 vccd1 _3353_/A sky130_fd_sc_hd__o21ai_1
XANTENNA__3911__A2 _4970_/B vssd1 vssd1 vccd1 vccd1 sky130_fd_sc_hd__diode_2
XFILLER_0_0_357 vssd1 vssd1 vccd1 vccd1 sky130_fd_sc_hd__fill_2
XANTENNA__3382__B _5296_/B vssd1 vssd1 vccd1 vccd1 sky130_fd_sc_hd__diode_2
XTAP_603 vssd1 vccd1 sky130_fd_sc_hd__tapvpwrvgnd_1
XTAP_614 vssd1 vccd1 sky130_fd_sc_hd__tapvpwrvgnd_1
XTAP_625 vssd1 vccd1 sky130_fd_sc_hd__tapvpwrvgnd_1
X_3271_ _6515_/Q vssd1 vssd1 vccd1 vccd1 _3271_/Y sky130_fd_sc_hd__inv_2
X_5010_ _5010_/A _5010_/B vssd1 vssd1 vccd1 vccd1 _5013_/A sky130_fd_sc_hd__nand2_1
XTAP_636 vssd1 vccd1 sky130_fd_sc_hd__tapvpwrvgnd_1
XTAP_647 vssd1 vccd1 sky130_fd_sc_hd__tapvpwrvgnd_1
XTAP_658 vssd1 vccd1 sky130_fd_sc_hd__tapvpwrvgnd_1
XTAP_669 vssd1 vccd1 sky130_fd_sc_hd__tapvpwrvgnd_1
XFILLER_0_84_68 vssd1 vssd1 vccd1 vccd1 sky130_fd_sc_hd__fill_2
X_6961_ vssd1 vssd1 vccd1 vccd1 _6961_/HI tex_mport_o[14] sky130_fd_sc_hd__conb_1
X_6892_ _6892_/CLK _6892_/D vssd1 vssd1 vccd1 vccd1 _6892_/Q sky130_fd_sc_hd__dfxtp_1
X_5912_ tex_addr_i[30] _5913_/B vssd1 vssd1 vccd1 vccd1 _5916_/A sky130_fd_sc_hd__nor2_1
XANTENNA__3978__A2 _6678_/Q vssd1 vssd1 vccd1 vccd1 sky130_fd_sc_hd__diode_2
XFILLER_0_48_327 vssd1 vssd1 vccd1 vccd1 sky130_fd_sc_hd__fill_1
XANTENNA__6602__RESET_B fanout144/X vssd1 vssd1 vccd1 vccd1 sky130_fd_sc_hd__diode_2
XFILLER_0_33_61 vssd1 vssd1 vccd1 vccd1 sky130_fd_sc_hd__fill_2
X_5843_ _5426_/X _5842_/X _5922_/S vssd1 vssd1 vccd1 vccd1 _5843_/X sky130_fd_sc_hd__mux2_1
XFILLER_0_33_83 vssd1 vssd1 vccd1 vccd1 sky130_fd_sc_hd__fill_2
XANTENNA__4927__A1 _5051_/B vssd1 vssd1 vccd1 vccd1 sky130_fd_sc_hd__diode_2
X_5774_ _5774_/A _5782_/B vssd1 vssd1 vccd1 vccd1 _5774_/Y sky130_fd_sc_hd__nor2_1
XFILLER_0_16_213 vssd1 vssd1 vccd1 vccd1 sky130_fd_sc_hd__decap_4
XFILLER_0_133_229 vssd1 vssd1 vccd1 vccd1 sky130_fd_sc_hd__fill_1
XFILLER_0_90_149 vssd1 vssd1 vccd1 vccd1 sky130_fd_sc_hd__decap_3
XFILLER_0_16_235 vssd1 vssd1 vccd1 vccd1 sky130_fd_sc_hd__fill_1
X_4725_ _4725_/A _4914_/A vssd1 vssd1 vccd1 vccd1 _4773_/A sky130_fd_sc_hd__nand2_1
X_4656_ _6624_/Q _4656_/B vssd1 vssd1 vccd1 vccd1 _4662_/A sky130_fd_sc_hd__xnor2_2
X_4587_ _5666_/A _4637_/D vssd1 vssd1 vccd1 vccd1 _4588_/B sky130_fd_sc_hd__nand2_1
X_3607_ _3608_/A _3608_/B _3608_/C vssd1 vssd1 vccd1 vccd1 _3607_/Y sky130_fd_sc_hd__nor3_1
XFILLER_0_31_249 vssd1 vssd1 vccd1 vccd1 sky130_fd_sc_hd__fill_2
X_6326_ _6323_/A _6325_/Y tex_fly_o vssd1 vssd1 vccd1 vccd1 _6805_/D sky130_fd_sc_hd__a21o_1
X_3538_ _3544_/A _3544_/B vssd1 vssd1 vccd1 vccd1 _3540_/C sky130_fd_sc_hd__or2_1
XFILLER_0_3_184 vssd1 vssd1 vccd1 vccd1 sky130_fd_sc_hd__fill_1
XANTENNA__4388__B _4816_/B vssd1 vssd1 vccd1 vccd1 sky130_fd_sc_hd__diode_2
X_6257_ _6249_/X _6256_/X _6268_/A vssd1 vssd1 vccd1 vccd1 _6257_/X sky130_fd_sc_hd__a21o_1
X_3469_ _3471_/A _3471_/B vssd1 vssd1 vccd1 vccd1 _3489_/A sky130_fd_sc_hd__and2_1
XANTENNA__3723__D _5276_/A vssd1 vssd1 vccd1 vccd1 sky130_fd_sc_hd__diode_2
X_6188_ hold22/A _6792_/Q vssd1 vssd1 vccd1 vccd1 _6190_/C sky130_fd_sc_hd__xnor2_1
X_5208_ _5209_/A _5209_/B vssd1 vssd1 vccd1 vccd1 _5208_/Y sky130_fd_sc_hd__nor2_1
XANTENNA__6095__S _6095_/S vssd1 vssd1 vccd1 vccd1 sky130_fd_sc_hd__diode_2
X_5139_ _5139_/A _5139_/B _5139_/C vssd1 vssd1 vccd1 vccd1 _5153_/A sky130_fd_sc_hd__nand3_1
XFILLER_0_98_216 vssd1 vssd1 vccd1 vccd1 sky130_ef_sc_hd__decap_12
XANTENNA__3418__A1 _5296_/A vssd1 vssd1 vccd1 vccd1 sky130_fd_sc_hd__diode_2
XANTENNA__3418__B2 _5276_/A vssd1 vssd1 vccd1 vccd1 sky130_fd_sc_hd__diode_2
XANTENNA__4091__A1 _4816_/A vssd1 vssd1 vccd1 vccd1 sky130_fd_sc_hd__diode_2
XANTENNA__6368__A0 hold53/A vssd1 vssd1 vccd1 vccd1 sky130_fd_sc_hd__diode_2
XANTENNA_fanout30_A _6098_/S vssd1 vssd1 vccd1 vccd1 sky130_fd_sc_hd__diode_2
XFILLER_0_81_105 vssd1 vssd1 vccd1 vccd1 sky130_fd_sc_hd__fill_2
XFILLER_0_109_259 vssd1 vssd1 vccd1 vccd1 sky130_fd_sc_hd__fill_1
XFILLER_0_47_393 vssd1 vssd1 vccd1 vccd1 sky130_ef_sc_hd__decap_12
XFILLER_0_117_281 vssd1 vssd1 vccd1 vccd1 sky130_fd_sc_hd__fill_2
XFILLER_0_22_249 vssd1 vssd1 vccd1 vccd1 sky130_fd_sc_hd__decap_3
XFILLER_0_30_282 vssd1 vssd1 vccd1 vccd1 sky130_fd_sc_hd__fill_2
XFILLER_0_100_181 vssd1 vssd1 vccd1 vccd1 sky130_ef_sc_hd__decap_12
XANTENNA__4745__C _4942_/B vssd1 vssd1 vccd1 vccd1 sky130_fd_sc_hd__diode_2
XFILLER_0_54_27 vssd1 vssd1 vccd1 vccd1 sky130_fd_sc_hd__fill_1
XFILLER_0_89_249 vssd1 vssd1 vccd1 vccd1 sky130_fd_sc_hd__fill_2
XFILLER_0_54_49 vssd1 vssd1 vccd1 vccd1 sky130_fd_sc_hd__fill_1
XFILLER_0_70_37 vssd1 vssd1 vccd1 vccd1 sky130_fd_sc_hd__fill_2
XFILLER_0_72_127 vssd1 vssd1 vccd1 vccd1 sky130_fd_sc_hd__fill_2
XFILLER_0_5_405 vssd1 vssd1 vccd1 vccd1 sky130_fd_sc_hd__fill_2
X_4510_ _4498_/A _4498_/C _4498_/B vssd1 vssd1 vccd1 vccd1 _4510_/X sky130_fd_sc_hd__o21a_1
X_5490_ hold25/X sstream_i[81] _6450_/S vssd1 vssd1 vccd1 vccd1 _6523_/D sky130_fd_sc_hd__mux2_1
Xhold106 _6654_/Q vssd1 vssd1 vccd1 vccd1 hold106/X sky130_fd_sc_hd__dlygate4sd3_1
XFILLER_0_102_3 vssd1 vssd1 vccd1 vccd1 sky130_fd_sc_hd__decap_6
X_4441_ _4440_/A _4440_/B _4440_/C vssd1 vssd1 vccd1 vccd1 _4442_/C sky130_fd_sc_hd__a21oi_1
Xhold117 _6857_/Q vssd1 vssd1 vccd1 vccd1 hold117/X sky130_fd_sc_hd__dlygate4sd3_1
XFILLER_0_79_68 vssd1 vssd1 vccd1 vccd1 sky130_fd_sc_hd__fill_2
XFILLER_0_79_57 vssd1 vssd1 vccd1 vccd1 sky130_fd_sc_hd__fill_2
XFILLER_0_123_273 vssd1 vssd1 vccd1 vccd1 sky130_fd_sc_hd__fill_2
Xhold139 _6835_/Q vssd1 vssd1 vccd1 vccd1 hold139/X sky130_fd_sc_hd__dlygate4sd3_1
Xhold128 _6808_/Q vssd1 vssd1 vccd1 vccd1 _3262_/A sky130_fd_sc_hd__dlygate4sd3_1
X_4372_ _4328_/A _4328_/C _4328_/B vssd1 vssd1 vccd1 vccd1 _4378_/B sky130_fd_sc_hd__a21o_1
XFILLER_0_0_132 vssd1 vssd1 vccd1 vccd1 sky130_fd_sc_hd__fill_2
XTAP_400 vssd1 vccd1 sky130_fd_sc_hd__tapvpwrvgnd_1
XFILLER_0_21_260 vssd1 vssd1 vccd1 vccd1 sky130_fd_sc_hd__fill_1
X_6111_ hold175/X _6749_/Q _6113_/S vssd1 vssd1 vccd1 vccd1 _6111_/X sky130_fd_sc_hd__mux2_1
X_3323_ _6838_/Q vssd1 vssd1 vccd1 vccd1 _3323_/Y sky130_fd_sc_hd__inv_2
XTAP_411 vssd1 vccd1 sky130_fd_sc_hd__tapvpwrvgnd_1
XTAP_422 vssd1 vccd1 sky130_fd_sc_hd__tapvpwrvgnd_1
XTAP_433 vssd1 vccd1 sky130_fd_sc_hd__tapvpwrvgnd_1
XFILLER_0_95_67 vssd1 vssd1 vccd1 vccd1 sky130_fd_sc_hd__fill_1
X_6042_ _5273_/B _6038_/B _6038_/Y vssd1 vssd1 vccd1 vccd1 _6681_/D sky130_fd_sc_hd__a21o_1
XTAP_444 vssd1 vccd1 sky130_fd_sc_hd__tapvpwrvgnd_1
XTAP_455 vssd1 vccd1 sky130_fd_sc_hd__tapvpwrvgnd_1
XTAP_466 vssd1 vccd1 sky130_fd_sc_hd__tapvpwrvgnd_1
XFILLER_0_28_50 vssd1 vssd1 vccd1 vccd1 sky130_fd_sc_hd__fill_2
X_3254_ _6737_/Q vssd1 vssd1 vccd1 vccd1 _5424_/A sky130_fd_sc_hd__inv_2
XFILLER_0_119_74 vssd1 vssd1 vccd1 vccd1 sky130_fd_sc_hd__fill_2
XTAP_477 vssd1 vccd1 sky130_fd_sc_hd__tapvpwrvgnd_1
XTAP_488 vssd1 vccd1 sky130_fd_sc_hd__tapvpwrvgnd_1
XTAP_499 vssd1 vccd1 sky130_fd_sc_hd__tapvpwrvgnd_1
X_6944_ vssd1 vssd1 vccd1 vccd1 _6944_/HI pix_mport_o[65] sky130_fd_sc_hd__conb_1
XFILLER_0_95_208 vssd1 vssd1 vccd1 vccd1 sky130_fd_sc_hd__decap_8
XFILLER_0_88_260 vssd1 vssd1 vccd1 vccd1 sky130_fd_sc_hd__decap_3
XANTENNA__3820__B2 _5049_/B vssd1 vssd1 vccd1 vccd1 sky130_fd_sc_hd__diode_2
XANTENNA__3820__A1 _5049_/A vssd1 vssd1 vccd1 vccd1 sky130_fd_sc_hd__diode_2
X_6875_ _6892_/CLK _6875_/D vssd1 vssd1 vccd1 vccd1 _6875_/Q sky130_fd_sc_hd__dfxtp_1
XFILLER_0_63_116 vssd1 vssd1 vccd1 vccd1 sky130_fd_sc_hd__decap_4
X_5826_ tex_addr_i[16] tex_addr_i[17] _5882_/B vssd1 vssd1 vccd1 vccd1 _5826_/Y sky130_fd_sc_hd__o21ai_1
XFILLER_0_106_218 vssd1 vssd1 vccd1 vccd1 sky130_fd_sc_hd__fill_1
X_5757_ tex_addr_i[11] _5758_/B vssd1 vssd1 vccd1 vccd1 _5772_/A sky130_fd_sc_hd__nand2_1
XFILLER_0_29_393 vssd1 vssd1 vccd1 vccd1 sky130_ef_sc_hd__decap_12
X_4708_ _4707_/A _4709_/B _4709_/A vssd1 vssd1 vccd1 vccd1 _4714_/A sky130_fd_sc_hd__o21ba_1
XFILLER_0_44_363 vssd1 vssd1 vccd1 vccd1 sky130_fd_sc_hd__fill_1
XFILLER_0_44_374 vssd1 vssd1 vccd1 vccd1 sky130_ef_sc_hd__decap_12
X_5688_ _5687_/B _5687_/C _5687_/A vssd1 vssd1 vccd1 vccd1 _5689_/B sky130_fd_sc_hd__o21ai_1
X_4639_ _5645_/B _4658_/D _4637_/D _5645_/A vssd1 vssd1 vccd1 vccd1 _4640_/B sky130_fd_sc_hd__a22o_1
XFILLER_0_12_260 vssd1 vssd1 vccd1 vccd1 sky130_fd_sc_hd__fill_2
X_6309_ _6792_/Q hold29/X _6319_/S vssd1 vssd1 vccd1 vccd1 hold30/A sky130_fd_sc_hd__mux2_1
XFILLER_0_12_293 vssd1 vssd1 vccd1 vccd1 sky130_fd_sc_hd__decap_4
XFILLER_0_79_260 vssd1 vssd1 vccd1 vccd1 sky130_fd_sc_hd__decap_4
XANTENNA__6053__A2 _6038_/B vssd1 vssd1 vccd1 vccd1 sky130_fd_sc_hd__diode_2
XFILLER_0_39_113 vssd1 vssd1 vccd1 vccd1 sky130_fd_sc_hd__fill_2
XFILLER_0_94_263 vssd1 vssd1 vccd1 vccd1 sky130_fd_sc_hd__decap_4
XFILLER_0_39_157 vssd1 vssd1 vccd1 vccd1 sky130_fd_sc_hd__fill_2
XFILLER_0_94_296 vssd1 vssd1 vccd1 vccd1 sky130_fd_sc_hd__fill_1
XANTENNA__3909__C _4970_/B vssd1 vssd1 vccd1 vccd1 sky130_fd_sc_hd__diode_2
XFILLER_0_39_179 vssd1 vssd1 vccd1 vccd1 sky130_fd_sc_hd__decap_3
XFILLER_0_54_105 vssd1 vssd1 vccd1 vccd1 sky130_fd_sc_hd__fill_2
XANTENNA__5564__B2 _5588_/C vssd1 vssd1 vccd1 vccd1 sky130_fd_sc_hd__diode_2
XANTENNA__3628__D _5118_/B vssd1 vssd1 vccd1 vccd1 sky130_fd_sc_hd__diode_2
XFILLER_0_40_29 vssd1 vssd1 vccd1 vccd1 sky130_fd_sc_hd__fill_2
XFILLER_0_105_273 vssd1 vssd1 vccd1 vccd1 sky130_fd_sc_hd__fill_2
XFILLER_0_49_16 vssd1 vssd1 vccd1 vccd1 sky130_fd_sc_hd__fill_2
XFILLER_0_10_219 vssd1 vssd1 vccd1 vccd1 sky130_fd_sc_hd__fill_1
XFILLER_0_50_399 vssd1 vssd1 vccd1 vccd1 sky130_fd_sc_hd__decap_8
XANTENNA__3363__D _5276_/B vssd1 vssd1 vccd1 vccd1 sky130_fd_sc_hd__diode_2
XFILLER_0_4_29 vssd1 vssd1 vccd1 vccd1 sky130_ef_sc_hd__decap_12
XANTENNA__6044__A2 _6038_/B vssd1 vssd1 vccd1 vccd1 sky130_fd_sc_hd__diode_2
X_4990_ _4872_/C _4872_/Y _4988_/Y _4989_/X vssd1 vssd1 vccd1 vccd1 _4993_/B sky130_fd_sc_hd__a211o_2
XFILLER_0_105_65 vssd1 vssd1 vccd1 vccd1 sky130_fd_sc_hd__fill_2
XFILLER_0_14_41 vssd1 vssd1 vccd1 vccd1 sky130_ef_sc_hd__decap_12
X_3941_ _3923_/A _3923_/C _3923_/B vssd1 vssd1 vccd1 vccd1 _3941_/Y sky130_fd_sc_hd__o21ai_2
X_6660_ _6853_/CLK _6660_/D vssd1 vssd1 vccd1 vccd1 hold38/A sky130_fd_sc_hd__dfxtp_1
XFILLER_0_14_85 vssd1 vssd1 vccd1 vccd1 sky130_fd_sc_hd__decap_4
XANTENNA__3819__C _5071_/A vssd1 vssd1 vccd1 vccd1 sky130_fd_sc_hd__diode_2
X_3872_ _3813_/B _3865_/Y _3867_/B vssd1 vssd1 vccd1 vccd1 _3873_/B sky130_fd_sc_hd__o21ba_1
XFILLER_0_45_116 vssd1 vssd1 vccd1 vccd1 sky130_fd_sc_hd__fill_2
X_6591_ _6802_/CLK _6591_/D fanout150/X vssd1 vssd1 vccd1 vccd1 tex_mport_o[34] sky130_fd_sc_hd__dfrtp_4
X_5611_ _5608_/X _5609_/X _5610_/X vssd1 vssd1 vccd1 vccd1 _5611_/X sky130_fd_sc_hd__o21a_1
XFILLER_0_45_149 vssd1 vssd1 vccd1 vccd1 sky130_fd_sc_hd__fill_1
X_5542_ depth_mport_o[17] hold213/X _5556_/S vssd1 vssd1 vccd1 vccd1 _6573_/D sky130_fd_sc_hd__mux2_1
XFILLER_0_30_40 vssd1 vssd1 vccd1 vccd1 sky130_fd_sc_hd__fill_2
XFILLER_0_53_160 vssd1 vssd1 vccd1 vccd1 sky130_fd_sc_hd__fill_2
XFILLER_0_83_7 vssd1 vssd1 vccd1 vccd1 sky130_fd_sc_hd__fill_1
X_5473_ hold115/X sstream_i[64] _6501_/S vssd1 vssd1 vccd1 vccd1 _6506_/D sky130_fd_sc_hd__mux2_1
XFILLER_0_41_355 vssd1 vssd1 vccd1 vccd1 sky130_fd_sc_hd__fill_2
X_4424_ _4386_/A _4385_/C _4385_/B vssd1 vssd1 vccd1 vccd1 _4440_/B sky130_fd_sc_hd__a21o_1
X_4355_ _4355_/A _4355_/B vssd1 vssd1 vccd1 vccd1 _4357_/B sky130_fd_sc_hd__nand2_1
XANTENNA__3869__B2 _5049_/D vssd1 vssd1 vccd1 vccd1 sky130_fd_sc_hd__diode_2
X_3306_ depth_mport_i[20] vssd1 vssd1 vccd1 vccd1 _3306_/Y sky130_fd_sc_hd__inv_2
XFILLER_0_39_82 vssd1 vssd1 vccd1 vccd1 sky130_fd_sc_hd__fill_2
X_4286_ _4264_/A _4264_/C _4264_/B vssd1 vssd1 vccd1 vccd1 _4287_/D sky130_fd_sc_hd__a21o_1
XANTENNA__3570__B _5300_/A vssd1 vssd1 vccd1 vccd1 sky130_fd_sc_hd__diode_2
XTAP_285 vssd1 vccd1 sky130_fd_sc_hd__tapvpwrvgnd_1
XTAP_296 vssd1 vccd1 sky130_fd_sc_hd__tapvpwrvgnd_1
X_6025_ tex_height_i[13] _6026_/B vssd1 vssd1 vccd1 vccd1 _6031_/B sky130_fd_sc_hd__or2_1
XFILLER_0_55_81 vssd1 vssd1 vccd1 vccd1 sky130_fd_sc_hd__fill_2
XFILLER_0_55_92 vssd1 vssd1 vccd1 vccd1 sky130_fd_sc_hd__fill_1
XANTENNA__4046__B2 _4942_/B vssd1 vssd1 vccd1 vccd1 sky130_fd_sc_hd__diode_2
XANTENNA__4046__A1 _5701_/A vssd1 vssd1 vccd1 vccd1 sky130_fd_sc_hd__diode_2
XFILLER_0_138_118 vssd1 vssd1 vccd1 vccd1 sky130_fd_sc_hd__fill_2
X_6927_ vssd1 vssd1 vccd1 vccd1 _6927_/HI pix_mport_o[28] sky130_fd_sc_hd__conb_1
XFILLER_0_119_310 vssd1 vssd1 vccd1 vccd1 sky130_fd_sc_hd__fill_2
Xfanout12 _5468_/X vssd1 vssd1 vccd1 vccd1 _6450_/S sky130_fd_sc_hd__clkbuf_8
XANTENNA__4832__D _4841_/D vssd1 vssd1 vccd1 vccd1 sky130_fd_sc_hd__diode_2
Xfanout23 _5554_/S vssd1 vssd1 vccd1 vccd1 _5541_/S sky130_fd_sc_hd__clkbuf_8
XFILLER_0_119_354 vssd1 vssd1 vccd1 vccd1 sky130_fd_sc_hd__fill_2
X_6858_ _6863_/CLK _6858_/D vssd1 vssd1 vccd1 vccd1 _6858_/Q sky130_fd_sc_hd__dfxtp_1
Xfanout34 _5599_/A vssd1 vssd1 vccd1 vccd1 _5796_/A sky130_fd_sc_hd__clkbuf_8
Xfanout45 _5051_/B vssd1 vssd1 vccd1 vccd1 _5308_/A sky130_fd_sc_hd__buf_4
Xfanout56 _6673_/Q vssd1 vssd1 vccd1 vccd1 _4816_/A sky130_fd_sc_hd__clkbuf_8
Xfanout67 _4971_/D vssd1 vssd1 vccd1 vccd1 _4551_/D sky130_fd_sc_hd__clkbuf_8
Xfanout78 _6662_/Q vssd1 vssd1 vccd1 vccd1 _4527_/B sky130_fd_sc_hd__buf_4
X_5809_ _5408_/B _5808_/Y _5922_/S vssd1 vssd1 vccd1 vccd1 _5809_/X sky130_fd_sc_hd__mux2_1
Xfanout89 tex_width_i[7] vssd1 vssd1 vccd1 vccd1 _5083_/B sky130_fd_sc_hd__buf_4
X_6789_ _6792_/CLK hold46/X vssd1 vssd1 vccd1 vccd1 _6789_/Q sky130_fd_sc_hd__dfxtp_1
XANTENNA__5717__S _5844_/S vssd1 vssd1 vccd1 vccd1 sky130_fd_sc_hd__diode_2
XFILLER_0_32_322 vssd1 vssd1 vccd1 vccd1 sky130_fd_sc_hd__decap_8
XFILLER_0_44_171 vssd1 vssd1 vccd1 vccd1 sky130_fd_sc_hd__fill_2
XANTENNA__3464__C _5272_/B vssd1 vssd1 vccd1 vccd1 sky130_fd_sc_hd__diode_2
XANTENNA__4592__A _5687_/B vssd1 vssd1 vccd1 vccd1 sky130_fd_sc_hd__diode_2
XFILLER_0_129_118 vssd1 vssd1 vccd1 vccd1 sky130_fd_sc_hd__fill_1
XFILLER_0_125_313 vssd1 vssd1 vccd1 vccd1 sky130_fd_sc_hd__fill_2
XFILLER_0_82_233 vssd1 vssd1 vccd1 vccd1 sky130_fd_sc_hd__fill_1
XFILLER_0_82_299 vssd1 vssd1 vccd1 vccd1 sky130_fd_sc_hd__fill_2
XFILLER_0_2_205 vssd1 vssd1 vccd1 vccd1 sky130_fd_sc_hd__fill_2
XFILLER_0_23_322 vssd1 vssd1 vccd1 vccd1 sky130_fd_sc_hd__fill_2
XFILLER_0_23_333 vssd1 vssd1 vccd1 vccd1 sky130_fd_sc_hd__decap_3
XFILLER_0_35_160 vssd1 vssd1 vccd1 vccd1 sky130_fd_sc_hd__fill_2
XFILLER_0_50_141 vssd1 vssd1 vccd1 vccd1 sky130_fd_sc_hd__fill_2
XFILLER_0_133_390 vssd1 vssd1 vccd1 vccd1 sky130_fd_sc_hd__fill_2
XANTENNA__4189__D _4841_/C vssd1 vssd1 vccd1 vccd1 sky130_fd_sc_hd__diode_2
X_4140_ _4136_/X _4140_/B _4614_/C _4822_/B vssd1 vssd1 vccd1 vccd1 _4140_/X sky130_fd_sc_hd__and4b_1
X_4071_ _4065_/A _4065_/B _4065_/C vssd1 vssd1 vccd1 vccd1 _4072_/C sky130_fd_sc_hd__a21o_1
XFILLER_0_92_46 vssd1 vssd1 vccd1 vccd1 sky130_fd_sc_hd__fill_1
XFILLER_0_116_75 vssd1 vssd1 vccd1 vccd1 sky130_fd_sc_hd__fill_2
XFILLER_0_25_73 vssd1 vssd1 vccd1 vccd1 sky130_fd_sc_hd__decap_3
X_4973_ _4973_/A _4973_/B _4973_/C vssd1 vssd1 vccd1 vccd1 _4976_/A sky130_fd_sc_hd__nand3_1
X_6712_ _6864_/CLK hold83/X vssd1 vssd1 vccd1 vccd1 hold82/A sky130_fd_sc_hd__dfxtp_1
X_3924_ _3923_/A _3922_/Y _3815_/X _3906_/Y vssd1 vssd1 vccd1 vccd1 _3927_/A sky130_fd_sc_hd__o211a_2
XFILLER_0_18_127 vssd1 vssd1 vccd1 vccd1 sky130_fd_sc_hd__fill_2
X_6643_ _6645_/CLK _6643_/D fanout139/X vssd1 vssd1 vccd1 vccd1 _6643_/Q sky130_fd_sc_hd__dfstp_1
XFILLER_0_58_296 vssd1 vssd1 vccd1 vccd1 sky130_fd_sc_hd__decap_4
XFILLER_0_116_313 vssd1 vssd1 vccd1 vccd1 sky130_fd_sc_hd__fill_2
XFILLER_0_73_277 vssd1 vssd1 vccd1 vccd1 sky130_fd_sc_hd__decap_3
X_3855_ _3854_/A _3853_/Y _3772_/B _3780_/Y vssd1 vssd1 vccd1 vccd1 _3858_/A sky130_fd_sc_hd__o211a_1
X_6574_ _6812_/CLK _6574_/D _6320_/C vssd1 vssd1 vccd1 vccd1 depth_mport_o[18] sky130_fd_sc_hd__dfrtp_4
XANTENNA__4200__A1 _5787_/A vssd1 vssd1 vccd1 vccd1 sky130_fd_sc_hd__diode_2
XANTENNA__4200__B2 _5787_/B vssd1 vssd1 vccd1 vccd1 sky130_fd_sc_hd__diode_2
XANTENNA_fanout128_A _5754_/A vssd1 vssd1 vccd1 vccd1 sky130_fd_sc_hd__diode_2
X_3786_ _5801_/A _4966_/B _5115_/C _4832_/C vssd1 vssd1 vccd1 vccd1 _3788_/B sky130_fd_sc_hd__a22o_1
X_5525_ depth_mport_o[0] hold206/X _5541_/S vssd1 vssd1 vccd1 vccd1 _6556_/D sky130_fd_sc_hd__mux2_1
XFILLER_0_74_3 vssd1 vssd1 vccd1 vccd1 sky130_fd_sc_hd__fill_2
X_5456_ _5456_/A _5456_/B _5456_/C _5456_/D vssd1 vssd1 vccd1 vccd1 _5458_/A sky130_fd_sc_hd__and4_2
X_4407_ _6632_/Q _4407_/B vssd1 vssd1 vccd1 vccd1 _4409_/C sky130_fd_sc_hd__or2_1
X_5387_ _5387_/A _5387_/B _5387_/C _5387_/D vssd1 vssd1 vccd1 vccd1 _5387_/X sky130_fd_sc_hd__and4_1
X_4338_ _4338_/A _4392_/A vssd1 vssd1 vccd1 vccd1 _4342_/A sky130_fd_sc_hd__nand2_1
X_4269_ _4269_/A _4269_/B _4269_/C vssd1 vssd1 vccd1 vccd1 _4330_/A sky130_fd_sc_hd__nand3_1
X_6008_ tex_height_i[9] _6008_/B vssd1 vssd1 vccd1 vccd1 _6009_/B sky130_fd_sc_hd__nand2_1
XTAP_1204 vssd1 vccd1 sky130_fd_sc_hd__tapvpwrvgnd_1
XTAP_1248 vssd1 vccd1 sky130_fd_sc_hd__tapvpwrvgnd_1
XTAP_1237 vssd1 vccd1 sky130_fd_sc_hd__tapvpwrvgnd_1
XTAP_1226 vssd1 vccd1 sky130_fd_sc_hd__tapvpwrvgnd_1
XTAP_1215 vssd1 vccd1 sky130_fd_sc_hd__tapvpwrvgnd_1
XTAP_1259 vssd1 vccd1 sky130_fd_sc_hd__tapvpwrvgnd_1
XFILLER_0_134_121 vssd1 vssd1 vccd1 vccd1 sky130_fd_sc_hd__fill_1
XFILLER_0_9_393 vssd1 vssd1 vccd1 vccd1 sky130_ef_sc_hd__decap_12
XFILLER_0_52_406 vssd1 vssd1 vccd1 vccd1 sky130_fd_sc_hd__fill_1
XFILLER_0_134_165 vssd1 vssd1 vccd1 vccd1 sky130_fd_sc_hd__decap_3
XFILLER_0_122_338 vssd1 vssd1 vccd1 vccd1 sky130_fd_sc_hd__fill_1
XFILLER_0_32_141 vssd1 vssd1 vccd1 vccd1 sky130_fd_sc_hd__decap_3
XANTENNA__4742__A2 _4942_/A vssd1 vssd1 vccd1 vccd1 sky130_fd_sc_hd__diode_2
XANTENNA__4587__A _5666_/A vssd1 vssd1 vccd1 vccd1 sky130_fd_sc_hd__diode_2
XANTENNA__5910__S _5922_/S vssd1 vssd1 vccd1 vccd1 sky130_fd_sc_hd__diode_2
XFILLER_0_99_141 vssd1 vssd1 vccd1 vccd1 sky130_fd_sc_hd__fill_2
XFILLER_0_87_314 vssd1 vssd1 vccd1 vccd1 sky130_fd_sc_hd__fill_1
XFILLER_0_62_27 vssd1 vssd1 vccd1 vccd1 sky130_fd_sc_hd__fill_1
XANTENNA_151 hold219/X vssd1 vssd1 vccd1 vccd1 sky130_fd_sc_hd__diode_2
XANTENNA_140 tex_addr_i[8] vssd1 vssd1 vccd1 vccd1 sky130_fd_sc_hd__diode_2
XFILLER_0_62_38 vssd1 vssd1 vccd1 vccd1 sky130_fd_sc_hd__fill_2
XFILLER_0_7_319 vssd1 vssd1 vccd1 vccd1 sky130_fd_sc_hd__fill_1
XFILLER_0_55_222 vssd1 vssd1 vccd1 vccd1 sky130_fd_sc_hd__fill_2
XFILLER_0_55_244 vssd1 vssd1 vccd1 vccd1 sky130_fd_sc_hd__fill_2
X_3640_ _3706_/A _3706_/B vssd1 vssd1 vccd1 vccd1 _3642_/C sky130_fd_sc_hd__nor2_1
X_3571_ _3959_/B _5300_/A _3569_/B _3567_/X vssd1 vssd1 vccd1 vccd1 _3573_/B sky130_fd_sc_hd__a31o_1
X_6290_ _6283_/C _6282_/X _6283_/A vssd1 vssd1 vccd1 vccd1 _6290_/Y sky130_fd_sc_hd__a21oi_1
XFILLER_0_113_349 vssd1 vssd1 vccd1 vccd1 sky130_fd_sc_hd__fill_2
X_5310_ _5310_/A _5310_/B vssd1 vssd1 vccd1 vccd1 _5312_/A sky130_fd_sc_hd__xnor2_2
XFILLER_0_121_393 vssd1 vssd1 vccd1 vccd1 sky130_ef_sc_hd__decap_12
X_5241_ _5232_/B _5416_/B _5230_/X vssd1 vssd1 vccd1 vccd1 _5241_/X sky130_fd_sc_hd__a21o_1
X_5172_ _5173_/A _5173_/B _5173_/C _5171_/Y vssd1 vssd1 vccd1 vccd1 _5172_/Y sky130_fd_sc_hd__nor4b_1
X_4123_ _4121_/B _4121_/C _4121_/A vssd1 vssd1 vccd1 vccd1 _4124_/B sky130_fd_sc_hd__a21oi_1
XANTENNA__6737__SET_B fanout140/X vssd1 vssd1 vccd1 vccd1 sky130_fd_sc_hd__diode_2
X_4054_ _4054_/A _4054_/B _4054_/C vssd1 vssd1 vccd1 vccd1 _4122_/A sky130_fd_sc_hd__nand3_1
XANTENNA__4944__B _4944_/B vssd1 vssd1 vccd1 vccd1 sky130_fd_sc_hd__diode_2
XFILLER_0_78_358 vssd1 vssd1 vccd1 vccd1 sky130_fd_sc_hd__fill_2
XFILLER_0_93_328 vssd1 vssd1 vccd1 vccd1 sky130_fd_sc_hd__decap_4
XFILLER_0_52_60 vssd1 vssd1 vccd1 vccd1 sky130_fd_sc_hd__decap_3
X_4956_ _4956_/A _4956_/B vssd1 vssd1 vccd1 vccd1 _4964_/A sky130_fd_sc_hd__nand2_1
X_3907_ _3798_/A _3798_/B _3798_/C vssd1 vssd1 vccd1 vccd1 _3919_/B sky130_fd_sc_hd__a21oi_1
XANTENNA__4972__A2 _4971_/B vssd1 vssd1 vccd1 vccd1 sky130_fd_sc_hd__diode_2
X_4887_ _4886_/A _4886_/Y _4872_/Y _4873_/X vssd1 vssd1 vccd1 vccd1 _4890_/B sky130_fd_sc_hd__o211ai_4
XFILLER_0_116_154 vssd1 vssd1 vccd1 vccd1 sky130_fd_sc_hd__fill_2
X_6626_ _6862_/CLK _6626_/D _6073_/A vssd1 vssd1 vccd1 vccd1 _6626_/Q sky130_fd_sc_hd__dfstp_1
X_3838_ _3838_/A _3838_/B _3846_/B _3838_/D vssd1 vssd1 vccd1 vccd1 _3838_/Y sky130_fd_sc_hd__nand4_4
XFILLER_0_61_225 vssd1 vssd1 vccd1 vccd1 sky130_fd_sc_hd__decap_3
X_6557_ _6864_/CLK _6557_/D _5468_/A vssd1 vssd1 vccd1 vccd1 depth_mport_o[1] sky130_fd_sc_hd__dfrtp_4
XFILLER_0_6_396 vssd1 vssd1 vccd1 vccd1 sky130_fd_sc_hd__decap_8
XFILLER_0_6_363 vssd1 vssd1 vccd1 vccd1 sky130_fd_sc_hd__fill_1
XFILLER_0_61_269 vssd1 vssd1 vccd1 vccd1 sky130_fd_sc_hd__decap_6
X_5508_ hold60/X sstream_i[99] _6464_/S vssd1 vssd1 vccd1 vccd1 _6541_/D sky130_fd_sc_hd__mux2_1
X_3769_ _3769_/A _3769_/B vssd1 vssd1 vccd1 vccd1 _3770_/B sky130_fd_sc_hd__xnor2_2
XFILLER_0_14_185 vssd1 vssd1 vccd1 vccd1 sky130_fd_sc_hd__decap_4
X_6488_ hold188/X sstream_i[46] _6493_/S vssd1 vssd1 vccd1 vccd1 _6879_/D sky130_fd_sc_hd__mux2_1
X_5439_ _5438_/A _5442_/A _5438_/C vssd1 vssd1 vccd1 vccd1 _5451_/C sky130_fd_sc_hd__o21ai_1
XANTENNA__6098__S _6098_/S vssd1 vssd1 vccd1 vccd1 sky130_fd_sc_hd__diode_2
XANTENNA__5685__B1 _5796_/A vssd1 vssd1 vccd1 vccd1 sky130_fd_sc_hd__diode_2
XANTENNA__5730__S _5844_/S vssd1 vssd1 vccd1 vccd1 sky130_fd_sc_hd__diode_2
XANTENNA__3463__A2 _5272_/B vssd1 vssd1 vccd1 vccd1 sky130_fd_sc_hd__diode_2
XTAP_1012 vssd1 vccd1 sky130_fd_sc_hd__tapvpwrvgnd_1
XTAP_1001 vssd1 vccd1 sky130_fd_sc_hd__tapvpwrvgnd_1
XFILLER_0_96_133 vssd1 vssd1 vccd1 vccd1 sky130_fd_sc_hd__fill_1
XFILLER_0_69_369 vssd1 vssd1 vccd1 vccd1 sky130_ef_sc_hd__decap_12
XTAP_1056 vssd1 vccd1 sky130_fd_sc_hd__tapvpwrvgnd_1
XTAP_1045 vssd1 vccd1 sky130_fd_sc_hd__tapvpwrvgnd_1
XTAP_1034 vssd1 vccd1 sky130_fd_sc_hd__tapvpwrvgnd_1
XTAP_1023 vssd1 vccd1 sky130_fd_sc_hd__tapvpwrvgnd_1
XTAP_1089 vssd1 vccd1 sky130_fd_sc_hd__tapvpwrvgnd_1
XTAP_1078 vssd1 vccd1 sky130_fd_sc_hd__tapvpwrvgnd_1
XTAP_1067 vssd1 vccd1 sky130_fd_sc_hd__tapvpwrvgnd_1
XFILLER_0_77_391 vssd1 vssd1 vccd1 vccd1 sky130_fd_sc_hd__fill_1
XFILLER_0_92_361 vssd1 vssd1 vccd1 vccd1 sky130_fd_sc_hd__decap_3
XFILLER_0_107_154 vssd1 vssd1 vccd1 vccd1 sky130_fd_sc_hd__fill_1
XFILLER_0_103_393 vssd1 vssd1 vccd1 vccd1 sky130_ef_sc_hd__decap_12
XTAP_807 vssd1 vccd1 sky130_fd_sc_hd__tapvpwrvgnd_1
XFILLER_0_20_166 vssd1 vssd1 vccd1 vccd1 sky130_fd_sc_hd__decap_4
XTAP_829 vssd1 vccd1 sky130_fd_sc_hd__tapvpwrvgnd_1
XTAP_818 vssd1 vccd1 sky130_fd_sc_hd__tapvpwrvgnd_1
XFILLER_0_87_177 vssd1 vssd1 vccd1 vccd1 sky130_fd_sc_hd__decap_4
XFILLER_0_75_328 vssd1 vssd1 vccd1 vccd1 sky130_fd_sc_hd__decap_8
X_4810_ _4966_/B _4822_/B vssd1 vssd1 vccd1 vccd1 _4848_/A sky130_fd_sc_hd__nand2_1
XFILLER_0_132_3 vssd1 vssd1 vccd1 vccd1 sky130_fd_sc_hd__fill_2
XANTENNA__5600__B1 _5599_/X vssd1 vssd1 vccd1 vccd1 sky130_fd_sc_hd__diode_2
X_5790_ tex_addr_i[14] _5791_/B vssd1 vssd1 vccd1 vccd1 _5812_/A sky130_fd_sc_hd__and2_1
XFILLER_0_7_105 vssd1 vssd1 vccd1 vccd1 sky130_fd_sc_hd__decap_6
XFILLER_0_22_41 vssd1 vssd1 vccd1 vccd1 sky130_fd_sc_hd__fill_2
X_4741_ _4816_/A _4942_/A _4794_/B _4942_/B vssd1 vssd1 vccd1 vccd1 _4743_/B sky130_fd_sc_hd__nand4_2
X_4672_ _4672_/A _4672_/B vssd1 vssd1 vccd1 vccd1 _4672_/Y sky130_fd_sc_hd__xnor2_1
XFILLER_0_22_85 vssd1 vssd1 vccd1 vccd1 sky130_fd_sc_hd__decap_4
XANTENNA__3827__C _5276_/B vssd1 vssd1 vccd1 vccd1 sky130_fd_sc_hd__diode_2
XFILLER_0_28_277 vssd1 vssd1 vccd1 vccd1 sky130_fd_sc_hd__fill_1
X_6411_ _6402_/B _6409_/Y _6416_/C _6384_/X vssd1 vssd1 vccd1 vccd1 _6413_/B sky130_fd_sc_hd__o22a_1
XFILLER_0_113_113 vssd1 vssd1 vccd1 vccd1 sky130_fd_sc_hd__fill_2
X_3623_ _3620_/B _3616_/B _3616_/C vssd1 vssd1 vccd1 vccd1 _3623_/X sky130_fd_sc_hd__o21a_1
XANTENNA__3546__D _5277_/B vssd1 vssd1 vccd1 vccd1 sky130_fd_sc_hd__diode_2
X_6342_ _6441_/B _6350_/B _6342_/C vssd1 vssd1 vccd1 vccd1 _6342_/X sky130_fd_sc_hd__and3_1
XFILLER_0_11_111 vssd1 vssd1 vccd1 vccd1 sky130_fd_sc_hd__fill_1
X_3554_ _3554_/A _3554_/B vssd1 vssd1 vccd1 vccd1 _3565_/B sky130_fd_sc_hd__or2_1
X_6273_ _6853_/Q _3306_/Y _3307_/Y _6852_/Q _6241_/X vssd1 vssd1 vccd1 vccd1 _6277_/B
+ sky130_fd_sc_hd__o221ai_1
X_3485_ _3484_/B _3485_/B vssd1 vssd1 vccd1 vccd1 _3486_/B sky130_fd_sc_hd__nand2b_1
X_5224_ _5201_/A _5199_/X _5192_/A _5193_/Y vssd1 vssd1 vccd1 vccd1 _5224_/X sky130_fd_sc_hd__o211a_1
XFILLER_0_37_3 vssd1 vssd1 vccd1 vccd1 sky130_fd_sc_hd__fill_2
X_5155_ _5153_/A _5153_/B _5153_/C vssd1 vssd1 vccd1 vccd1 _5156_/C sky130_fd_sc_hd__a21oi_2
X_4106_ _5083_/A _4736_/D _5049_/D _4736_/B vssd1 vssd1 vccd1 vccd1 _4108_/A sky130_fd_sc_hd__a22oi_1
X_5086_ _5086_/A _5086_/B vssd1 vssd1 vccd1 vccd1 _5154_/A sky130_fd_sc_hd__nand2_1
X_4037_ _4037_/A _4037_/B _4037_/C vssd1 vssd1 vccd1 vccd1 _4236_/A sky130_fd_sc_hd__nand3_1
XPHY_106 vssd1 vssd1 vccd1 vccd1 sky130_fd_sc_hd__decap_3
XPHY_139 vssd1 vssd1 vccd1 vccd1 sky130_fd_sc_hd__decap_3
XPHY_128 vssd1 vssd1 vccd1 vccd1 sky130_fd_sc_hd__decap_3
XFILLER_0_19_222 vssd1 vssd1 vccd1 vccd1 sky130_fd_sc_hd__fill_2
X_5988_ _5994_/C _5988_/B vssd1 vssd1 vccd1 vccd1 _5988_/Y sky130_fd_sc_hd__nand2_1
XPHY_117 vssd1 vssd1 vccd1 vccd1 sky130_fd_sc_hd__decap_3
XFILLER_0_19_266 vssd1 vssd1 vccd1 vccd1 sky130_fd_sc_hd__fill_2
X_4939_ _5064_/B _4938_/X _4937_/X vssd1 vssd1 vccd1 vccd1 _4941_/A sky130_fd_sc_hd__a21bo_1
XANTENNA__4945__A2 _4944_/B vssd1 vssd1 vccd1 vccd1 sky130_fd_sc_hd__diode_2
XANTENNA_40 sstream_i[15] vssd1 vssd1 vccd1 vccd1 sky130_fd_sc_hd__diode_2
XFILLER_0_74_394 vssd1 vssd1 vccd1 vccd1 sky130_ef_sc_hd__decap_12
XANTENNA_84 sstream_i[31] vssd1 vssd1 vccd1 vccd1 sky130_fd_sc_hd__diode_2
XANTENNA_51 sstream_i[17] vssd1 vssd1 vccd1 vccd1 sky130_fd_sc_hd__diode_2
XANTENNA_62 sstream_i[20] vssd1 vssd1 vccd1 vccd1 sky130_fd_sc_hd__diode_2
XANTENNA_73 sstream_i[25] vssd1 vssd1 vccd1 vccd1 sky130_fd_sc_hd__diode_2
X_6609_ _6830_/CLK _6609_/D fanout153/X vssd1 vssd1 vccd1 vccd1 tex_mport_o[52] sky130_fd_sc_hd__dfrtp_4
XFILLER_0_34_247 vssd1 vssd1 vccd1 vccd1 sky130_fd_sc_hd__decap_4
XANTENNA_95 sstream_i[3] vssd1 vssd1 vccd1 vccd1 sky130_fd_sc_hd__diode_2
XFILLER_0_6_182 vssd1 vssd1 vccd1 vccd1 sky130_fd_sc_hd__fill_2
XFILLER_0_100_363 vssd1 vssd1 vccd1 vccd1 sky130_fd_sc_hd__fill_1
XANTENNA__3358__A1_N _5299_/A vssd1 vssd1 vccd1 vccd1 sky130_fd_sc_hd__diode_2
XPHY_8 vssd1 vssd1 vccd1 vccd1 sky130_fd_sc_hd__decap_3
XFILLER_0_57_317 vssd1 vssd1 vccd1 vccd1 sky130_fd_sc_hd__decap_4
XFILLER_0_84_136 vssd1 vssd1 vccd1 vccd1 sky130_fd_sc_hd__fill_2
XFILLER_0_84_169 vssd1 vssd1 vccd1 vccd1 sky130_fd_sc_hd__fill_1
XANTENNA__6138__A1 _6224_/B vssd1 vssd1 vccd1 vccd1 sky130_fd_sc_hd__diode_2
XFILLER_0_65_361 vssd1 vssd1 vccd1 vccd1 sky130_fd_sc_hd__fill_2
XFILLER_0_25_214 vssd1 vssd1 vccd1 vccd1 sky130_fd_sc_hd__fill_1
XFILLER_0_80_353 vssd1 vssd1 vccd1 vccd1 sky130_fd_sc_hd__decap_8
XANTENNA__3944__A _5801_/A vssd1 vssd1 vccd1 vccd1 sky130_fd_sc_hd__diode_2
XFILLER_0_33_291 vssd1 vssd1 vccd1 vccd1 sky130_fd_sc_hd__fill_1
XFILLER_0_0_325 vssd1 vssd1 vccd1 vccd1 sky130_fd_sc_hd__fill_2
X_3270_ _6516_/Q vssd1 vssd1 vccd1 vccd1 _3270_/Y sky130_fd_sc_hd__inv_2
XFILLER_0_0_369 vssd1 vssd1 vccd1 vccd1 sky130_fd_sc_hd__fill_2
XTAP_604 vssd1 vccd1 sky130_fd_sc_hd__tapvpwrvgnd_1
XTAP_615 vssd1 vccd1 sky130_fd_sc_hd__tapvpwrvgnd_1
XTAP_626 vssd1 vccd1 sky130_fd_sc_hd__tapvpwrvgnd_1
XTAP_637 vssd1 vccd1 sky130_fd_sc_hd__tapvpwrvgnd_1
XTAP_648 vssd1 vccd1 sky130_fd_sc_hd__tapvpwrvgnd_1
XTAP_659 vssd1 vccd1 sky130_fd_sc_hd__tapvpwrvgnd_1
X_6960_ vssd1 vssd1 vccd1 vccd1 _6960_/HI tex_mport_o[13] sky130_fd_sc_hd__conb_1
X_5911_ hold175/X _5910_/X _5923_/S vssd1 vssd1 vccd1 vccd1 _6650_/D sky130_fd_sc_hd__mux2_1
XANTENNA__5821__A0 _5422_/X vssd1 vssd1 vccd1 vccd1 sky130_fd_sc_hd__diode_2
X_6891_ _6892_/CLK _6891_/D vssd1 vssd1 vccd1 vccd1 _6891_/Q sky130_fd_sc_hd__dfxtp_1
X_5842_ _5863_/A _5851_/B vssd1 vssd1 vccd1 vccd1 _5842_/X sky130_fd_sc_hd__xor2_1
XFILLER_0_124_97 vssd1 vssd1 vccd1 vccd1 sky130_fd_sc_hd__fill_2
X_5773_ _5772_/A _5772_/B _5772_/C vssd1 vssd1 vccd1 vccd1 _5782_/B sky130_fd_sc_hd__a21oi_2
XANTENNA__4927__A2 _5656_/A vssd1 vssd1 vccd1 vccd1 sky130_fd_sc_hd__diode_2
XFILLER_0_90_106 vssd1 vssd1 vccd1 vccd1 sky130_fd_sc_hd__fill_1
X_4724_ _6638_/Q _4913_/B vssd1 vssd1 vccd1 vccd1 _4914_/A sky130_fd_sc_hd__nand2_1
XFILLER_0_83_191 vssd1 vssd1 vccd1 vccd1 sky130_fd_sc_hd__fill_2
XFILLER_0_83_180 vssd1 vssd1 vccd1 vccd1 sky130_fd_sc_hd__fill_2
XFILLER_0_16_247 vssd1 vssd1 vccd1 vccd1 sky130_fd_sc_hd__decap_4
XFILLER_0_126_293 vssd1 vssd1 vccd1 vccd1 sky130_fd_sc_hd__decap_4
X_4655_ _4655_/A _4655_/B vssd1 vssd1 vccd1 vccd1 _4674_/A sky130_fd_sc_hd__xnor2_2
X_4586_ _5656_/A _4637_/D _4585_/B _4582_/X vssd1 vssd1 vccd1 vccd1 _4588_/A sky130_fd_sc_hd__a31o_1
X_3606_ _3606_/A _3606_/B vssd1 vssd1 vccd1 vccd1 _3608_/C sky130_fd_sc_hd__xnor2_1
XANTENNA__5888__B1 _5594_/Y vssd1 vssd1 vccd1 vccd1 sky130_fd_sc_hd__diode_2
XANTENNA_fanout110_A _4638_/A vssd1 vssd1 vccd1 vccd1 sky130_fd_sc_hd__diode_2
X_6325_ hold39/X pix_mport_i[32] vssd1 vssd1 vccd1 vccd1 _6325_/Y sky130_fd_sc_hd__nand2b_1
X_3537_ _3537_/A _3537_/B vssd1 vssd1 vccd1 vccd1 _3544_/B sky130_fd_sc_hd__xnor2_1
XFILLER_0_3_163 vssd1 vssd1 vccd1 vccd1 sky130_fd_sc_hd__decap_3
X_6256_ _6253_/X _6268_/B _6255_/X _6252_/X _6251_/A vssd1 vssd1 vccd1 vccd1 _6256_/X
+ sky130_fd_sc_hd__a32o_1
X_3468_ _3468_/A _3468_/B vssd1 vssd1 vccd1 vccd1 _3471_/B sky130_fd_sc_hd__nor2_1
X_6187_ pix_mport_o[44] _6207_/B _6185_/X _6186_/Y vssd1 vssd1 vccd1 vccd1 _6772_/D
+ sky130_fd_sc_hd__a22o_1
X_3399_ _3399_/A _3399_/B vssd1 vssd1 vccd1 vccd1 _3401_/B sky130_fd_sc_hd__xnor2_1
X_5207_ _5207_/A _5207_/B vssd1 vssd1 vccd1 vccd1 _5209_/B sky130_fd_sc_hd__nand2_1
X_5138_ _5136_/A _5136_/B _5136_/C vssd1 vssd1 vccd1 vccd1 _5139_/C sky130_fd_sc_hd__a21o_1
XFILLER_0_98_228 vssd1 vssd1 vccd1 vccd1 sky130_fd_sc_hd__fill_1
XANTENNA__3418__A2 _5273_/B vssd1 vssd1 vccd1 vccd1 sky130_fd_sc_hd__diode_2
X_5069_ _5076_/B _5076_/A vssd1 vssd1 vccd1 vccd1 _5078_/A sky130_fd_sc_hd__and2b_1
XFILLER_0_94_401 vssd1 vssd1 vccd1 vccd1 sky130_fd_sc_hd__decap_6
XANTENNA__4091__A2 _4488_/A vssd1 vssd1 vccd1 vccd1 sky130_fd_sc_hd__diode_2
XFILLER_0_66_169 vssd1 vssd1 vccd1 vccd1 sky130_fd_sc_hd__fill_2
XFILLER_0_132_230 vssd1 vssd1 vccd1 vccd1 sky130_fd_sc_hd__fill_2
XFILLER_0_117_293 vssd1 vssd1 vccd1 vccd1 sky130_fd_sc_hd__fill_2
Xclkbuf_leaf_15_clk_i clkbuf_2_3__f_clk_i/X vssd1 vssd1 vccd1 vccd1 _6832_/CLK sky130_fd_sc_hd__clkbuf_16
XANTENNA_clkbuf_leaf_7_clk_i_A clkbuf_leaf_9_clk_i/A vssd1 vssd1 vccd1 vccd1 sky130_fd_sc_hd__diode_2
XFILLER_0_100_193 vssd1 vssd1 vccd1 vccd1 sky130_fd_sc_hd__decap_3
XANTENNA__4745__D _4776_/A vssd1 vssd1 vccd1 vccd1 sky130_fd_sc_hd__diode_2
XFILLER_0_70_27 vssd1 vssd1 vccd1 vccd1 sky130_fd_sc_hd__fill_1
XFILLER_0_57_147 vssd1 vssd1 vccd1 vccd1 sky130_fd_sc_hd__fill_1
XFILLER_0_57_169 vssd1 vssd1 vccd1 vccd1 sky130_fd_sc_hd__fill_2
XFILLER_0_38_361 vssd1 vssd1 vccd1 vccd1 sky130_fd_sc_hd__decap_3
XFILLER_0_72_139 vssd1 vssd1 vccd1 vccd1 sky130_fd_sc_hd__fill_1
XFILLER_0_110_11 vssd1 vssd1 vccd1 vccd1 sky130_fd_sc_hd__fill_2
XFILLER_0_123_241 vssd1 vssd1 vccd1 vccd1 sky130_fd_sc_hd__fill_2
X_4440_ _4440_/A _4440_/B _4440_/C vssd1 vssd1 vccd1 vccd1 _4452_/A sky130_fd_sc_hd__and3_2
XFILLER_0_80_183 vssd1 vssd1 vccd1 vccd1 sky130_fd_sc_hd__fill_2
Xhold107 _6885_/Q vssd1 vssd1 vccd1 vccd1 hold107/X sky130_fd_sc_hd__dlygate4sd3_1
Xhold118 _6836_/Q vssd1 vssd1 vccd1 vccd1 hold118/X sky130_fd_sc_hd__dlygate4sd3_1
Xhold129 _3333_/X vssd1 vssd1 vccd1 vccd1 _6807_/D sky130_fd_sc_hd__dlygate4sd3_1
X_4371_ _4362_/A _4362_/C _4362_/B vssd1 vssd1 vccd1 vccd1 _4371_/Y sky130_fd_sc_hd__o21ai_2
X_6110_ _6649_/Q hold238/X _6113_/S vssd1 vssd1 vccd1 vccd1 _6110_/X sky130_fd_sc_hd__mux2_1
X_3322_ _6839_/Q vssd1 vssd1 vccd1 vccd1 _6258_/B sky130_fd_sc_hd__inv_2
XTAP_401 vssd1 vccd1 sky130_fd_sc_hd__tapvpwrvgnd_1
XTAP_412 vssd1 vccd1 sky130_fd_sc_hd__tapvpwrvgnd_1
XTAP_423 vssd1 vccd1 sky130_fd_sc_hd__tapvpwrvgnd_1
X_3253_ _5666_/A vssd1 vssd1 vccd1 vccd1 _3253_/Y sky130_fd_sc_hd__inv_2
X_6041_ _5300_/B _6038_/B _6038_/Y vssd1 vssd1 vccd1 vccd1 _6680_/D sky130_fd_sc_hd__a21o_1
XTAP_434 vssd1 vccd1 sky130_fd_sc_hd__tapvpwrvgnd_1
XTAP_445 vssd1 vccd1 sky130_fd_sc_hd__tapvpwrvgnd_1
XTAP_456 vssd1 vccd1 sky130_fd_sc_hd__tapvpwrvgnd_1
XTAP_467 vssd1 vccd1 sky130_fd_sc_hd__tapvpwrvgnd_1
XTAP_478 vssd1 vccd1 sky130_fd_sc_hd__tapvpwrvgnd_1
XFILLER_0_28_62 vssd1 vssd1 vccd1 vccd1 sky130_fd_sc_hd__fill_2
XTAP_489 vssd1 vccd1 sky130_fd_sc_hd__tapvpwrvgnd_1
X_6943_ vssd1 vssd1 vccd1 vccd1 _6943_/HI pix_mport_o[63] sky130_fd_sc_hd__conb_1
XANTENNA__6823__RESET_B fanout153/X vssd1 vssd1 vccd1 vccd1 sky130_fd_sc_hd__diode_2
X_6874_ _6892_/CLK _6874_/D vssd1 vssd1 vccd1 vccd1 _6874_/Q sky130_fd_sc_hd__dfxtp_1
XANTENNA__3820__A2 _5071_/A vssd1 vssd1 vccd1 vccd1 sky130_fd_sc_hd__diode_2
XFILLER_0_36_309 vssd1 vssd1 vccd1 vccd1 sky130_fd_sc_hd__decap_8
X_5825_ _5825_/A _5837_/B vssd1 vssd1 vccd1 vccd1 _5825_/X sky130_fd_sc_hd__or2_1
XFILLER_0_63_128 vssd1 vssd1 vccd1 vccd1 sky130_fd_sc_hd__fill_1
X_5756_ _5755_/Y _6517_/Q _5802_/B vssd1 vssd1 vccd1 vccd1 _5758_/B sky130_fd_sc_hd__mux2_1
XFILLER_0_8_288 vssd1 vssd1 vccd1 vccd1 sky130_fd_sc_hd__fill_2
X_4707_ _4707_/A _4707_/B vssd1 vssd1 vccd1 vccd1 _5392_/B sky130_fd_sc_hd__nor2_2
X_5687_ _5687_/A _5687_/B _5687_/C vssd1 vssd1 vccd1 vccd1 _5701_/B sky130_fd_sc_hd__or3_1
X_4638_ _4638_/A _4688_/C vssd1 vssd1 vccd1 vccd1 _4675_/A sky130_fd_sc_hd__nand2_1
XFILLER_0_44_386 vssd1 vssd1 vccd1 vccd1 sky130_ef_sc_hd__decap_12
XFILLER_0_8_83 vssd1 vssd1 vccd1 vccd1 sky130_fd_sc_hd__fill_1
X_4569_ _4568_/A _4568_/B _4568_/C _4568_/D vssd1 vssd1 vccd1 vccd1 _4571_/C sky130_fd_sc_hd__o31ai_2
X_6308_ _6791_/Q hold5/X _6319_/S vssd1 vssd1 vccd1 vccd1 hold6/A sky130_fd_sc_hd__mux2_1
X_6239_ _3307_/Y _6852_/Q _3308_/Y _6851_/Q _6238_/X vssd1 vssd1 vccd1 vccd1 _6239_/X
+ sky130_fd_sc_hd__a221o_1
XTAP_990 vssd1 vccd1 sky130_fd_sc_hd__tapvpwrvgnd_1
XFILLER_0_79_294 vssd1 vssd1 vccd1 vccd1 sky130_fd_sc_hd__fill_2
XFILLER_0_94_253 vssd1 vssd1 vccd1 vccd1 sky130_fd_sc_hd__fill_2
XANTENNA__3909__D _4966_/B vssd1 vssd1 vccd1 vccd1 sky130_fd_sc_hd__diode_2
XFILLER_0_39_169 vssd1 vssd1 vccd1 vccd1 sky130_fd_sc_hd__fill_2
XFILLER_0_50_334 vssd1 vssd1 vccd1 vccd1 sky130_fd_sc_hd__fill_2
XFILLER_0_120_288 vssd1 vssd1 vccd1 vccd1 sky130_fd_sc_hd__fill_2
XFILLER_0_65_27 vssd1 vssd1 vccd1 vccd1 sky130_fd_sc_hd__fill_2
X_3940_ _3927_/A _3927_/B _3925_/X vssd1 vssd1 vccd1 vccd1 _3940_/X sky130_fd_sc_hd__o21ba_1
XFILLER_0_14_53 vssd1 vssd1 vccd1 vccd1 sky130_ef_sc_hd__decap_12
XANTENNA__3819__D _5064_/B vssd1 vssd1 vccd1 vccd1 sky130_fd_sc_hd__diode_2
X_3871_ _5083_/A _3961_/A _5296_/A _5081_/D _3870_/X vssd1 vssd1 vccd1 vccd1 _3920_/A
+ sky130_fd_sc_hd__a41o_1
X_6590_ _6818_/CLK _6590_/D fanout142/X vssd1 vssd1 vccd1 vccd1 tex_mport_o[33] sky130_fd_sc_hd__dfrtp_4
X_5610_ _3253_/Y _6509_/Q _6508_/Q _3252_/Y vssd1 vssd1 vccd1 vccd1 _5610_/X sky130_fd_sc_hd__o22a_1
XFILLER_0_26_331 vssd1 vssd1 vccd1 vccd1 sky130_fd_sc_hd__decap_8
XFILLER_0_38_191 vssd1 vssd1 vccd1 vccd1 sky130_fd_sc_hd__fill_2
X_5541_ depth_mport_o[16] hold153/X _5541_/S vssd1 vssd1 vccd1 vccd1 _6572_/D sky130_fd_sc_hd__mux2_1
XFILLER_0_30_63 vssd1 vssd1 vccd1 vccd1 sky130_fd_sc_hd__fill_2
XFILLER_0_41_323 vssd1 vssd1 vccd1 vccd1 sky130_fd_sc_hd__fill_1
X_5472_ hold18/X sstream_i[63] _6486_/S vssd1 vssd1 vccd1 vccd1 _6505_/D sky130_fd_sc_hd__mux2_1
XFILLER_0_30_85 vssd1 vssd1 vccd1 vccd1 sky130_fd_sc_hd__fill_2
X_4423_ _4423_/A _4423_/B vssd1 vssd1 vccd1 vccd1 _4442_/A sky130_fd_sc_hd__or2_1
X_4354_ _6633_/Q _4354_/B vssd1 vssd1 vccd1 vccd1 _4355_/B sky130_fd_sc_hd__or2_1
X_3305_ depth_mport_i[21] vssd1 vssd1 vccd1 vccd1 _3305_/Y sky130_fd_sc_hd__inv_2
X_4285_ _4264_/A _4264_/C _4264_/B vssd1 vssd1 vccd1 vccd1 _4285_/Y sky130_fd_sc_hd__a21oi_1
X_6024_ _5081_/B _6023_/Y _6037_/S vssd1 vssd1 vccd1 vccd1 _6674_/D sky130_fd_sc_hd__mux2_1
XTAP_286 vssd1 vccd1 sky130_fd_sc_hd__tapvpwrvgnd_1
XTAP_297 vssd1 vccd1 sky130_fd_sc_hd__tapvpwrvgnd_1
X_6926_ vssd1 vssd1 vccd1 vccd1 _6926_/HI pix_mport_o[27] sky130_fd_sc_hd__conb_1
XANTENNA__4046__A2 _4476_/D vssd1 vssd1 vccd1 vccd1 sky130_fd_sc_hd__diode_2
Xfanout13 _5468_/X vssd1 vssd1 vccd1 vccd1 _5502_/S sky130_fd_sc_hd__clkbuf_4
XFILLER_0_76_253 vssd1 vssd1 vccd1 vccd1 sky130_fd_sc_hd__fill_2
XFILLER_0_119_322 vssd1 vssd1 vccd1 vccd1 sky130_fd_sc_hd__fill_2
Xfanout24 _6223_/B vssd1 vssd1 vccd1 vccd1 _6207_/B sky130_fd_sc_hd__buf_4
Xfanout35 _6810_/Q vssd1 vssd1 vccd1 vccd1 _5599_/A sky130_fd_sc_hd__clkbuf_8
Xfanout46 _6678_/Q vssd1 vssd1 vccd1 vccd1 _5051_/B sky130_fd_sc_hd__buf_4
X_6857_ _6880_/CLK _6857_/D vssd1 vssd1 vccd1 vccd1 _6857_/Q sky130_fd_sc_hd__dfxtp_2
X_6788_ _6830_/CLK hold43/X vssd1 vssd1 vccd1 vccd1 _6788_/Q sky130_fd_sc_hd__dfxtp_1
XANTENNA__6624__SET_B fanout145/X vssd1 vssd1 vccd1 vccd1 sky130_fd_sc_hd__diode_2
X_5808_ _5808_/A _5808_/B vssd1 vssd1 vccd1 vccd1 _5808_/Y sky130_fd_sc_hd__xnor2_1
Xfanout79 _6684_/Q vssd1 vssd1 vccd1 vccd1 _5296_/B sky130_fd_sc_hd__buf_4
XFILLER_0_17_320 vssd1 vssd1 vccd1 vccd1 sky130_fd_sc_hd__decap_6
Xfanout57 _4776_/A vssd1 vssd1 vccd1 vccd1 _5118_/B sky130_fd_sc_hd__buf_4
Xfanout68 hold279/X vssd1 vssd1 vccd1 vccd1 _4971_/D sky130_fd_sc_hd__buf_4
X_5739_ _5739_/A _5739_/B vssd1 vssd1 vccd1 vccd1 _5740_/B sky130_fd_sc_hd__nand2_1
XFILLER_0_17_353 vssd1 vssd1 vccd1 vccd1 sky130_fd_sc_hd__fill_2
XFILLER_0_17_386 vssd1 vssd1 vccd1 vccd1 sky130_fd_sc_hd__decap_6
XFILLER_0_32_345 vssd1 vssd1 vccd1 vccd1 sky130_fd_sc_hd__decap_6
XANTENNA__3464__D _5286_/B vssd1 vssd1 vccd1 vccd1 sky130_fd_sc_hd__diode_2
XFILLER_0_32_378 vssd1 vssd1 vccd1 vccd1 sky130_fd_sc_hd__fill_2
XANTENNA_fanout90_A _4816_/B vssd1 vssd1 vccd1 vccd1 sky130_fd_sc_hd__diode_2
XANTENNA__6431__B1 _6546_/Q vssd1 vssd1 vccd1 vccd1 sky130_fd_sc_hd__diode_2
XFILLER_0_67_242 vssd1 vssd1 vccd1 vccd1 sky130_fd_sc_hd__fill_2
XFILLER_0_137_130 vssd1 vssd1 vccd1 vccd1 sky130_fd_sc_hd__fill_2
XFILLER_0_27_117 vssd1 vssd1 vccd1 vccd1 sky130_fd_sc_hd__fill_2
XFILLER_0_35_194 vssd1 vssd1 vccd1 vccd1 sky130_fd_sc_hd__fill_2
XANTENNA__5643__S _5844_/S vssd1 vssd1 vccd1 vccd1 sky130_fd_sc_hd__diode_2
XFILLER_0_23_367 vssd1 vssd1 vccd1 vccd1 sky130_fd_sc_hd__decap_6
XFILLER_0_50_153 vssd1 vssd1 vccd1 vccd1 sky130_fd_sc_hd__fill_1
X_4070_ _4070_/A _4070_/B vssd1 vssd1 vccd1 vccd1 _4072_/B sky130_fd_sc_hd__xnor2_1
XFILLER_0_25_41 vssd1 vssd1 vccd1 vccd1 sky130_fd_sc_hd__fill_2
XFILLER_0_116_98 vssd1 vssd1 vccd1 vccd1 sky130_fd_sc_hd__fill_1
X_4972_ _5801_/A _4971_/B _5787_/A _4971_/D vssd1 vssd1 vccd1 vccd1 _4973_/C sky130_fd_sc_hd__a22o_1
XFILLER_0_58_220 vssd1 vssd1 vccd1 vccd1 sky130_fd_sc_hd__fill_2
X_6711_ _6802_/CLK hold41/X vssd1 vssd1 vccd1 vccd1 hold40/A sky130_fd_sc_hd__dfxtp_1
XFILLER_0_73_201 vssd1 vssd1 vccd1 vccd1 sky130_fd_sc_hd__fill_1
XFILLER_0_18_117 vssd1 vssd1 vccd1 vccd1 sky130_fd_sc_hd__decap_3
X_3923_ _3923_/A _3923_/B _3923_/C vssd1 vssd1 vccd1 vccd1 _3923_/X sky130_fd_sc_hd__or3_2
XFILLER_0_58_253 vssd1 vssd1 vccd1 vccd1 sky130_fd_sc_hd__decap_4
XFILLER_0_128_163 vssd1 vssd1 vccd1 vccd1 sky130_fd_sc_hd__fill_1
XFILLER_0_18_139 vssd1 vssd1 vccd1 vccd1 sky130_fd_sc_hd__fill_1
X_3854_ _3854_/A _3854_/B _3854_/C vssd1 vssd1 vccd1 vccd1 _3854_/X sky130_fd_sc_hd__or3_2
X_6642_ _6745_/CLK _6642_/D fanout139/X vssd1 vssd1 vccd1 vccd1 _6642_/Q sky130_fd_sc_hd__dfstp_1
XFILLER_0_73_256 vssd1 vssd1 vccd1 vccd1 sky130_fd_sc_hd__fill_2
XFILLER_0_33_109 vssd1 vssd1 vccd1 vccd1 sky130_fd_sc_hd__decap_3
XFILLER_0_41_62 vssd1 vssd1 vccd1 vccd1 sky130_fd_sc_hd__decap_4
X_6573_ _6812_/CLK _6573_/D _6320_/C vssd1 vssd1 vccd1 vccd1 depth_mport_o[17] sky130_fd_sc_hd__dfrtp_4
XANTENNA__4200__A2 _4527_/B vssd1 vssd1 vccd1 vccd1 sky130_fd_sc_hd__diode_2
XFILLER_0_26_172 vssd1 vssd1 vccd1 vccd1 sky130_fd_sc_hd__fill_1
X_3785_ _5308_/B _4832_/C _4966_/B _5115_/C vssd1 vssd1 vccd1 vccd1 _3788_/A sky130_fd_sc_hd__nand4_2
X_5524_ _6231_/A _5524_/B vssd1 vssd1 vccd1 vccd1 _5554_/S sky130_fd_sc_hd__nor2_2
XANTENNA__6489__A0 hold217/X vssd1 vssd1 vccd1 vccd1 sky130_fd_sc_hd__diode_2
XANTENNA__4958__A _5081_/A vssd1 vssd1 vccd1 vccd1 sky130_fd_sc_hd__diode_2
X_5455_ _6750_/Q _5599_/B vssd1 vssd1 vccd1 vccd1 _5456_/D sky130_fd_sc_hd__xnor2_1
X_4406_ _4394_/A _4394_/C _4394_/B vssd1 vssd1 vccd1 vccd1 _4410_/A sky130_fd_sc_hd__a21bo_1
XFILLER_0_67_3 vssd1 vssd1 vccd1 vccd1 sky130_fd_sc_hd__decap_3
X_5386_ _6728_/Q _5728_/B vssd1 vssd1 vccd1 vccd1 _5387_/D sky130_fd_sc_hd__xnor2_1
X_4337_ _4338_/A _4337_/B _4337_/C vssd1 vssd1 vccd1 vccd1 _4392_/A sky130_fd_sc_hd__nand3_1
XFILLER_0_5_51 vssd1 vssd1 vccd1 vccd1 sky130_fd_sc_hd__decap_4
X_4268_ _5701_/A _4582_/D _4551_/D _5687_/A vssd1 vssd1 vccd1 vccd1 _4269_/C sky130_fd_sc_hd__a22o_1
X_6007_ tex_height_i[9] _6008_/B vssd1 vssd1 vccd1 vccd1 _6016_/C sky130_fd_sc_hd__or2_1
X_4199_ _4199_/A _4199_/B vssd1 vssd1 vccd1 vccd1 _4207_/A sky130_fd_sc_hd__nor2_1
XTAP_1205 vssd1 vccd1 sky130_fd_sc_hd__tapvpwrvgnd_1
XTAP_1238 vssd1 vccd1 sky130_fd_sc_hd__tapvpwrvgnd_1
XTAP_1227 vssd1 vccd1 sky130_fd_sc_hd__tapvpwrvgnd_1
XTAP_1216 vssd1 vccd1 sky130_fd_sc_hd__tapvpwrvgnd_1
XTAP_1249 vssd1 vccd1 sky130_fd_sc_hd__tapvpwrvgnd_1
X_6909_ vssd1 vssd1 vccd1 vccd1 _6909_/HI pix_mport_o[10] sky130_fd_sc_hd__conb_1
XFILLER_0_49_275 vssd1 vssd1 vccd1 vccd1 sky130_fd_sc_hd__decap_4
XFILLER_0_119_163 vssd1 vssd1 vccd1 vccd1 sky130_fd_sc_hd__decap_3
XFILLER_0_9_350 vssd1 vssd1 vccd1 vccd1 sky130_fd_sc_hd__fill_2
XANTENNA__4727__B1 _4814_/D vssd1 vssd1 vccd1 vccd1 sky130_fd_sc_hd__diode_2
XFILLER_0_134_155 vssd1 vssd1 vccd1 vccd1 sky130_fd_sc_hd__fill_1
XFILLER_0_64_289 vssd1 vssd1 vccd1 vccd1 sky130_ef_sc_hd__decap_12
XFILLER_0_17_161 vssd1 vssd1 vccd1 vccd1 sky130_fd_sc_hd__decap_4
XFILLER_0_115_391 vssd1 vssd1 vccd1 vccd1 sky130_fd_sc_hd__fill_1
XFILLER_0_20_315 vssd1 vssd1 vccd1 vccd1 sky130_fd_sc_hd__fill_2
XFILLER_0_130_350 vssd1 vssd1 vccd1 vccd1 sky130_fd_sc_hd__fill_1
XFILLER_0_20_348 vssd1 vssd1 vccd1 vccd1 sky130_fd_sc_hd__decap_3
XFILLER_0_20_359 vssd1 vssd1 vccd1 vccd1 sky130_fd_sc_hd__fill_2
Xhold290 _6626_/Q vssd1 vssd1 vccd1 vccd1 hold290/X sky130_fd_sc_hd__dlygate4sd3_1
XFILLER_0_99_120 vssd1 vssd1 vccd1 vccd1 sky130_fd_sc_hd__fill_1
XFILLER_0_87_337 vssd1 vssd1 vccd1 vccd1 sky130_fd_sc_hd__fill_2
XANTENNA_152 sstream_i[111] vssd1 vssd1 vccd1 vccd1 sky130_fd_sc_hd__diode_2
XANTENNA_141 tex_height_i[0] vssd1 vssd1 vccd1 vccd1 sky130_fd_sc_hd__diode_2
XANTENNA_130 tex_addr_i[15] vssd1 vssd1 vccd1 vccd1 sky130_fd_sc_hd__diode_2
XANTENNA__4718__B1 _4736_/D vssd1 vssd1 vccd1 vccd1 sky130_fd_sc_hd__diode_2
XFILLER_0_113_306 vssd1 vssd1 vccd1 vccd1 sky130_fd_sc_hd__fill_1
X_3570_ _3959_/B _5300_/A vssd1 vssd1 vccd1 vccd1 _3594_/B sky130_fd_sc_hd__nand2_1
XFILLER_0_23_164 vssd1 vssd1 vccd1 vccd1 sky130_fd_sc_hd__fill_2
XANTENNA__5881__B _5919_/B vssd1 vssd1 vccd1 vccd1 sky130_fd_sc_hd__diode_2
XANTENNA__4778__A _4971_/B vssd1 vssd1 vccd1 vccd1 sky130_fd_sc_hd__diode_2
XFILLER_0_11_337 vssd1 vssd1 vccd1 vccd1 sky130_fd_sc_hd__fill_2
X_5240_ _4714_/Y _4715_/Y _5039_/X _5239_/B vssd1 vssd1 vccd1 vccd1 _5410_/B sky130_fd_sc_hd__a211o_1
XFILLER_0_11_359 vssd1 vssd1 vccd1 vccd1 sky130_fd_sc_hd__fill_2
X_5171_ _5156_/Y _5167_/X _4984_/B _4984_/Y vssd1 vssd1 vccd1 vccd1 _5171_/Y sky130_fd_sc_hd__o211ai_2
X_4122_ _4122_/A _4122_/B vssd1 vssd1 vccd1 vccd1 _4224_/A sky130_fd_sc_hd__and2_2
X_4053_ _4052_/B _4052_/C _4052_/A vssd1 vssd1 vccd1 vccd1 _4054_/C sky130_fd_sc_hd__a21bo_1
XANTENNA__4960__B _5083_/B vssd1 vssd1 vccd1 vccd1 sky130_fd_sc_hd__diode_2
X_4955_ _5191_/B _4955_/B vssd1 vssd1 vccd1 vccd1 _4988_/A sky130_fd_sc_hd__nand2_1
X_3906_ _3815_/A _3815_/B _3815_/C vssd1 vssd1 vccd1 vccd1 _3906_/Y sky130_fd_sc_hd__o21ai_1
XANTENNA_fanout140_A _5937_/A vssd1 vssd1 vccd1 vccd1 sky130_fd_sc_hd__diode_2
X_4886_ _4886_/A _4886_/B _4886_/C vssd1 vssd1 vccd1 vccd1 _4886_/Y sky130_fd_sc_hd__nor3_2
X_6625_ _6627_/CLK _6625_/D fanout145/X vssd1 vssd1 vccd1 vccd1 _6625_/Q sky130_fd_sc_hd__dfstp_1
X_3837_ _3846_/A _3835_/X _3824_/X _3832_/Y vssd1 vssd1 vccd1 vccd1 _3838_/D sky130_fd_sc_hd__a211o_1
XFILLER_0_46_278 vssd1 vssd1 vccd1 vccd1 sky130_fd_sc_hd__decap_3
XFILLER_0_61_204 vssd1 vssd1 vccd1 vccd1 sky130_fd_sc_hd__fill_2
XFILLER_0_61_215 vssd1 vssd1 vccd1 vccd1 sky130_fd_sc_hd__fill_2
X_6556_ _6864_/CLK _6556_/D _5468_/A vssd1 vssd1 vccd1 vccd1 depth_mport_o[0] sky130_fd_sc_hd__dfrtp_4
XFILLER_0_104_306 vssd1 vssd1 vccd1 vccd1 sky130_fd_sc_hd__fill_2
X_3768_ _3768_/A _3768_/B vssd1 vssd1 vccd1 vccd1 _3769_/B sky130_fd_sc_hd__nand2_1
X_5507_ hold98/X sstream_i[98] _6464_/S vssd1 vssd1 vccd1 vccd1 _6540_/D sky130_fd_sc_hd__mux2_1
XFILLER_0_14_197 vssd1 vssd1 vccd1 vccd1 sky130_fd_sc_hd__fill_1
X_3699_ _3700_/B _3700_/A vssd1 vssd1 vccd1 vccd1 _3699_/X sky130_fd_sc_hd__and2b_1
X_6487_ hold198/X sstream_i[45] _6493_/S vssd1 vssd1 vccd1 vccd1 _6878_/D sky130_fd_sc_hd__mux2_1
XFILLER_0_112_372 vssd1 vssd1 vccd1 vccd1 sky130_ef_sc_hd__decap_12
X_5438_ _5438_/A _5442_/A _5438_/C vssd1 vssd1 vccd1 vccd1 _5451_/B sky130_fd_sc_hd__or3_1
X_5369_ _5645_/A _4688_/C _6621_/Q vssd1 vssd1 vccd1 vccd1 _5370_/B sky130_fd_sc_hd__a21oi_1
XFILLER_0_77_91 vssd1 vssd1 vccd1 vccd1 sky130_fd_sc_hd__fill_2
XANTENNA_hold185_A _6551_/Q vssd1 vssd1 vccd1 vccd1 sky130_fd_sc_hd__diode_2
XANTENNA_fanout53_A _4794_/B vssd1 vssd1 vccd1 vccd1 sky130_fd_sc_hd__diode_2
XTAP_1013 vssd1 vccd1 sky130_fd_sc_hd__tapvpwrvgnd_1
XTAP_1002 vssd1 vccd1 sky130_fd_sc_hd__tapvpwrvgnd_1
XFILLER_0_69_337 vssd1 vssd1 vccd1 vccd1 sky130_fd_sc_hd__fill_2
XTAP_1046 vssd1 vccd1 sky130_fd_sc_hd__tapvpwrvgnd_1
XTAP_1035 vssd1 vccd1 sky130_fd_sc_hd__tapvpwrvgnd_1
XTAP_1024 vssd1 vccd1 sky130_fd_sc_hd__tapvpwrvgnd_1
XFILLER_0_96_167 vssd1 vssd1 vccd1 vccd1 sky130_fd_sc_hd__decap_4
XFILLER_0_84_307 vssd1 vssd1 vccd1 vccd1 sky130_fd_sc_hd__fill_1
XTAP_1079 vssd1 vccd1 sky130_fd_sc_hd__tapvpwrvgnd_1
XTAP_1068 vssd1 vccd1 sky130_fd_sc_hd__tapvpwrvgnd_1
XTAP_1057 vssd1 vccd1 sky130_fd_sc_hd__tapvpwrvgnd_1
XTAP_808 vssd1 vccd1 sky130_fd_sc_hd__tapvpwrvgnd_1
XTAP_819 vssd1 vccd1 sky130_fd_sc_hd__tapvpwrvgnd_1
XANTENNA__4100__A1 _4970_/B vssd1 vssd1 vccd1 vccd1 sky130_fd_sc_hd__diode_2
XFILLER_0_87_134 vssd1 vssd1 vccd1 vccd1 sky130_fd_sc_hd__decap_3
XFILLER_0_87_167 vssd1 vssd1 vccd1 vccd1 sky130_fd_sc_hd__fill_1
XANTENNA__5600__B2 _5588_/C vssd1 vssd1 vccd1 vccd1 sky130_fd_sc_hd__diode_2
XFILLER_0_68_381 vssd1 vssd1 vccd1 vccd1 sky130_ef_sc_hd__decap_12
XFILLER_0_113_55 vssd1 vssd1 vccd1 vccd1 sky130_fd_sc_hd__fill_1
XFILLER_0_28_234 vssd1 vssd1 vccd1 vccd1 sky130_fd_sc_hd__decap_8
X_4740_ _5083_/A _5687_/B vssd1 vssd1 vccd1 vccd1 _4743_/A sky130_fd_sc_hd__and2_1
XFILLER_0_125_3 vssd1 vssd1 vccd1 vccd1 sky130_fd_sc_hd__decap_3
XFILLER_0_113_77 vssd1 vssd1 vccd1 vccd1 sky130_fd_sc_hd__fill_2
X_4671_ _4669_/X _4671_/B vssd1 vssd1 vccd1 vccd1 _5367_/A sky130_fd_sc_hd__and2b_1
XFILLER_0_22_53 vssd1 vssd1 vccd1 vccd1 sky130_fd_sc_hd__fill_2
X_6410_ _6410_/A _6410_/B vssd1 vssd1 vccd1 vccd1 _6416_/C sky130_fd_sc_hd__nand2_1
XFILLER_0_98_24 vssd1 vssd1 vccd1 vccd1 sky130_fd_sc_hd__fill_2
X_3622_ _3622_/A _3622_/B vssd1 vssd1 vccd1 vccd1 _3700_/A sky130_fd_sc_hd__xnor2_1
X_6341_ hold179/X _6553_/Q _6340_/C _6350_/A vssd1 vssd1 vccd1 vccd1 _6342_/C sky130_fd_sc_hd__a22o_1
XFILLER_0_11_123 vssd1 vssd1 vccd1 vccd1 sky130_fd_sc_hd__fill_1
X_3553_ _5286_/A _5300_/B _3461_/C _3461_/D vssd1 vssd1 vccd1 vccd1 _3554_/B sky130_fd_sc_hd__a22oi_1
X_6272_ depth_mport_i[18] _3309_/Y depth_mport_i[17] _3311_/Y _6237_/X vssd1 vssd1
+ vccd1 vccd1 _6277_/A sky130_fd_sc_hd__a221o_1
X_3484_ _3485_/B _3484_/B vssd1 vssd1 vccd1 vccd1 _3486_/A sky130_fd_sc_hd__nand2b_1
XANTENNA__5116__B1 _5115_/D vssd1 vssd1 vccd1 vccd1 sky130_fd_sc_hd__diode_2
XANTENNA__4658__D _4658_/D vssd1 vssd1 vccd1 vccd1 sky130_fd_sc_hd__diode_2
XFILLER_0_11_167 vssd1 vssd1 vccd1 vccd1 sky130_fd_sc_hd__fill_1
X_5223_ _5223_/A _5223_/B vssd1 vssd1 vccd1 vccd1 _5445_/B sky130_fd_sc_hd__or2_1
X_5154_ _5154_/A _5154_/B vssd1 vssd1 vccd1 vccd1 _5156_/B sky130_fd_sc_hd__xnor2_2
X_4105_ _4104_/B _4104_/C _4104_/A vssd1 vssd1 vccd1 vccd1 _4121_/A sky130_fd_sc_hd__a21bo_1
XFILLER_0_47_50 vssd1 vssd1 vccd1 vccd1 sky130_fd_sc_hd__decap_3
X_5085_ _5085_/A _5122_/B _5085_/C vssd1 vssd1 vccd1 vccd1 _5085_/X sky130_fd_sc_hd__and3_1
XFILLER_0_47_94 vssd1 vssd1 vccd1 vccd1 sky130_fd_sc_hd__decap_3
X_4036_ _4102_/B _4030_/C _4253_/A vssd1 vssd1 vccd1 vccd1 _4037_/C sky130_fd_sc_hd__a21o_1
XFILLER_0_2_41 vssd1 vssd1 vccd1 vccd1 sky130_ef_sc_hd__decap_12
XFILLER_0_78_145 vssd1 vssd1 vccd1 vccd1 sky130_fd_sc_hd__decap_3
XFILLER_0_78_112 vssd1 vssd1 vccd1 vccd1 sky130_fd_sc_hd__fill_2
XFILLER_0_2_85 vssd1 vssd1 vccd1 vccd1 sky130_ef_sc_hd__decap_12
XANTENNA__4971__A _5801_/A vssd1 vssd1 vccd1 vccd1 sky130_fd_sc_hd__diode_2
XFILLER_0_93_104 vssd1 vssd1 vccd1 vccd1 sky130_fd_sc_hd__fill_2
XFILLER_0_63_82 vssd1 vssd1 vccd1 vccd1 sky130_fd_sc_hd__decap_4
XPHY_107 vssd1 vssd1 vccd1 vccd1 sky130_fd_sc_hd__decap_3
XPHY_129 vssd1 vssd1 vccd1 vccd1 sky130_fd_sc_hd__decap_3
X_5987_ tex_height_i[4] _5987_/B vssd1 vssd1 vccd1 vccd1 _5988_/B sky130_fd_sc_hd__nand2_1
XPHY_118 vssd1 vssd1 vccd1 vccd1 sky130_fd_sc_hd__decap_3
X_4938_ _5091_/A _5091_/B _5106_/B vssd1 vssd1 vccd1 vccd1 _4938_/X sky130_fd_sc_hd__and3_1
XANTENNA_41 sstream_i[15] vssd1 vssd1 vccd1 vccd1 sky130_fd_sc_hd__diode_2
XANTENNA_30 sstream_i[13] vssd1 vssd1 vccd1 vccd1 sky130_fd_sc_hd__diode_2
XFILLER_0_34_204 vssd1 vssd1 vccd1 vccd1 sky130_fd_sc_hd__decap_4
X_4869_ _4869_/A _4869_/B _4869_/C vssd1 vssd1 vccd1 vccd1 _4869_/Y sky130_fd_sc_hd__nand3_2
XANTENNA_52 sstream_i[17] vssd1 vssd1 vccd1 vccd1 sky130_fd_sc_hd__diode_2
XANTENNA_74 sstream_i[26] vssd1 vssd1 vccd1 vccd1 sky130_fd_sc_hd__diode_2
XANTENNA_63 sstream_i[21] vssd1 vssd1 vccd1 vccd1 sky130_fd_sc_hd__diode_2
X_6608_ _6751_/CLK _6608_/D _5937_/A vssd1 vssd1 vccd1 vccd1 tex_mport_o[51] sky130_fd_sc_hd__dfrtp_4
XANTENNA_85 sstream_i[31] vssd1 vssd1 vccd1 vccd1 sky130_fd_sc_hd__diode_2
XANTENNA_96 sstream_i[4] vssd1 vssd1 vccd1 vccd1 sky130_fd_sc_hd__diode_2
XFILLER_0_104_136 vssd1 vssd1 vccd1 vccd1 sky130_fd_sc_hd__fill_2
XFILLER_0_104_125 vssd1 vssd1 vccd1 vccd1 sky130_fd_sc_hd__decap_4
XFILLER_0_104_114 vssd1 vssd1 vccd1 vccd1 sky130_fd_sc_hd__fill_2
X_6539_ _6855_/CLK _6539_/D vssd1 vssd1 vccd1 vccd1 _6539_/Q sky130_fd_sc_hd__dfxtp_2
XFILLER_0_100_353 vssd1 vssd1 vccd1 vccd1 sky130_fd_sc_hd__fill_2
XANTENNA__5741__S _5784_/S vssd1 vssd1 vccd1 vccd1 sky130_fd_sc_hd__diode_2
XANTENNA__4094__B1 _4841_/C vssd1 vssd1 vccd1 vccd1 sky130_fd_sc_hd__diode_2
XFILLER_0_84_104 vssd1 vssd1 vccd1 vccd1 sky130_fd_sc_hd__fill_2
XFILLER_0_69_167 vssd1 vssd1 vccd1 vccd1 sky130_fd_sc_hd__fill_1
XPHY_9 vssd1 vssd1 vccd1 vccd1 sky130_fd_sc_hd__decap_3
XANTENNA__3841__B1 _3999_/A vssd1 vssd1 vccd1 vccd1 sky130_fd_sc_hd__diode_2
XFILLER_0_57_307 vssd1 vssd1 vccd1 vccd1 sky130_fd_sc_hd__decap_3
XANTENNA_clkbuf_leaf_3_clk_i_A clkbuf_leaf_9_clk_i/A vssd1 vssd1 vccd1 vccd1 sky130_fd_sc_hd__diode_2
XANTENNA__3497__A _5286_/A vssd1 vssd1 vccd1 vccd1 sky130_fd_sc_hd__diode_2
XFILLER_0_84_159 vssd1 vssd1 vccd1 vccd1 sky130_fd_sc_hd__decap_3
XFILLER_0_84_148 vssd1 vssd1 vccd1 vccd1 sky130_fd_sc_hd__fill_1
XFILLER_0_135_250 vssd1 vssd1 vccd1 vccd1 sky130_fd_sc_hd__fill_2
XFILLER_0_4_109 vssd1 vssd1 vccd1 vccd1 sky130_ef_sc_hd__decap_12
XFILLER_0_80_365 vssd1 vssd1 vccd1 vccd1 sky130_fd_sc_hd__fill_2
XANTENNA__3944__B _5787_/A vssd1 vssd1 vccd1 vccd1 sky130_fd_sc_hd__diode_2
XFILLER_0_33_281 vssd1 vssd1 vccd1 vccd1 sky130_fd_sc_hd__fill_1
XFILLER_0_68_27 vssd1 vssd1 vccd1 vccd1 sky130_fd_sc_hd__fill_1
XFILLER_0_0_337 vssd1 vssd1 vccd1 vccd1 sky130_fd_sc_hd__fill_2
XTAP_605 vssd1 vccd1 sky130_fd_sc_hd__tapvpwrvgnd_1
XTAP_616 vssd1 vccd1 sky130_fd_sc_hd__tapvpwrvgnd_1
XTAP_627 vssd1 vccd1 sky130_fd_sc_hd__tapvpwrvgnd_1
XTAP_638 vssd1 vccd1 sky130_fd_sc_hd__tapvpwrvgnd_1
XTAP_649 vssd1 vccd1 sky130_fd_sc_hd__tapvpwrvgnd_1
XFILLER_0_108_55 vssd1 vssd1 vccd1 vccd1 sky130_fd_sc_hd__fill_2
XFILLER_0_17_75 vssd1 vssd1 vccd1 vccd1 sky130_fd_sc_hd__fill_1
X_5910_ _5440_/X _5909_/Y _5922_/S vssd1 vssd1 vccd1 vccd1 _5910_/X sky130_fd_sc_hd__mux2_1
XANTENNA__4791__A _5051_/B vssd1 vssd1 vccd1 vccd1 sky130_fd_sc_hd__diode_2
X_6890_ _6892_/CLK _6890_/D vssd1 vssd1 vccd1 vccd1 hold36/A sky130_fd_sc_hd__dfxtp_1
XFILLER_0_48_307 vssd1 vssd1 vccd1 vccd1 sky130_fd_sc_hd__fill_1
XFILLER_0_75_137 vssd1 vssd1 vccd1 vccd1 sky130_fd_sc_hd__decap_3
X_5841_ _5841_/A _5841_/B vssd1 vssd1 vccd1 vccd1 _5851_/B sky130_fd_sc_hd__and2_1
X_5772_ _5772_/A _5772_/B _5772_/C vssd1 vssd1 vccd1 vccd1 _5774_/A sky130_fd_sc_hd__and3_1
XFILLER_0_16_204 vssd1 vssd1 vccd1 vccd1 sky130_fd_sc_hd__decap_6
XFILLER_0_56_351 vssd1 vssd1 vccd1 vccd1 sky130_fd_sc_hd__fill_2
XFILLER_0_56_373 vssd1 vssd1 vccd1 vccd1 sky130_ef_sc_hd__decap_12
X_4723_ _4723_/A _4723_/B vssd1 vssd1 vccd1 vccd1 _4913_/B sky130_fd_sc_hd__xnor2_1
X_4654_ _4654_/A _4668_/A vssd1 vssd1 vccd1 vccd1 _5366_/A sky130_fd_sc_hd__xnor2_2
XFILLER_0_71_376 vssd1 vssd1 vccd1 vccd1 sky130_ef_sc_hd__decap_12
XANTENNA__5888__A1 _5922_/S vssd1 vssd1 vccd1 vccd1 sky130_fd_sc_hd__diode_2
X_4585_ _4582_/X _4585_/B _5656_/A _4637_/D vssd1 vssd1 vccd1 vccd1 _4594_/A sky130_fd_sc_hd__and4b_1
XFILLER_0_3_142 vssd1 vssd1 vccd1 vccd1 sky130_fd_sc_hd__decap_4
XFILLER_0_3_153 vssd1 vssd1 vccd1 vccd1 sky130_fd_sc_hd__fill_2
X_3605_ _3605_/A _3605_/B _3605_/C vssd1 vssd1 vccd1 vccd1 _3608_/B sky130_fd_sc_hd__nor3_1
XFILLER_0_31_229 vssd1 vssd1 vccd1 vccd1 sky130_fd_sc_hd__decap_6
X_6324_ hold39/X _6328_/A _6224_/B pix_mport_o[64] vssd1 vssd1 vccd1 vccd1 _6804_/D
+ sky130_fd_sc_hd__o2bb2a_1
XFILLER_0_101_106 vssd1 vssd1 vccd1 vccd1 sky130_fd_sc_hd__decap_6
XANTENNA__4031__A _4842_/A vssd1 vssd1 vccd1 vccd1 sky130_fd_sc_hd__diode_2
XANTENNA_fanout103_A _5106_/A vssd1 vssd1 vccd1 vccd1 sky130_fd_sc_hd__diode_2
X_3536_ _3540_/B _3536_/B vssd1 vssd1 vccd1 vccd1 _3544_/A sky130_fd_sc_hd__nand2_1
XFILLER_0_3_175 vssd1 vssd1 vccd1 vccd1 sky130_fd_sc_hd__decap_4
XFILLER_0_24_292 vssd1 vssd1 vccd1 vccd1 sky130_fd_sc_hd__fill_2
X_6255_ _6255_/A _6842_/Q vssd1 vssd1 vccd1 vccd1 _6255_/X sky130_fd_sc_hd__or2_1
XANTENNA__4388__D _4658_/D vssd1 vssd1 vccd1 vccd1 sky130_fd_sc_hd__diode_2
X_3467_ _5320_/A _5296_/B _3466_/C _3466_/D vssd1 vssd1 vccd1 vccd1 _3468_/B sky130_fd_sc_hd__a22oi_1
XANTENNA__4966__A _4966_/A vssd1 vssd1 vccd1 vccd1 sky130_fd_sc_hd__diode_2
X_5206_ _6644_/Q _5206_/B vssd1 vssd1 vccd1 vccd1 _5207_/B sky130_fd_sc_hd__or2_1
X_6186_ _6162_/A _6173_/A _6183_/Y _6184_/X _6207_/B vssd1 vssd1 vccd1 vccd1 _6186_/Y
+ sky130_fd_sc_hd__a41oi_1
X_3398_ _3999_/A _6688_/Q vssd1 vssd1 vccd1 vccd1 _3399_/B sky130_fd_sc_hd__nand2_1
XFILLER_0_58_93 vssd1 vssd1 vccd1 vccd1 sky130_fd_sc_hd__decap_3
X_5137_ _5137_/A _5137_/B vssd1 vssd1 vccd1 vccd1 _5139_/B sky130_fd_sc_hd__xnor2_1
X_5068_ _5068_/A _5068_/B vssd1 vssd1 vccd1 vccd1 _5076_/B sky130_fd_sc_hd__or2_1
XANTENNA__4615__A2 _4614_/C vssd1 vssd1 vccd1 vccd1 sky130_fd_sc_hd__diode_2
XFILLER_0_74_81 vssd1 vssd1 vccd1 vccd1 sky130_fd_sc_hd__decap_3
X_4019_ _5264_/A _5264_/B vssd1 vssd1 vccd1 vccd1 _5336_/A sky130_fd_sc_hd__xnor2_1
XFILLER_0_66_126 vssd1 vssd1 vccd1 vccd1 sky130_fd_sc_hd__fill_1
XFILLER_0_90_80 vssd1 vssd1 vccd1 vccd1 sky130_fd_sc_hd__fill_2
XFILLER_0_81_118 vssd1 vssd1 vccd1 vccd1 sky130_fd_sc_hd__fill_2
XFILLER_0_124_209 vssd1 vssd1 vccd1 vccd1 sky130_fd_sc_hd__fill_2
XANTENNA__5872__B1_N _5591_/X vssd1 vssd1 vccd1 vccd1 sky130_fd_sc_hd__diode_2
XFILLER_0_30_251 vssd1 vssd1 vccd1 vccd1 sky130_fd_sc_hd__fill_1
XFILLER_0_100_172 vssd1 vssd1 vccd1 vccd1 sky130_fd_sc_hd__decap_6
XANTENNA__6056__A1 _6539_/Q vssd1 vssd1 vccd1 vccd1 sky130_fd_sc_hd__diode_2
XFILLER_0_89_229 vssd1 vssd1 vccd1 vccd1 sky130_fd_sc_hd__fill_2
XFILLER_0_89_218 vssd1 vssd1 vccd1 vccd1 sky130_fd_sc_hd__fill_2
XFILLER_0_57_137 vssd1 vssd1 vccd1 vccd1 sky130_fd_sc_hd__fill_1
XFILLER_0_72_107 vssd1 vssd1 vccd1 vccd1 sky130_fd_sc_hd__fill_2
Xhold108 _6659_/Q vssd1 vssd1 vccd1 vccd1 hold108/X sky130_fd_sc_hd__dlygate4sd3_1
XFILLER_0_123_253 vssd1 vssd1 vccd1 vccd1 sky130_fd_sc_hd__fill_1
XFILLER_0_80_195 vssd1 vssd1 vccd1 vccd1 sky130_fd_sc_hd__fill_1
XFILLER_0_13_218 vssd1 vssd1 vccd1 vccd1 sky130_fd_sc_hd__decap_3
Xhold119 _6839_/Q vssd1 vssd1 vccd1 vccd1 hold119/X sky130_fd_sc_hd__dlygate4sd3_1
X_4370_ _4370_/A _4370_/B vssd1 vssd1 vccd1 vccd1 _4418_/A sky130_fd_sc_hd__or2_1
X_3321_ _6840_/Q vssd1 vssd1 vccd1 vccd1 _3321_/Y sky130_fd_sc_hd__inv_2
XFILLER_0_0_145 vssd1 vssd1 vccd1 vccd1 sky130_fd_sc_hd__fill_2
XFILLER_0_21_251 vssd1 vssd1 vccd1 vccd1 sky130_fd_sc_hd__fill_2
XFILLER_0_95_47 vssd1 vssd1 vccd1 vccd1 sky130_fd_sc_hd__fill_2
XTAP_402 vssd1 vccd1 sky130_fd_sc_hd__tapvpwrvgnd_1
XTAP_413 vssd1 vccd1 sky130_fd_sc_hd__tapvpwrvgnd_1
XTAP_424 vssd1 vccd1 sky130_fd_sc_hd__tapvpwrvgnd_1
X_3252_ _5656_/A vssd1 vssd1 vccd1 vccd1 _3252_/Y sky130_fd_sc_hd__inv_2
X_6040_ _5277_/A _6038_/B _6038_/Y vssd1 vssd1 vccd1 vccd1 _6679_/D sky130_fd_sc_hd__a21o_1
XTAP_435 vssd1 vccd1 sky130_fd_sc_hd__tapvpwrvgnd_1
XTAP_446 vssd1 vccd1 sky130_fd_sc_hd__tapvpwrvgnd_1
XTAP_457 vssd1 vccd1 sky130_fd_sc_hd__tapvpwrvgnd_1
XTAP_468 vssd1 vccd1 sky130_fd_sc_hd__tapvpwrvgnd_1
XTAP_479 vssd1 vccd1 sky130_fd_sc_hd__tapvpwrvgnd_1
XFILLER_0_28_85 vssd1 vssd1 vccd1 vccd1 sky130_fd_sc_hd__decap_3
X_6942_ vssd1 vssd1 vccd1 vccd1 _6942_/HI pix_mport_o[62] sky130_fd_sc_hd__conb_1
XFILLER_0_88_251 vssd1 vssd1 vccd1 vccd1 sky130_fd_sc_hd__fill_1
XFILLER_0_88_240 vssd1 vssd1 vccd1 vccd1 sky130_fd_sc_hd__fill_2
XFILLER_0_76_402 vssd1 vssd1 vccd1 vccd1 sky130_fd_sc_hd__decap_4
X_6873_ _6892_/CLK _6873_/D vssd1 vssd1 vccd1 vccd1 _6873_/Q sky130_fd_sc_hd__dfxtp_1
XANTENNA__5558__B1 _5557_/X vssd1 vssd1 vccd1 vccd1 sky130_fd_sc_hd__diode_2
XANTENNA__4026__A _4614_/C vssd1 vssd1 vccd1 vccd1 sky130_fd_sc_hd__diode_2
X_5824_ _5824_/A _5824_/B vssd1 vssd1 vccd1 vccd1 _5837_/B sky130_fd_sc_hd__or2_1
XFILLER_0_91_405 vssd1 vssd1 vccd1 vccd1 sky130_fd_sc_hd__fill_2
X_5755_ _5755_/A _5766_/B vssd1 vssd1 vccd1 vccd1 _5755_/Y sky130_fd_sc_hd__nand2_1
XFILLER_0_56_170 vssd1 vssd1 vccd1 vccd1 sky130_fd_sc_hd__decap_3
XFILLER_0_97_3 vssd1 vssd1 vccd1 vccd1 sky130_fd_sc_hd__fill_1
X_4706_ _4418_/C _4419_/X _4458_/Y _4460_/Y vssd1 vssd1 vccd1 vccd1 _4707_/B sky130_fd_sc_hd__a211oi_1
X_5686_ hold210/X _5685_/X _5844_/S vssd1 vssd1 vccd1 vccd1 _6625_/D sky130_fd_sc_hd__mux2_1
X_4637_ _5645_/A _5645_/B _4658_/D _4637_/D vssd1 vssd1 vccd1 vccd1 _4637_/X sky130_fd_sc_hd__and4_1
XFILLER_0_44_398 vssd1 vssd1 vccd1 vccd1 sky130_fd_sc_hd__decap_8
X_4568_ _4568_/A _4568_/B _4568_/C _4568_/D vssd1 vssd1 vccd1 vccd1 _4571_/B sky130_fd_sc_hd__or4_2
XFILLER_0_69_92 vssd1 vssd1 vccd1 vccd1 sky130_fd_sc_hd__decap_3
X_6307_ hold22/X hold9/X _6319_/S vssd1 vssd1 vccd1 vccd1 _6790_/D sky130_fd_sc_hd__mux2_1
X_4499_ _4498_/A _4498_/Y _4457_/Y _4463_/X vssd1 vssd1 vccd1 vccd1 _4500_/A sky130_fd_sc_hd__o211a_1
X_3519_ _5277_/A _5300_/A vssd1 vssd1 vccd1 vccd1 _3520_/B sky130_fd_sc_hd__nand2_1
X_6238_ _3308_/Y _6851_/Q _3310_/Y _6850_/Q _6237_/X vssd1 vssd1 vccd1 vccd1 _6238_/X
+ sky130_fd_sc_hd__o221a_1
X_6169_ _6157_/A _6159_/B _6157_/B vssd1 vssd1 vccd1 vccd1 _6170_/B sky130_fd_sc_hd__a21boi_1
XTAP_980 vssd1 vccd1 sky130_fd_sc_hd__tapvpwrvgnd_1
XTAP_991 vssd1 vccd1 sky130_fd_sc_hd__tapvpwrvgnd_1
XANTENNA__6647__SET_B _5937_/A vssd1 vssd1 vccd1 vccd1 sky130_fd_sc_hd__diode_2
XANTENNA__5320__A _5320_/A vssd1 vssd1 vccd1 vccd1 sky130_fd_sc_hd__diode_2
XFILLER_0_79_273 vssd1 vssd1 vccd1 vccd1 sky130_fd_sc_hd__fill_1
XFILLER_0_39_104 vssd1 vssd1 vccd1 vccd1 sky130_fd_sc_hd__fill_2
XFILLER_0_39_137 vssd1 vssd1 vccd1 vccd1 sky130_fd_sc_hd__fill_2
XANTENNA__3494__B _5273_/A vssd1 vssd1 vccd1 vccd1 sky130_fd_sc_hd__diode_2
XFILLER_0_62_173 vssd1 vssd1 vccd1 vccd1 sky130_fd_sc_hd__fill_1
XFILLER_0_62_184 vssd1 vssd1 vccd1 vccd1 sky130_fd_sc_hd__fill_2
XFILLER_0_65_39 vssd1 vssd1 vccd1 vccd1 sky130_fd_sc_hd__decap_3
XFILLER_0_85_210 vssd1 vssd1 vccd1 vccd1 sky130_fd_sc_hd__decap_4
XFILLER_0_85_287 vssd1 vssd1 vccd1 vccd1 sky130_fd_sc_hd__fill_2
XFILLER_0_85_254 vssd1 vssd1 vccd1 vccd1 sky130_fd_sc_hd__fill_2
XFILLER_0_73_405 vssd1 vssd1 vccd1 vccd1 sky130_fd_sc_hd__fill_2
XFILLER_0_14_76 vssd1 vssd1 vccd1 vccd1 sky130_fd_sc_hd__fill_2
XFILLER_0_14_65 vssd1 vssd1 vccd1 vccd1 sky130_fd_sc_hd__decap_4
X_3870_ _3870_/A _5083_/B _3870_/C _3870_/D vssd1 vssd1 vccd1 vccd1 _3870_/X sky130_fd_sc_hd__and4_1
X_5540_ depth_mport_o[15] hold158/X _5556_/S vssd1 vssd1 vccd1 vccd1 _6571_/D sky130_fd_sc_hd__mux2_1
XFILLER_0_26_365 vssd1 vssd1 vccd1 vccd1 sky130_fd_sc_hd__decap_6
XFILLER_0_30_20 vssd1 vssd1 vccd1 vccd1 sky130_fd_sc_hd__fill_2
X_5471_ hold28/X sstream_i[62] _6486_/S vssd1 vssd1 vccd1 vccd1 _6504_/D sky130_fd_sc_hd__mux2_1
XFILLER_0_5_248 vssd1 vssd1 vccd1 vccd1 sky130_fd_sc_hd__fill_1
XFILLER_0_41_302 vssd1 vssd1 vccd1 vccd1 sky130_fd_sc_hd__fill_2
XFILLER_0_53_184 vssd1 vssd1 vccd1 vccd1 sky130_fd_sc_hd__fill_2
X_4422_ _4422_/A _4422_/B vssd1 vssd1 vccd1 vccd1 _4423_/B sky130_fd_sc_hd__nor2_1
XFILLER_0_111_223 vssd1 vssd1 vccd1 vccd1 sky130_fd_sc_hd__fill_1
XFILLER_0_111_212 vssd1 vssd1 vccd1 vccd1 sky130_fd_sc_hd__fill_1
X_4353_ _4342_/A _4342_/C _4342_/B vssd1 vssd1 vccd1 vccd1 _4357_/A sky130_fd_sc_hd__a21bo_1
X_3304_ depth_mport_i[22] vssd1 vssd1 vccd1 vccd1 _3304_/Y sky130_fd_sc_hd__inv_2
X_4284_ _4283_/B _4283_/C _4283_/A vssd1 vssd1 vccd1 vccd1 _4287_/C sky130_fd_sc_hd__a21o_1
X_6023_ _5945_/B _6038_/C _6022_/X vssd1 vssd1 vccd1 vccd1 _6023_/Y sky130_fd_sc_hd__a21oi_1
XTAP_287 vssd1 vccd1 sky130_fd_sc_hd__tapvpwrvgnd_1
XTAP_298 vssd1 vccd1 sky130_fd_sc_hd__tapvpwrvgnd_1
Xclkbuf_leaf_14_clk_i clkbuf_2_3__f_clk_i/X vssd1 vssd1 vccd1 vccd1 _6830_/CLK sky130_fd_sc_hd__clkbuf_16
X_6925_ vssd1 vssd1 vccd1 vccd1 _6925_/HI pix_mport_o[26] sky130_fd_sc_hd__conb_1
XFILLER_0_12_3 vssd1 vssd1 vccd1 vccd1 sky130_ef_sc_hd__decap_12
Xfanout14 _6465_/S vssd1 vssd1 vccd1 vccd1 _6464_/S sky130_fd_sc_hd__clkbuf_8
Xfanout25 _6115_/Y vssd1 vssd1 vccd1 vccd1 _6223_/B sky130_fd_sc_hd__buf_4
X_6856_ _6862_/CLK _6856_/D vssd1 vssd1 vccd1 vccd1 _6856_/Q sky130_fd_sc_hd__dfxtp_1
XFILLER_0_91_202 vssd1 vssd1 vccd1 vccd1 sky130_fd_sc_hd__decap_4
Xfanout47 _4944_/B vssd1 vssd1 vccd1 vccd1 _3870_/A sky130_fd_sc_hd__buf_4
Xfanout36 _6685_/Q vssd1 vssd1 vccd1 vccd1 _5276_/B sky130_fd_sc_hd__buf_4
XFILLER_0_36_118 vssd1 vssd1 vccd1 vccd1 sky130_fd_sc_hd__fill_1
X_6787_ _6802_/CLK hold81/X vssd1 vssd1 vccd1 vccd1 _6787_/Q sky130_fd_sc_hd__dfxtp_1
XFILLER_0_91_235 vssd1 vssd1 vccd1 vccd1 sky130_fd_sc_hd__fill_2
Xfanout69 _4971_/B vssd1 vssd1 vccd1 vccd1 _4582_/D sky130_fd_sc_hd__buf_4
X_5807_ _5812_/A _5807_/B vssd1 vssd1 vccd1 vccd1 _5808_/B sky130_fd_sc_hd__nor2_1
Xfanout58 _6672_/Q vssd1 vssd1 vccd1 vccd1 _4776_/A sky130_fd_sc_hd__clkbuf_8
X_3999_ _3999_/A _6682_/Q vssd1 vssd1 vccd1 vccd1 _4001_/B sky130_fd_sc_hd__nand2_1
XFILLER_0_91_268 vssd1 vssd1 vccd1 vccd1 sky130_fd_sc_hd__decap_4
X_5738_ _5738_/A _5738_/B vssd1 vssd1 vccd1 vccd1 _5740_/A sky130_fd_sc_hd__nor2_1
XANTENNA__3595__A _5081_/A vssd1 vssd1 vccd1 vccd1 sky130_fd_sc_hd__diode_2
XFILLER_0_134_359 vssd1 vssd1 vccd1 vccd1 sky130_fd_sc_hd__decap_4
X_5669_ tex_addr_i[3] _5670_/B vssd1 vssd1 vccd1 vccd1 _5671_/A sky130_fd_sc_hd__nand2_1
XANTENNA__3493__A1 _5320_/A vssd1 vssd1 vccd1 vccd1 sky130_fd_sc_hd__diode_2
XFILLER_0_99_368 vssd1 vssd1 vccd1 vccd1 sky130_ef_sc_hd__decap_12
XFILLER_0_67_221 vssd1 vssd1 vccd1 vccd1 sky130_fd_sc_hd__decap_3
XFILLER_0_27_107 vssd1 vssd1 vccd1 vccd1 sky130_fd_sc_hd__fill_2
XFILLER_0_55_405 vssd1 vssd1 vccd1 vccd1 sky130_fd_sc_hd__fill_2
XFILLER_0_137_164 vssd1 vssd1 vccd1 vccd1 sky130_fd_sc_hd__fill_1
XFILLER_0_82_213 vssd1 vssd1 vccd1 vccd1 sky130_fd_sc_hd__decap_4
XFILLER_0_125_337 vssd1 vssd1 vccd1 vccd1 sky130_fd_sc_hd__decap_3
XFILLER_0_82_279 vssd1 vssd1 vccd1 vccd1 sky130_fd_sc_hd__fill_1
XFILLER_0_125_348 vssd1 vssd1 vccd1 vccd1 sky130_fd_sc_hd__fill_1
XFILLER_0_50_110 vssd1 vssd1 vccd1 vccd1 sky130_fd_sc_hd__fill_1
XFILLER_0_76_38 vssd1 vssd1 vccd1 vccd1 sky130_fd_sc_hd__fill_2
XANTENNA__4681__B1 _4658_/D vssd1 vssd1 vccd1 vccd1 sky130_fd_sc_hd__diode_2
XFILLER_0_25_53 vssd1 vssd1 vccd1 vccd1 sky130_fd_sc_hd__decap_3
X_4971_ _5801_/A _4971_/B _5787_/A _4971_/D vssd1 vssd1 vccd1 vccd1 _4973_/B sky130_fd_sc_hd__nand4_1
XFILLER_0_58_232 vssd1 vssd1 vccd1 vccd1 sky130_fd_sc_hd__fill_2
X_6710_ _6818_/CLK _6710_/D vssd1 vssd1 vccd1 vccd1 hold1/A sky130_fd_sc_hd__dfxtp_1
X_3922_ _3923_/A _3923_/B _3923_/C vssd1 vssd1 vccd1 vccd1 _3922_/Y sky130_fd_sc_hd__nor3_1
XFILLER_0_58_265 vssd1 vssd1 vccd1 vccd1 sky130_fd_sc_hd__decap_3
X_3853_ _3854_/A _3854_/B _3854_/C vssd1 vssd1 vccd1 vccd1 _3853_/Y sky130_fd_sc_hd__nor3_1
XFILLER_0_41_41 vssd1 vssd1 vccd1 vccd1 sky130_fd_sc_hd__fill_2
X_6641_ _6745_/CLK _6641_/D fanout139/X vssd1 vssd1 vccd1 vccd1 _6641_/Q sky130_fd_sc_hd__dfstp_1
XFILLER_0_132_65 vssd1 vssd1 vccd1 vccd1 sky130_fd_sc_hd__fill_2
XFILLER_0_116_326 vssd1 vssd1 vccd1 vccd1 sky130_fd_sc_hd__fill_1
XFILLER_0_116_304 vssd1 vssd1 vccd1 vccd1 sky130_fd_sc_hd__fill_1
X_6572_ _6812_/CLK _6572_/D _6320_/C vssd1 vssd1 vccd1 vccd1 depth_mport_o[16] sky130_fd_sc_hd__dfrtp_4
X_3784_ _5300_/A _5118_/B _3711_/A _3710_/D vssd1 vssd1 vccd1 vccd1 _3791_/B sky130_fd_sc_hd__a22o_1
XFILLER_0_26_162 vssd1 vssd1 vccd1 vccd1 sky130_fd_sc_hd__fill_1
XFILLER_0_131_307 vssd1 vssd1 vccd1 vccd1 sky130_fd_sc_hd__fill_2
X_5523_ _6784_/Q _6783_/Q vssd1 vssd1 vccd1 vccd1 _5524_/B sky130_fd_sc_hd__nand2b_1
XANTENNA__5834__S _5922_/S vssd1 vssd1 vccd1 vccd1 sky130_fd_sc_hd__diode_2
XFILLER_0_14_379 vssd1 vssd1 vccd1 vccd1 sky130_fd_sc_hd__decap_6
X_5454_ _5454_/A _5454_/B vssd1 vssd1 vccd1 vccd1 _5599_/B sky130_fd_sc_hd__xor2_1
XANTENNA__4958__B _4958_/B vssd1 vssd1 vccd1 vccd1 sky130_fd_sc_hd__diode_2
XFILLER_0_41_143 vssd1 vssd1 vccd1 vccd1 sky130_fd_sc_hd__fill_1
X_5385_ _6727_/Q _5385_/B vssd1 vssd1 vccd1 vccd1 _5387_/C sky130_fd_sc_hd__xnor2_1
X_4405_ _4405_/A _4451_/A vssd1 vssd1 vccd1 vccd1 _4412_/A sky130_fd_sc_hd__nand2_1
XFILLER_0_41_198 vssd1 vssd1 vccd1 vccd1 sky130_fd_sc_hd__fill_2
X_4336_ _4330_/A _4330_/B _4330_/C vssd1 vssd1 vccd1 vccd1 _4337_/C sky130_fd_sc_hd__a21o_1
XFILLER_0_22_390 vssd1 vssd1 vccd1 vccd1 sky130_ef_sc_hd__decap_12
X_4267_ _5687_/B _4518_/D vssd1 vssd1 vccd1 vccd1 _4269_/B sky130_fd_sc_hd__and2_1
X_4198_ _4971_/B _4822_/B _4171_/X _4172_/Y vssd1 vssd1 vccd1 vccd1 _4199_/B sky130_fd_sc_hd__o2bb2a_1
X_6006_ _5115_/C _6005_/X _6037_/S vssd1 vssd1 vccd1 vccd1 _6670_/D sky130_fd_sc_hd__mux2_1
XTAP_1239 vssd1 vccd1 sky130_fd_sc_hd__tapvpwrvgnd_1
XTAP_1228 vssd1 vccd1 sky130_fd_sc_hd__tapvpwrvgnd_1
XTAP_1217 vssd1 vccd1 sky130_fd_sc_hd__tapvpwrvgnd_1
XTAP_1206 vssd1 vccd1 sky130_fd_sc_hd__tapvpwrvgnd_1
XFILLER_0_89_390 vssd1 vssd1 vccd1 vccd1 sky130_fd_sc_hd__fill_2
XFILLER_0_82_81 vssd1 vssd1 vccd1 vccd1 sky130_fd_sc_hd__decap_3
XFILLER_0_82_70 vssd1 vssd1 vccd1 vccd1 sky130_fd_sc_hd__fill_2
XFILLER_0_49_232 vssd1 vssd1 vccd1 vccd1 sky130_fd_sc_hd__decap_3
X_6908_ vssd1 vssd1 vccd1 vccd1 _6908_/HI pix_mport_o[9] sky130_fd_sc_hd__conb_1
XFILLER_0_37_405 vssd1 vssd1 vccd1 vccd1 sky130_fd_sc_hd__fill_2
XFILLER_0_49_254 vssd1 vssd1 vccd1 vccd1 sky130_fd_sc_hd__decap_3
XFILLER_0_119_142 vssd1 vssd1 vccd1 vccd1 sky130_fd_sc_hd__fill_2
XFILLER_0_119_131 vssd1 vssd1 vccd1 vccd1 sky130_fd_sc_hd__fill_2
X_6839_ _6855_/CLK _6839_/D vssd1 vssd1 vccd1 vccd1 _6839_/Q sky130_fd_sc_hd__dfxtp_1
XFILLER_0_64_235 vssd1 vssd1 vccd1 vccd1 sky130_fd_sc_hd__fill_2
XFILLER_0_107_315 vssd1 vssd1 vccd1 vccd1 sky130_fd_sc_hd__fill_2
XANTENNA__4727__A1 _4476_/D vssd1 vssd1 vccd1 vccd1 sky130_fd_sc_hd__diode_2
XANTENNA__4727__B2 _5115_/C vssd1 vssd1 vccd1 vccd1 sky130_fd_sc_hd__diode_2
XFILLER_0_134_178 vssd1 vssd1 vccd1 vccd1 sky130_fd_sc_hd__decap_8
XFILLER_0_32_132 vssd1 vssd1 vccd1 vccd1 sky130_fd_sc_hd__fill_2
Xhold280 _6637_/Q vssd1 vssd1 vccd1 vccd1 hold280/X sky130_fd_sc_hd__dlygate4sd3_1
XFILLER_0_1_3 vssd1 vssd1 vccd1 vccd1 sky130_ef_sc_hd__decap_12
Xhold291 _6665_/Q vssd1 vssd1 vccd1 vccd1 hold291/X sky130_fd_sc_hd__dlygate4sd3_1
XFILLER_0_99_176 vssd1 vssd1 vccd1 vccd1 sky130_fd_sc_hd__decap_4
XANTENNA_120 tex_addr_i[10] vssd1 vssd1 vccd1 vccd1 sky130_fd_sc_hd__diode_2
XANTENNA_142 tex_height_i[6] vssd1 vssd1 vccd1 vccd1 sky130_fd_sc_hd__diode_2
XANTENNA_131 tex_addr_i[15] vssd1 vssd1 vccd1 vccd1 sky130_fd_sc_hd__diode_2
XANTENNA_153 sstream_i[22] vssd1 vssd1 vccd1 vccd1 sky130_fd_sc_hd__diode_2
XFILLER_0_95_393 vssd1 vssd1 vccd1 vccd1 sky130_ef_sc_hd__decap_12
XFILLER_0_55_235 vssd1 vssd1 vccd1 vccd1 sky130_fd_sc_hd__decap_4
XANTENNA__4718__A1 _4736_/B vssd1 vssd1 vccd1 vccd1 sky130_fd_sc_hd__diode_2
XANTENNA__4718__B2 _4944_/B vssd1 vssd1 vccd1 vccd1 sky130_fd_sc_hd__diode_2
XFILLER_0_125_167 vssd1 vssd1 vccd1 vccd1 sky130_fd_sc_hd__fill_1
XFILLER_0_11_55 vssd1 vssd1 vccd1 vccd1 sky130_fd_sc_hd__fill_1
XFILLER_0_87_15 vssd1 vssd1 vccd1 vccd1 sky130_fd_sc_hd__fill_2
XFILLER_0_11_349 vssd1 vssd1 vccd1 vccd1 sky130_fd_sc_hd__fill_1
XFILLER_0_23_187 vssd1 vssd1 vccd1 vccd1 sky130_fd_sc_hd__fill_2
XANTENNA__4778__B _4971_/D vssd1 vssd1 vccd1 vccd1 sky130_fd_sc_hd__diode_2
XFILLER_0_121_362 vssd1 vssd1 vccd1 vccd1 sky130_fd_sc_hd__fill_1
X_5170_ _5061_/A _5061_/C _5061_/B vssd1 vssd1 vccd1 vccd1 _5173_/C sky130_fd_sc_hd__a21oi_1
X_4121_ _4121_/A _4121_/B _4121_/C vssd1 vssd1 vccd1 vccd1 _4124_/A sky130_fd_sc_hd__and3_1
XANTENNA__4794__A _4942_/A vssd1 vssd1 vccd1 vccd1 sky130_fd_sc_hd__diode_2
X_4052_ _4052_/A _4052_/B _4052_/C vssd1 vssd1 vccd1 vccd1 _4065_/A sky130_fd_sc_hd__nand3_1
XFILLER_0_36_52 vssd1 vssd1 vccd1 vccd1 sky130_fd_sc_hd__fill_2
XFILLER_0_78_305 vssd1 vssd1 vccd1 vccd1 sky130_fd_sc_hd__decap_3
XFILLER_0_36_85 vssd1 vssd1 vccd1 vccd1 sky130_fd_sc_hd__fill_1
XFILLER_0_19_405 vssd1 vssd1 vccd1 vccd1 sky130_fd_sc_hd__fill_2
XANTENNA__4957__B2 _4966_/C vssd1 vssd1 vccd1 vccd1 sky130_fd_sc_hd__diode_2
XANTENNA__4957__A1 _5115_/C vssd1 vssd1 vccd1 vccd1 sky130_fd_sc_hd__diode_2
X_4954_ _5191_/A _4952_/X _4799_/X _4804_/B vssd1 vssd1 vccd1 vccd1 _4955_/B sky130_fd_sc_hd__a211o_1
X_3905_ _3838_/A _3838_/B _3846_/B _3838_/D vssd1 vssd1 vccd1 vccd1 _3905_/X sky130_fd_sc_hd__a22o_1
X_4885_ _4868_/X _4881_/Y _4880_/Y _4880_/A vssd1 vssd1 vccd1 vccd1 _4886_/C sky130_fd_sc_hd__o211a_1
X_6624_ _6841_/CLK _6624_/D fanout145/X vssd1 vssd1 vccd1 vccd1 _6624_/Q sky130_fd_sc_hd__dfstp_1
X_3836_ _3824_/X _3832_/Y _3846_/A _3835_/X vssd1 vssd1 vccd1 vccd1 _3846_/B sky130_fd_sc_hd__o211ai_4
X_6555_ _6864_/CLK _6555_/D vssd1 vssd1 vccd1 vccd1 _6555_/Q sky130_fd_sc_hd__dfxtp_1
X_3767_ _6648_/Q _3767_/B vssd1 vssd1 vccd1 vccd1 _3768_/B sky130_fd_sc_hd__or2_1
XFILLER_0_61_238 vssd1 vssd1 vccd1 vccd1 sky130_fd_sc_hd__fill_2
XFILLER_0_131_126 vssd1 vssd1 vccd1 vccd1 sky130_fd_sc_hd__fill_1
X_5506_ hold195/X sstream_i[97] _6464_/S vssd1 vssd1 vccd1 vccd1 _6539_/D sky130_fd_sc_hd__mux2_1
XFILLER_0_14_165 vssd1 vssd1 vccd1 vccd1 sky130_fd_sc_hd__fill_2
XFILLER_0_14_176 vssd1 vssd1 vccd1 vccd1 sky130_fd_sc_hd__fill_2
X_3698_ _3698_/A _3698_/B vssd1 vssd1 vccd1 vccd1 _3700_/B sky130_fd_sc_hd__nor2_1
X_6486_ hold218/X sstream_i[44] _6486_/S vssd1 vssd1 vccd1 vccd1 _6877_/D sky130_fd_sc_hd__mux2_1
XFILLER_0_112_384 vssd1 vssd1 vccd1 vccd1 sky130_ef_sc_hd__decap_12
XFILLER_0_112_362 vssd1 vssd1 vccd1 vccd1 sky130_fd_sc_hd__fill_2
X_5437_ _5437_/A _5437_/B vssd1 vssd1 vccd1 vccd1 _5438_/C sky130_fd_sc_hd__nor2_1
X_5368_ _5368_/A _5368_/B vssd1 vssd1 vccd1 vccd1 _5567_/B sky130_fd_sc_hd__xnor2_2
X_4319_ _4320_/A _4320_/B vssd1 vssd1 vccd1 vccd1 _4340_/B sky130_fd_sc_hd__and2_1
X_5299_ _5299_/A _6691_/Q vssd1 vssd1 vccd1 vccd1 _5301_/A sky130_fd_sc_hd__nand2_1
XTAP_1003 vssd1 vccd1 sky130_fd_sc_hd__tapvpwrvgnd_1
XANTENNA_fanout46_A _6678_/Q vssd1 vssd1 vccd1 vccd1 sky130_fd_sc_hd__diode_2
XTAP_1047 vssd1 vccd1 sky130_fd_sc_hd__tapvpwrvgnd_1
XTAP_1036 vssd1 vccd1 sky130_fd_sc_hd__tapvpwrvgnd_1
XTAP_1025 vssd1 vccd1 sky130_fd_sc_hd__tapvpwrvgnd_1
XTAP_1014 vssd1 vccd1 sky130_fd_sc_hd__tapvpwrvgnd_1
XTAP_1069 vssd1 vccd1 sky130_fd_sc_hd__tapvpwrvgnd_1
XTAP_1058 vssd1 vccd1 sky130_fd_sc_hd__tapvpwrvgnd_1
XFILLER_0_77_393 vssd1 vssd1 vccd1 vccd1 sky130_ef_sc_hd__decap_12
XFILLER_0_37_268 vssd1 vssd1 vccd1 vccd1 sky130_fd_sc_hd__fill_1
XTAP_809 vssd1 vccd1 sky130_fd_sc_hd__tapvpwrvgnd_1
XANTENNA__4100__A2 _5718_/B vssd1 vssd1 vccd1 vccd1 sky130_fd_sc_hd__diode_2
XFILLER_0_87_146 vssd1 vssd1 vccd1 vccd1 sky130_fd_sc_hd__fill_2
XANTENNA__4939__A1 _5064_/B vssd1 vssd1 vccd1 vccd1 sky130_fd_sc_hd__diode_2
XFILLER_0_68_393 vssd1 vssd1 vccd1 vccd1 sky130_ef_sc_hd__decap_12
XFILLER_0_28_202 vssd1 vssd1 vccd1 vccd1 sky130_fd_sc_hd__fill_2
XFILLER_0_28_224 vssd1 vssd1 vccd1 vccd1 sky130_fd_sc_hd__fill_1
XFILLER_0_113_34 vssd1 vssd1 vccd1 vccd1 sky130_fd_sc_hd__decap_3
XFILLER_0_138_281 vssd1 vssd1 vccd1 vccd1 sky130_fd_sc_hd__fill_2
XFILLER_0_113_89 vssd1 vssd1 vccd1 vccd1 sky130_fd_sc_hd__fill_2
X_4670_ _4670_/A _4670_/B _4668_/X vssd1 vssd1 vccd1 vccd1 _4671_/B sky130_fd_sc_hd__or3b_1
XFILLER_0_83_363 vssd1 vssd1 vccd1 vccd1 sky130_ef_sc_hd__decap_12
XFILLER_0_28_268 vssd1 vssd1 vccd1 vccd1 sky130_fd_sc_hd__fill_2
XFILLER_0_118_3 vssd1 vssd1 vccd1 vccd1 sky130_fd_sc_hd__decap_3
XFILLER_0_113_104 vssd1 vssd1 vccd1 vccd1 sky130_fd_sc_hd__fill_2
X_3621_ _3621_/A _3621_/B vssd1 vssd1 vccd1 vccd1 _3622_/B sky130_fd_sc_hd__and2_1
XANTENNA__4789__A _5071_/A vssd1 vssd1 vccd1 vccd1 sky130_fd_sc_hd__diode_2
X_6340_ hold75/X _6340_/B _6340_/C _6350_/A vssd1 vssd1 vccd1 vccd1 _6350_/B sky130_fd_sc_hd__nand4_1
XFILLER_0_113_137 vssd1 vssd1 vccd1 vccd1 sky130_fd_sc_hd__fill_2
X_3552_ _3552_/A _3552_/B vssd1 vssd1 vccd1 vccd1 _3565_/A sky130_fd_sc_hd__xor2_1
XFILLER_0_113_159 vssd1 vssd1 vccd1 vccd1 sky130_fd_sc_hd__fill_2
XFILLER_0_113_148 vssd1 vssd1 vccd1 vccd1 sky130_fd_sc_hd__decap_3
XFILLER_0_11_113 vssd1 vssd1 vccd1 vccd1 sky130_fd_sc_hd__fill_2
X_6271_ _6247_/X _6270_/X _6244_/X _6245_/X vssd1 vssd1 vccd1 vccd1 _6271_/X sky130_fd_sc_hd__o2bb2a_1
XFILLER_0_11_146 vssd1 vssd1 vccd1 vccd1 sky130_fd_sc_hd__fill_1
X_3483_ _3483_/A _3483_/B vssd1 vssd1 vccd1 vccd1 _3484_/B sky130_fd_sc_hd__or2_1
XANTENNA__5116__A1 _5766_/A vssd1 vssd1 vccd1 vccd1 sky130_fd_sc_hd__diode_2
X_5222_ _5252_/B _5220_/X _5179_/Y _5183_/A vssd1 vssd1 vccd1 vccd1 _5223_/B sky130_fd_sc_hd__o211a_1
XANTENNA__6817__RESET_B fanout153/X vssd1 vssd1 vccd1 vccd1 sky130_fd_sc_hd__diode_2
X_5153_ _5153_/A _5153_/B _5153_/C vssd1 vssd1 vccd1 vccd1 _5156_/A sky130_fd_sc_hd__and3_2
X_4104_ _4104_/A _4104_/B _4104_/C vssd1 vssd1 vccd1 vccd1 _4222_/A sky130_fd_sc_hd__nand3_1
X_5084_ _6675_/Q _5083_/B _5122_/A _5083_/D vssd1 vssd1 vccd1 vccd1 _5085_/C sky130_fd_sc_hd__a22o_1
X_4035_ _4971_/B _5718_/B _4033_/X _4031_/X _5718_/A vssd1 vssd1 vccd1 vccd1 _4037_/B
+ sky130_fd_sc_hd__a32o_1
XFILLER_0_2_53 vssd1 vssd1 vccd1 vccd1 sky130_ef_sc_hd__decap_12
XANTENNA__4971__B _4971_/B vssd1 vssd1 vccd1 vccd1 sky130_fd_sc_hd__diode_2
XANTENNA__3648__A1_N _5083_/B vssd1 vssd1 vccd1 vccd1 sky130_fd_sc_hd__diode_2
XFILLER_0_2_97 vssd1 vssd1 vccd1 vccd1 sky130_ef_sc_hd__decap_12
X_5986_ tex_height_i[4] _5987_/B vssd1 vssd1 vccd1 vccd1 _5994_/C sky130_fd_sc_hd__or2_2
XPHY_108 vssd1 vssd1 vccd1 vccd1 sky130_fd_sc_hd__decap_3
XPHY_119 vssd1 vssd1 vccd1 vccd1 sky130_fd_sc_hd__decap_3
XFILLER_0_136_207 vssd1 vssd1 vccd1 vccd1 sky130_fd_sc_hd__fill_2
XFILLER_0_19_235 vssd1 vssd1 vccd1 vccd1 sky130_fd_sc_hd__decap_6
X_4937_ _5091_/B _5064_/B _5273_/B _5091_/A vssd1 vssd1 vccd1 vccd1 _4937_/X sky130_fd_sc_hd__a22o_1
XFILLER_0_59_393 vssd1 vssd1 vccd1 vccd1 sky130_ef_sc_hd__decap_12
XFILLER_0_129_281 vssd1 vssd1 vccd1 vccd1 sky130_fd_sc_hd__decap_3
XANTENNA_31 sstream_i[13] vssd1 vssd1 vccd1 vccd1 sky130_fd_sc_hd__diode_2
XANTENNA_20 sstream_i[12] vssd1 vssd1 vccd1 vccd1 sky130_fd_sc_hd__diode_2
XFILLER_0_74_363 vssd1 vssd1 vccd1 vccd1 sky130_fd_sc_hd__fill_1
XFILLER_0_34_216 vssd1 vssd1 vccd1 vccd1 sky130_fd_sc_hd__decap_8
X_4868_ _4869_/A _4869_/B _4869_/C vssd1 vssd1 vccd1 vccd1 _4868_/X sky130_fd_sc_hd__and3_1
XANTENNA_42 sstream_i[15] vssd1 vssd1 vccd1 vccd1 sky130_fd_sc_hd__diode_2
XANTENNA_53 sstream_i[17] vssd1 vssd1 vccd1 vccd1 sky130_fd_sc_hd__diode_2
XANTENNA_64 sstream_i[21] vssd1 vssd1 vccd1 vccd1 sky130_fd_sc_hd__diode_2
X_6607_ _6830_/CLK _6607_/D fanout153/X vssd1 vssd1 vccd1 vccd1 tex_mport_o[50] sky130_fd_sc_hd__dfrtp_4
XANTENNA_75 sstream_i[27] vssd1 vssd1 vccd1 vccd1 sky130_fd_sc_hd__diode_2
X_3819_ _5306_/A _5049_/B _5071_/A _5064_/B vssd1 vssd1 vccd1 vccd1 _3819_/X sky130_fd_sc_hd__and4_1
XANTENNA_86 sstream_i[31] vssd1 vssd1 vccd1 vccd1 sky130_fd_sc_hd__diode_2
XANTENNA_97 sstream_i[5] vssd1 vssd1 vccd1 vccd1 sky130_fd_sc_hd__diode_2
X_4799_ _4800_/A _4800_/B _4800_/C vssd1 vssd1 vccd1 vccd1 _4799_/X sky130_fd_sc_hd__and3_1
X_6538_ _6855_/CLK _6538_/D vssd1 vssd1 vccd1 vccd1 hold75/A sky130_fd_sc_hd__dfxtp_2
XFILLER_0_42_260 vssd1 vssd1 vccd1 vccd1 sky130_fd_sc_hd__decap_4
X_6469_ hold174/X sstream_i[27] _6472_/S vssd1 vssd1 vccd1 vccd1 _6860_/D sky130_fd_sc_hd__mux2_1
XFILLER_0_100_365 vssd1 vssd1 vccd1 vccd1 sky130_ef_sc_hd__decap_12
XANTENNA__4094__A1 _4966_/A vssd1 vssd1 vccd1 vccd1 sky130_fd_sc_hd__diode_2
XANTENNA__4094__B2 _4966_/C vssd1 vssd1 vccd1 vccd1 sky130_fd_sc_hd__diode_2
XFILLER_0_69_113 vssd1 vssd1 vccd1 vccd1 sky130_fd_sc_hd__fill_2
XFILLER_0_69_157 vssd1 vssd1 vccd1 vccd1 sky130_fd_sc_hd__fill_2
XANTENNA__3497__B _5273_/B vssd1 vssd1 vccd1 vccd1 sky130_fd_sc_hd__diode_2
XFILLER_0_92_193 vssd1 vssd1 vccd1 vccd1 sky130_fd_sc_hd__decap_3
XFILLER_0_92_182 vssd1 vssd1 vccd1 vccd1 sky130_fd_sc_hd__fill_1
XFILLER_0_92_171 vssd1 vssd1 vccd1 vccd1 sky130_fd_sc_hd__fill_2
XFILLER_0_25_238 vssd1 vssd1 vccd1 vccd1 sky130_fd_sc_hd__decap_6
XFILLER_0_40_208 vssd1 vssd1 vccd1 vccd1 sky130_fd_sc_hd__fill_2
XANTENNA__3944__C _4971_/D vssd1 vssd1 vccd1 vccd1 sky130_fd_sc_hd__diode_2
XANTENNA__5932__S _5932_/S vssd1 vssd1 vccd1 vccd1 sky130_fd_sc_hd__diode_2
XFILLER_0_110_129 vssd1 vssd1 vccd1 vccd1 sky130_fd_sc_hd__fill_2
XFILLER_0_110_107 vssd1 vssd1 vccd1 vccd1 sky130_fd_sc_hd__fill_1
XTAP_606 vssd1 vccd1 sky130_fd_sc_hd__tapvpwrvgnd_1
XTAP_617 vssd1 vccd1 sky130_fd_sc_hd__tapvpwrvgnd_1
XTAP_628 vssd1 vccd1 sky130_fd_sc_hd__tapvpwrvgnd_1
XTAP_639 vssd1 vccd1 sky130_fd_sc_hd__tapvpwrvgnd_1
XFILLER_0_84_27 vssd1 vssd1 vccd1 vccd1 sky130_fd_sc_hd__fill_1
XFILLER_0_17_65 vssd1 vssd1 vccd1 vccd1 sky130_fd_sc_hd__fill_1
XANTENNA__4791__B _5656_/A vssd1 vssd1 vccd1 vccd1 sky130_fd_sc_hd__diode_2
XFILLER_0_75_105 vssd1 vssd1 vccd1 vccd1 sky130_fd_sc_hd__fill_2
XFILLER_0_33_20 vssd1 vssd1 vccd1 vccd1 sky130_fd_sc_hd__fill_2
X_5840_ tex_addr_i[16] tex_addr_i[17] tex_addr_i[18] tex_addr_i[19] _5913_/B vssd1
+ vssd1 vccd1 vccd1 _5840_/Y sky130_fd_sc_hd__o41ai_1
X_5771_ _5782_/A _5771_/B vssd1 vssd1 vccd1 vccd1 _5772_/C sky130_fd_sc_hd__or2_1
XFILLER_0_33_75 vssd1 vssd1 vccd1 vccd1 sky130_fd_sc_hd__decap_3
XANTENNA__3596__B1 _5118_/B vssd1 vssd1 vccd1 vccd1 sky130_fd_sc_hd__diode_2
XFILLER_0_56_363 vssd1 vssd1 vccd1 vccd1 sky130_fd_sc_hd__fill_1
X_4722_ _4723_/B _4723_/A vssd1 vssd1 vccd1 vccd1 _4725_/A sky130_fd_sc_hd__nand2b_1
XFILLER_0_126_251 vssd1 vssd1 vccd1 vccd1 sky130_fd_sc_hd__fill_1
XFILLER_0_56_385 vssd1 vssd1 vccd1 vccd1 sky130_ef_sc_hd__decap_12
X_4653_ _4654_/A _4668_/A vssd1 vssd1 vccd1 vccd1 _4653_/X sky130_fd_sc_hd__and2b_1
X_4584_ _5645_/B _4614_/C _4582_/D _5645_/A vssd1 vssd1 vccd1 vccd1 _4585_/B sky130_fd_sc_hd__a22o_1
XANTENNA__4312__A _5754_/B vssd1 vssd1 vccd1 vccd1 sky130_fd_sc_hd__diode_2
XFILLER_0_71_388 vssd1 vssd1 vccd1 vccd1 sky130_fd_sc_hd__decap_4
X_3604_ _3605_/B _3605_/C _3605_/A vssd1 vssd1 vccd1 vccd1 _3608_/A sky130_fd_sc_hd__o21a_2
X_6323_ _6323_/A pix_mport_i[32] vssd1 vssd1 vccd1 vccd1 _6328_/A sky130_fd_sc_hd__nor2_1
X_3535_ _3534_/A _3534_/B _3533_/X vssd1 vssd1 vccd1 vccd1 _3536_/B sky130_fd_sc_hd__o21bai_1
X_6254_ _6255_/A _6842_/Q _6841_/Q _3320_/Y vssd1 vssd1 vccd1 vccd1 _6268_/B sky130_fd_sc_hd__a22o_1
X_3466_ _5320_/A _5296_/B _3466_/C _3466_/D vssd1 vssd1 vccd1 vccd1 _3468_/A sky130_fd_sc_hd__and4_1
XANTENNA__3870__B _5083_/B vssd1 vssd1 vccd1 vccd1 sky130_fd_sc_hd__diode_2
XANTENNA__4966__B _4966_/B vssd1 vssd1 vccd1 vccd1 sky130_fd_sc_hd__diode_2
X_5205_ _5127_/X _5205_/B vssd1 vssd1 vccd1 vccd1 _5209_/A sky130_fd_sc_hd__and2b_1
X_6185_ _6162_/A _6173_/A _6184_/X _6183_/Y vssd1 vssd1 vccd1 vccd1 _6185_/X sky130_fd_sc_hd__a31o_1
X_3397_ _3397_/A _3397_/B vssd1 vssd1 vccd1 vccd1 _3399_/A sky130_fd_sc_hd__or2_1
X_5136_ _5136_/A _5136_/B _5136_/C vssd1 vssd1 vccd1 vccd1 _5139_/A sky130_fd_sc_hd__nand3_1
XANTENNA__4076__A1 _4816_/A vssd1 vssd1 vccd1 vccd1 sky130_fd_sc_hd__diode_2
X_5067_ _6642_/Q _5067_/B vssd1 vssd1 vccd1 vccd1 _5068_/B sky130_fd_sc_hd__nor2_1
XFILLER_0_74_93 vssd1 vssd1 vccd1 vccd1 sky130_fd_sc_hd__fill_1
X_4018_ _5264_/A _5264_/B vssd1 vssd1 vccd1 vccd1 _5433_/A sky130_fd_sc_hd__nor2_1
XANTENNA__3598__A _5081_/B vssd1 vssd1 vccd1 vccd1 sky130_fd_sc_hd__diode_2
XANTENNA__3823__A1 _5051_/A vssd1 vssd1 vccd1 vccd1 sky130_fd_sc_hd__diode_2
XFILLER_0_90_70 vssd1 vssd1 vccd1 vccd1 sky130_fd_sc_hd__decap_4
XFILLER_0_66_149 vssd1 vssd1 vccd1 vccd1 sky130_fd_sc_hd__fill_2
XFILLER_0_66_138 vssd1 vssd1 vccd1 vccd1 sky130_fd_sc_hd__fill_2
X_5969_ _5969_/A _5969_/B _5969_/C _5969_/D vssd1 vssd1 vccd1 vccd1 _5969_/X sky130_fd_sc_hd__or4_4
XFILLER_0_74_193 vssd1 vssd1 vccd1 vccd1 sky130_fd_sc_hd__fill_1
XFILLER_0_22_208 vssd1 vssd1 vccd1 vccd1 sky130_fd_sc_hd__fill_2
XFILLER_0_132_276 vssd1 vssd1 vccd1 vccd1 sky130_fd_sc_hd__fill_2
XANTENNA__5752__S _5844_/S vssd1 vssd1 vccd1 vccd1 sky130_fd_sc_hd__diode_2
XFILLER_0_30_263 vssd1 vssd1 vccd1 vccd1 sky130_fd_sc_hd__fill_1
XANTENNA_clkbuf_leaf_25_clk_i_A _6684_/CLK vssd1 vssd1 vccd1 vccd1 sky130_fd_sc_hd__diode_2
XFILLER_0_97_263 vssd1 vssd1 vccd1 vccd1 sky130_fd_sc_hd__fill_1
XFILLER_0_70_29 vssd1 vssd1 vccd1 vccd1 sky130_fd_sc_hd__fill_2
XANTENNA__5927__S _5932_/S vssd1 vssd1 vccd1 vccd1 sky130_fd_sc_hd__diode_2
XFILLER_0_80_141 vssd1 vssd1 vccd1 vccd1 sky130_fd_sc_hd__decap_3
XFILLER_0_79_27 vssd1 vssd1 vccd1 vccd1 sky130_fd_sc_hd__fill_2
XFILLER_0_53_344 vssd1 vssd1 vccd1 vccd1 sky130_fd_sc_hd__decap_4
XFILLER_0_79_38 vssd1 vssd1 vccd1 vccd1 sky130_fd_sc_hd__fill_2
XFILLER_0_111_405 vssd1 vssd1 vccd1 vccd1 sky130_fd_sc_hd__fill_2
Xhold109 _6524_/Q vssd1 vssd1 vccd1 vccd1 hold109/X sky130_fd_sc_hd__dlygate4sd3_1
X_3320_ depth_mport_i[8] vssd1 vssd1 vccd1 vccd1 _3320_/Y sky130_fd_sc_hd__inv_2
XFILLER_0_123_298 vssd1 vssd1 vccd1 vccd1 sky130_fd_sc_hd__fill_2
XFILLER_0_0_113 vssd1 vssd1 vccd1 vccd1 sky130_ef_sc_hd__decap_12
XFILLER_0_0_179 vssd1 vssd1 vccd1 vccd1 sky130_fd_sc_hd__decap_4
XTAP_403 vssd1 vccd1 sky130_fd_sc_hd__tapvpwrvgnd_1
XTAP_414 vssd1 vccd1 sky130_fd_sc_hd__tapvpwrvgnd_1
X_3251_ _5645_/B vssd1 vssd1 vccd1 vccd1 _3251_/Y sky130_fd_sc_hd__inv_2
XTAP_425 vssd1 vccd1 sky130_fd_sc_hd__tapvpwrvgnd_1
XTAP_436 vssd1 vccd1 sky130_fd_sc_hd__tapvpwrvgnd_1
XTAP_447 vssd1 vccd1 sky130_fd_sc_hd__tapvpwrvgnd_1
XTAP_458 vssd1 vccd1 sky130_fd_sc_hd__tapvpwrvgnd_1
XTAP_469 vssd1 vccd1 sky130_fd_sc_hd__tapvpwrvgnd_1
XFILLER_0_28_42 vssd1 vssd1 vccd1 vccd1 sky130_fd_sc_hd__fill_2
XANTENNA__6047__A2 _6038_/B vssd1 vssd1 vccd1 vccd1 sky130_fd_sc_hd__diode_2
XFILLER_0_28_97 vssd1 vssd1 vccd1 vccd1 sky130_fd_sc_hd__fill_2
X_6941_ vssd1 vssd1 vccd1 vccd1 _6941_/HI pix_mport_o[61] sky130_fd_sc_hd__conb_1
X_6872_ _6892_/CLK _6872_/D vssd1 vssd1 vccd1 vccd1 _6872_/Q sky130_fd_sc_hd__dfxtp_1
XFILLER_0_48_105 vssd1 vssd1 vccd1 vccd1 sky130_fd_sc_hd__decap_3
XFILLER_0_48_149 vssd1 vssd1 vccd1 vccd1 sky130_fd_sc_hd__fill_2
X_5823_ tex_addr_i[18] _5919_/B vssd1 vssd1 vccd1 vccd1 _5837_/A sky130_fd_sc_hd__xnor2_1
XFILLER_0_63_108 vssd1 vssd1 vccd1 vccd1 sky130_fd_sc_hd__fill_2
XFILLER_0_8_213 vssd1 vssd1 vccd1 vccd1 sky130_fd_sc_hd__fill_2
XFILLER_0_29_374 vssd1 vssd1 vccd1 vccd1 sky130_ef_sc_hd__decap_12
X_5754_ _5754_/A _5754_/B _5754_/C vssd1 vssd1 vccd1 vccd1 _5766_/B sky130_fd_sc_hd__or3_1
XFILLER_0_8_246 vssd1 vssd1 vccd1 vccd1 sky130_fd_sc_hd__fill_2
XFILLER_0_56_182 vssd1 vssd1 vccd1 vccd1 sky130_fd_sc_hd__decap_4
XFILLER_0_60_62 vssd1 vssd1 vccd1 vccd1 sky130_fd_sc_hd__decap_3
X_4705_ _5361_/A _5389_/A _5389_/B _4704_/Y vssd1 vssd1 vccd1 vccd1 _5392_/A sky130_fd_sc_hd__a31o_2
X_5685_ _5695_/B _5684_/Y _5796_/A _5567_/B vssd1 vssd1 vccd1 vccd1 _5685_/X sky130_fd_sc_hd__a2bb2o_1
XFILLER_0_44_355 vssd1 vssd1 vccd1 vccd1 sky130_fd_sc_hd__fill_2
XFILLER_0_56_193 vssd1 vssd1 vccd1 vccd1 sky130_fd_sc_hd__decap_3
XFILLER_0_114_221 vssd1 vssd1 vccd1 vccd1 sky130_fd_sc_hd__fill_2
X_4636_ _6625_/Q _4636_/B vssd1 vssd1 vccd1 vccd1 _4650_/A sky130_fd_sc_hd__xnor2_2
XANTENNA__4042__A _4816_/A vssd1 vssd1 vccd1 vccd1 sky130_fd_sc_hd__diode_2
XFILLER_0_71_174 vssd1 vssd1 vccd1 vccd1 sky130_fd_sc_hd__fill_2
XFILLER_0_8_41 vssd1 vssd1 vccd1 vccd1 sky130_ef_sc_hd__decap_12
X_6306_ _6789_/Q hold45/X _6319_/S vssd1 vssd1 vccd1 vccd1 hold46/A sky130_fd_sc_hd__mux2_1
X_4567_ _6628_/Q _4567_/B vssd1 vssd1 vccd1 vccd1 _4568_/D sky130_fd_sc_hd__xnor2_1
XFILLER_0_8_85 vssd1 vssd1 vccd1 vccd1 sky130_ef_sc_hd__decap_12
X_4498_ _4498_/A _4498_/B _4498_/C vssd1 vssd1 vccd1 vccd1 _4498_/Y sky130_fd_sc_hd__nor3_2
XFILLER_0_12_274 vssd1 vssd1 vccd1 vccd1 sky130_fd_sc_hd__fill_2
X_3518_ _3518_/A _3518_/B vssd1 vssd1 vccd1 vccd1 _3520_/A sky130_fd_sc_hd__nand2_1
X_6237_ _3310_/Y _6850_/Q _6849_/Q _6275_/B vssd1 vssd1 vccd1 vccd1 _6237_/X sky130_fd_sc_hd__a22o_1
X_3449_ _3449_/A _3585_/A vssd1 vssd1 vccd1 vccd1 _3455_/A sky130_fd_sc_hd__nor2_1
X_6168_ _6168_/A _6168_/B vssd1 vssd1 vccd1 vccd1 _6170_/A sky130_fd_sc_hd__nor2_1
XTAP_970 vssd1 vccd1 sky130_fd_sc_hd__tapvpwrvgnd_1
XTAP_992 vssd1 vccd1 sky130_fd_sc_hd__tapvpwrvgnd_1
XTAP_981 vssd1 vccd1 sky130_fd_sc_hd__tapvpwrvgnd_1
X_5119_ _5286_/A _4776_/A _5117_/B _5115_/X vssd1 vssd1 vccd1 vccd1 _5121_/B sky130_fd_sc_hd__a31o_1
X_6099_ hold221/X _6737_/Q _6113_/S vssd1 vssd1 vccd1 vccd1 _6099_/X sky130_fd_sc_hd__mux2_1
XANTENNA__5797__A1 _5599_/A vssd1 vssd1 vccd1 vccd1 sky130_fd_sc_hd__diode_2
XANTENNA__5549__A1 hold117/X vssd1 vssd1 vccd1 vccd1 sky130_fd_sc_hd__diode_2
XFILLER_0_94_244 vssd1 vssd1 vccd1 vccd1 sky130_fd_sc_hd__fill_1
XFILLER_0_39_149 vssd1 vssd1 vccd1 vccd1 sky130_fd_sc_hd__fill_1
XFILLER_0_62_141 vssd1 vssd1 vccd1 vccd1 sky130_fd_sc_hd__fill_2
XFILLER_0_105_287 vssd1 vssd1 vccd1 vccd1 sky130_fd_sc_hd__fill_2
XFILLER_0_120_279 vssd1 vssd1 vccd1 vccd1 sky130_fd_sc_hd__decap_3
XANTENNA__4127__A _4794_/B vssd1 vssd1 vccd1 vccd1 sky130_fd_sc_hd__diode_2
XANTENNA__3669__C _5299_/A vssd1 vssd1 vccd1 vccd1 sky130_fd_sc_hd__diode_2
XFILLER_0_85_222 vssd1 vssd1 vccd1 vccd1 sky130_fd_sc_hd__fill_2
XFILLER_0_85_266 vssd1 vssd1 vccd1 vccd1 sky130_fd_sc_hd__fill_1
XFILLER_0_26_322 vssd1 vssd1 vccd1 vccd1 sky130_fd_sc_hd__fill_1
X_5470_ hold102/X sstream_i[61] _6486_/S vssd1 vssd1 vccd1 vccd1 _6503_/D sky130_fd_sc_hd__mux2_1
XFILLER_0_26_388 vssd1 vssd1 vccd1 vccd1 sky130_ef_sc_hd__decap_12
XFILLER_0_100_3 vssd1 vssd1 vccd1 vccd1 sky130_fd_sc_hd__decap_3
X_4421_ _4397_/A _4397_/B _4397_/C vssd1 vssd1 vccd1 vccd1 _4443_/B sky130_fd_sc_hd__a21oi_1
XFILLER_0_30_98 vssd1 vssd1 vccd1 vccd1 sky130_fd_sc_hd__fill_2
X_4352_ _4352_/A _4409_/A vssd1 vssd1 vccd1 vccd1 _4359_/A sky130_fd_sc_hd__nand2_1
X_3303_ depth_mport_i[23] vssd1 vssd1 vccd1 vccd1 _6234_/A sky130_fd_sc_hd__inv_2
X_4283_ _4283_/A _4283_/B _4283_/C vssd1 vssd1 vccd1 vccd1 _4287_/B sky130_fd_sc_hd__nand3_1
XFILLER_0_39_74 vssd1 vssd1 vccd1 vccd1 sky130_fd_sc_hd__fill_2
X_6022_ _6038_/C _6026_/B _6022_/C vssd1 vssd1 vccd1 vccd1 _6022_/X sky130_fd_sc_hd__and3b_1
XTAP_288 vssd1 vccd1 sky130_fd_sc_hd__tapvpwrvgnd_1
XTAP_299 vssd1 vccd1 sky130_fd_sc_hd__tapvpwrvgnd_1
X_6924_ vssd1 vssd1 vccd1 vccd1 _6924_/HI pix_mport_o[25] sky130_fd_sc_hd__conb_1
XFILLER_0_119_302 vssd1 vssd1 vccd1 vccd1 sky130_fd_sc_hd__fill_1
Xfanout15 _6465_/S vssd1 vssd1 vccd1 vccd1 _6473_/S sky130_fd_sc_hd__clkbuf_4
Xfanout26 _6061_/S vssd1 vssd1 vccd1 vccd1 _6072_/S sky130_fd_sc_hd__buf_6
X_6855_ _6855_/CLK _6855_/D vssd1 vssd1 vccd1 vccd1 _6855_/Q sky130_fd_sc_hd__dfxtp_1
XFILLER_0_64_406 vssd1 vssd1 vccd1 vccd1 sky130_fd_sc_hd__fill_1
Xfanout37 _6683_/Q vssd1 vssd1 vccd1 vccd1 _5286_/B sky130_fd_sc_hd__buf_4
X_6786_ _6802_/CLK _6786_/D vssd1 vssd1 vccd1 vccd1 _6786_/Q sky130_fd_sc_hd__dfxtp_1
XFILLER_0_91_214 vssd1 vssd1 vccd1 vccd1 sky130_fd_sc_hd__decap_3
X_5806_ _5806_/A _5812_/B vssd1 vssd1 vccd1 vccd1 _5808_/A sky130_fd_sc_hd__nor2_1
Xfanout48 _6677_/Q vssd1 vssd1 vccd1 vccd1 _4944_/B sky130_fd_sc_hd__buf_4
XFILLER_0_17_311 vssd1 vssd1 vccd1 vccd1 sky130_fd_sc_hd__fill_1
X_3998_ _5093_/A _6682_/Q _3986_/A _3984_/B vssd1 vssd1 vccd1 vccd1 _4001_/A sky130_fd_sc_hd__a31o_1
Xfanout59 _5115_/D vssd1 vssd1 vccd1 vccd1 _4774_/B sky130_fd_sc_hd__buf_4
XFILLER_0_91_258 vssd1 vssd1 vccd1 vccd1 sky130_fd_sc_hd__fill_1
X_5737_ tex_addr_i[9] _5737_/B vssd1 vssd1 vccd1 vccd1 _5738_/B sky130_fd_sc_hd__nor2_2
XFILLER_0_17_366 vssd1 vssd1 vccd1 vccd1 sky130_fd_sc_hd__fill_1
XFILLER_0_32_314 vssd1 vssd1 vccd1 vccd1 sky130_fd_sc_hd__fill_2
XFILLER_0_44_163 vssd1 vssd1 vccd1 vccd1 sky130_fd_sc_hd__fill_2
X_5668_ _5667_/Y _6509_/Q _5802_/B vssd1 vssd1 vccd1 vccd1 _5670_/B sky130_fd_sc_hd__mux2_1
XFILLER_0_32_358 vssd1 vssd1 vccd1 vccd1 sky130_fd_sc_hd__decap_4
X_4619_ _5666_/A _4658_/D vssd1 vssd1 vccd1 vccd1 _4621_/B sky130_fd_sc_hd__nand2_1
X_5599_ _5599_/A _5599_/B vssd1 vssd1 vccd1 vccd1 _5599_/X sky130_fd_sc_hd__and2_2
XFILLER_0_102_257 vssd1 vssd1 vccd1 vccd1 sky130_fd_sc_hd__fill_1
XFILLER_0_96_80 vssd1 vssd1 vccd1 vccd1 sky130_fd_sc_hd__fill_2
XANTENNA_fanout76_A _6663_/Q vssd1 vssd1 vccd1 vccd1 sky130_fd_sc_hd__diode_2
XANTENNA__3493__A2 _5296_/B vssd1 vssd1 vccd1 vccd1 sky130_fd_sc_hd__diode_2
XFILLER_0_125_305 vssd1 vssd1 vccd1 vccd1 sky130_fd_sc_hd__fill_2
XFILLER_0_35_130 vssd1 vssd1 vccd1 vccd1 sky130_fd_sc_hd__fill_2
XFILLER_0_35_152 vssd1 vssd1 vccd1 vccd1 sky130_fd_sc_hd__fill_2
XFILLER_0_23_347 vssd1 vssd1 vccd1 vccd1 sky130_fd_sc_hd__decap_6
XFILLER_0_133_393 vssd1 vssd1 vccd1 vccd1 sky130_ef_sc_hd__decap_12
XANTENNA__6726__SET_B fanout145/X vssd1 vssd1 vccd1 vccd1 sky130_fd_sc_hd__diode_2
XFILLER_0_92_27 vssd1 vssd1 vccd1 vccd1 sky130_fd_sc_hd__fill_1
XFILLER_0_116_67 vssd1 vssd1 vccd1 vccd1 sky130_fd_sc_hd__fill_2
XFILLER_0_116_45 vssd1 vssd1 vccd1 vccd1 sky130_fd_sc_hd__fill_2
XFILLER_0_25_32 vssd1 vssd1 vccd1 vccd1 sky130_fd_sc_hd__fill_2
X_4970_ _5787_/B _4970_/B vssd1 vssd1 vccd1 vccd1 _4973_/A sky130_fd_sc_hd__and2_1
X_3921_ _3919_/A _3919_/B _3918_/X vssd1 vssd1 vccd1 vccd1 _3923_/C sky130_fd_sc_hd__o21ba_1
XFILLER_0_46_406 vssd1 vssd1 vccd1 vccd1 sky130_fd_sc_hd__fill_1
XFILLER_0_73_225 vssd1 vssd1 vccd1 vccd1 sky130_fd_sc_hd__fill_1
X_3852_ _3852_/A _3852_/B vssd1 vssd1 vccd1 vccd1 _3854_/C sky130_fd_sc_hd__xor2_1
X_6640_ _6751_/CLK _6640_/D _5937_/A vssd1 vssd1 vccd1 vccd1 _6640_/Q sky130_fd_sc_hd__dfstp_1
XFILLER_0_132_55 vssd1 vssd1 vccd1 vccd1 sky130_fd_sc_hd__fill_2
X_6571_ _6862_/CLK _6571_/D _6320_/C vssd1 vssd1 vccd1 vccd1 depth_mport_o[15] sky130_fd_sc_hd__dfrtp_4
XANTENNA__5933__A1 _5784_/S vssd1 vssd1 vccd1 vccd1 sky130_fd_sc_hd__diode_2
XFILLER_0_73_269 vssd1 vssd1 vccd1 vccd1 sky130_fd_sc_hd__fill_2
XFILLER_0_41_75 vssd1 vssd1 vccd1 vccd1 sky130_fd_sc_hd__decap_4
X_5522_ hold240/X sstream_i[113] _6473_/S vssd1 vssd1 vccd1 vccd1 _6555_/D sky130_fd_sc_hd__mux2_1
XFILLER_0_109_390 vssd1 vssd1 vccd1 vccd1 sky130_fd_sc_hd__fill_2
X_3783_ _3783_/A _3783_/B vssd1 vssd1 vccd1 vccd1 _3801_/A sky130_fd_sc_hd__xor2_1
XFILLER_0_26_141 vssd1 vssd1 vccd1 vccd1 sky130_fd_sc_hd__fill_2
XFILLER_0_124_360 vssd1 vssd1 vccd1 vccd1 sky130_fd_sc_hd__decap_4
XFILLER_0_41_122 vssd1 vssd1 vccd1 vccd1 sky130_fd_sc_hd__fill_2
XFILLER_0_41_133 vssd1 vssd1 vccd1 vccd1 sky130_fd_sc_hd__fill_2
XFILLER_0_14_369 vssd1 vssd1 vccd1 vccd1 sky130_fd_sc_hd__decap_3
X_5453_ _5435_/Y _5436_/X _5451_/X _5452_/Y vssd1 vssd1 vccd1 vccd1 _5456_/C sky130_fd_sc_hd__o22a_1
X_5384_ _6726_/Q _5384_/B vssd1 vssd1 vccd1 vccd1 _5387_/B sky130_fd_sc_hd__xnor2_1
X_4404_ _6631_/Q _4449_/B vssd1 vssd1 vccd1 vccd1 _4451_/A sky130_fd_sc_hd__nand2_1
XANTENNA__6011__S _6037_/S vssd1 vssd1 vccd1 vccd1 sky130_fd_sc_hd__diode_2
XANTENNA__4958__C _5118_/B vssd1 vssd1 vccd1 vccd1 sky130_fd_sc_hd__diode_2
X_4335_ _4335_/A _4335_/B vssd1 vssd1 vccd1 vccd1 _4337_/B sky130_fd_sc_hd__xnor2_1
X_4266_ _5701_/A _5687_/A _4971_/B _4551_/D vssd1 vssd1 vccd1 vccd1 _4269_/A sky130_fd_sc_hd__nand4_2
X_4197_ _4196_/B _4196_/C _4196_/A vssd1 vssd1 vccd1 vccd1 _4203_/B sky130_fd_sc_hd__a21o_1
X_6005_ _6004_/Y hold183/X _6038_/C vssd1 vssd1 vccd1 vccd1 _6005_/X sky130_fd_sc_hd__mux2_1
XTAP_1229 vssd1 vccd1 sky130_fd_sc_hd__tapvpwrvgnd_1
XTAP_1218 vssd1 vccd1 sky130_fd_sc_hd__tapvpwrvgnd_1
XTAP_1207 vssd1 vccd1 sky130_fd_sc_hd__tapvpwrvgnd_1
XFILLER_0_49_211 vssd1 vssd1 vccd1 vccd1 sky130_fd_sc_hd__fill_2
X_6907_ vssd1 vssd1 vccd1 vccd1 _6907_/HI pix_mport_o[8] sky130_fd_sc_hd__conb_1
XFILLER_0_49_266 vssd1 vssd1 vccd1 vccd1 sky130_fd_sc_hd__fill_1
X_6838_ _6864_/CLK _6838_/D vssd1 vssd1 vccd1 vccd1 _6838_/Q sky130_fd_sc_hd__dfxtp_1
XFILLER_0_64_225 vssd1 vssd1 vccd1 vccd1 sky130_fd_sc_hd__fill_1
XFILLER_0_49_288 vssd1 vssd1 vccd1 vccd1 sky130_fd_sc_hd__fill_1
XFILLER_0_134_113 vssd1 vssd1 vccd1 vccd1 sky130_fd_sc_hd__fill_2
XFILLER_0_107_327 vssd1 vssd1 vccd1 vccd1 sky130_fd_sc_hd__fill_2
XFILLER_0_9_363 vssd1 vssd1 vccd1 vccd1 sky130_ef_sc_hd__decap_12
XANTENNA__4727__A2 _4958_/B vssd1 vssd1 vccd1 vccd1 sky130_fd_sc_hd__diode_2
XFILLER_0_134_135 vssd1 vssd1 vccd1 vccd1 sky130_fd_sc_hd__fill_2
XFILLER_0_134_124 vssd1 vssd1 vccd1 vccd1 sky130_fd_sc_hd__fill_2
X_6769_ _6830_/CLK _6769_/D fanout153/X vssd1 vssd1 vccd1 vccd1 pix_mport_o[41] sky130_fd_sc_hd__dfrtp_4
XFILLER_0_115_393 vssd1 vssd1 vccd1 vccd1 sky130_ef_sc_hd__decap_12
XANTENNA__5688__B1 _5687_/A vssd1 vssd1 vccd1 vccd1 sky130_fd_sc_hd__diode_2
XFILLER_0_130_363 vssd1 vssd1 vccd1 vccd1 sky130_fd_sc_hd__fill_1
Xhold270 _6733_/Q vssd1 vssd1 vccd1 vccd1 hold270/X sky130_fd_sc_hd__dlygate4sd3_1
XFILLER_0_13_391 vssd1 vssd1 vccd1 vccd1 sky130_fd_sc_hd__fill_1
Xhold292 _6628_/Q vssd1 vssd1 vccd1 vccd1 hold292/X sky130_fd_sc_hd__dlygate4sd3_1
Xhold281 _6639_/Q vssd1 vssd1 vccd1 vccd1 hold281/X sky130_fd_sc_hd__dlygate4sd3_1
XFILLER_0_99_111 vssd1 vssd1 vccd1 vccd1 sky130_fd_sc_hd__fill_1
XANTENNA__5860__A0 _5447_/X vssd1 vssd1 vccd1 vccd1 sky130_fd_sc_hd__diode_2
XANTENNA_110 sstream_i[7] vssd1 vssd1 vccd1 vccd1 sky130_fd_sc_hd__diode_2
XANTENNA_121 tex_addr_i[10] vssd1 vssd1 vccd1 vccd1 sky130_fd_sc_hd__diode_2
XANTENNA_132 tex_addr_i[1] vssd1 vssd1 vccd1 vccd1 sky130_fd_sc_hd__diode_2
XANTENNA_143 tex_width_i[0] vssd1 vssd1 vccd1 vccd1 sky130_fd_sc_hd__diode_2
XANTENNA_154 sstream_i[22] vssd1 vssd1 vccd1 vccd1 sky130_fd_sc_hd__diode_2
XFILLER_0_55_203 vssd1 vssd1 vccd1 vccd1 sky130_fd_sc_hd__fill_1
XFILLER_0_125_113 vssd1 vssd1 vccd1 vccd1 sky130_fd_sc_hd__decap_3
XFILLER_0_70_217 vssd1 vssd1 vccd1 vccd1 sky130_fd_sc_hd__fill_2
XFILLER_0_70_206 vssd1 vssd1 vccd1 vccd1 sky130_fd_sc_hd__fill_1
XANTENNA__4718__A2 _5051_/B vssd1 vssd1 vccd1 vccd1 sky130_fd_sc_hd__diode_2
XFILLER_0_23_122 vssd1 vssd1 vccd1 vccd1 sky130_fd_sc_hd__fill_2
Xclkbuf_leaf_13_clk_i clkbuf_2_3__f_clk_i/X vssd1 vssd1 vccd1 vccd1 _6827_/CLK sky130_fd_sc_hd__clkbuf_16
XFILLER_0_121_352 vssd1 vssd1 vccd1 vccd1 sky130_fd_sc_hd__decap_3
XFILLER_0_11_328 vssd1 vssd1 vccd1 vccd1 sky130_fd_sc_hd__fill_2
XANTENNA__4778__C _4966_/A vssd1 vssd1 vccd1 vccd1 sky130_fd_sc_hd__diode_2
X_4120_ _4119_/B _4119_/C _4119_/A vssd1 vssd1 vccd1 vccd1 _4121_/C sky130_fd_sc_hd__a21o_1
Xclkbuf_leaf_28_clk_i clkbuf_leaf_1_clk_i/A vssd1 vssd1 vccd1 vccd1 _6880_/CLK sky130_fd_sc_hd__clkbuf_16
XANTENNA__4794__B _4794_/B vssd1 vssd1 vccd1 vccd1 sky130_fd_sc_hd__diode_2
XFILLER_0_127_22 vssd1 vssd1 vccd1 vccd1 sky130_fd_sc_hd__fill_2
X_4051_ _5701_/A _4518_/D _4966_/B _5687_/A vssd1 vssd1 vccd1 vccd1 _4052_/C sky130_fd_sc_hd__a22o_1
XFILLER_0_36_20 vssd1 vssd1 vccd1 vccd1 sky130_fd_sc_hd__fill_2
XANTENNA__4957__A2 _4822_/B vssd1 vssd1 vccd1 vccd1 sky130_fd_sc_hd__diode_2
X_4953_ _4799_/X _4804_/B _5191_/A _4952_/X vssd1 vssd1 vccd1 vccd1 _5191_/B sky130_fd_sc_hd__o211ai_2
XANTENNA__4315__A _5718_/B vssd1 vssd1 vccd1 vccd1 sky130_fd_sc_hd__diode_2
XANTENNA__6605__RESET_B _5937_/A vssd1 vssd1 vccd1 vccd1 sky130_fd_sc_hd__diode_2
XANTENNA__6006__S _6037_/S vssd1 vssd1 vccd1 vccd1 sky130_fd_sc_hd__diode_2
X_3904_ _3854_/A _3854_/B _3854_/C vssd1 vssd1 vccd1 vccd1 _3904_/Y sky130_fd_sc_hd__o21ai_2
XFILLER_0_46_203 vssd1 vssd1 vccd1 vccd1 sky130_fd_sc_hd__decap_3
X_6623_ _6862_/CLK _6623_/D _6073_/A vssd1 vssd1 vccd1 vccd1 _6623_/Q sky130_fd_sc_hd__dfstp_1
XFILLER_0_46_247 vssd1 vssd1 vccd1 vccd1 sky130_fd_sc_hd__decap_4
XFILLER_0_52_96 vssd1 vssd1 vccd1 vccd1 sky130_fd_sc_hd__fill_2
X_4884_ _4884_/A _4884_/B vssd1 vssd1 vccd1 vccd1 _4886_/B sky130_fd_sc_hd__nand2_1
XFILLER_0_6_344 vssd1 vssd1 vccd1 vccd1 sky130_fd_sc_hd__fill_2
X_3835_ _3835_/A _3835_/B _3835_/C vssd1 vssd1 vccd1 vccd1 _3835_/X sky130_fd_sc_hd__or3_2
X_6554_ _6862_/CLK _6554_/D vssd1 vssd1 vccd1 vccd1 hold44/A sky130_fd_sc_hd__dfxtp_1
XFILLER_0_14_122 vssd1 vssd1 vccd1 vccd1 sky130_fd_sc_hd__decap_4
XFILLER_0_6_355 vssd1 vssd1 vccd1 vccd1 sky130_fd_sc_hd__fill_2
X_3766_ _3757_/A _3757_/B _3756_/A vssd1 vssd1 vccd1 vccd1 _3769_/A sky130_fd_sc_hd__a21o_2
X_5505_ hold75/X sstream_i[96] _6464_/S vssd1 vssd1 vccd1 vccd1 _6538_/D sky130_fd_sc_hd__mux2_1
X_6485_ hold216/X sstream_i[43] _6486_/S vssd1 vssd1 vccd1 vccd1 _6876_/D sky130_fd_sc_hd__mux2_1
XANTENNA__4050__A _5311_/A vssd1 vssd1 vccd1 vccd1 sky130_fd_sc_hd__diode_2
XFILLER_0_72_3 vssd1 vssd1 vccd1 vccd1 sky130_fd_sc_hd__fill_2
X_3697_ _3690_/X _3692_/Y _3698_/A _3696_/X vssd1 vssd1 vccd1 vccd1 _3698_/B sky130_fd_sc_hd__a211oi_2
X_5436_ _6747_/Q _5436_/B _5436_/C vssd1 vssd1 vccd1 vccd1 _5436_/X sky130_fd_sc_hd__and3_1
XFILLER_0_112_396 vssd1 vssd1 vccd1 vccd1 sky130_fd_sc_hd__decap_8
X_5367_ _5367_/A _5367_/B vssd1 vssd1 vccd1 vccd1 _5382_/B sky130_fd_sc_hd__xor2_2
XANTENNA__5580__S _5601_/S vssd1 vssd1 vccd1 vccd1 sky130_fd_sc_hd__diode_2
X_4318_ _4816_/B _4841_/D _4317_/B _4314_/X vssd1 vssd1 vccd1 vccd1 _4320_/B sky130_fd_sc_hd__a31o_1
X_5298_ _5296_/X _5297_/X _5298_/S vssd1 vssd1 vccd1 vccd1 _5302_/A sky130_fd_sc_hd__mux2_1
X_4249_ _4246_/X _4247_/Y _4082_/X _4090_/Y vssd1 vssd1 vccd1 vccd1 _4249_/X sky130_fd_sc_hd__o211a_1
XTAP_1004 vssd1 vccd1 sky130_fd_sc_hd__tapvpwrvgnd_1
XFILLER_0_96_125 vssd1 vssd1 vccd1 vccd1 sky130_fd_sc_hd__decap_8
XFILLER_0_96_114 vssd1 vssd1 vccd1 vccd1 sky130_fd_sc_hd__fill_2
XANTENNA_hold240_A _6555_/Q vssd1 vssd1 vccd1 vccd1 sky130_fd_sc_hd__diode_2
XTAP_1037 vssd1 vccd1 sky130_fd_sc_hd__tapvpwrvgnd_1
XTAP_1026 vssd1 vccd1 sky130_fd_sc_hd__tapvpwrvgnd_1
XTAP_1015 vssd1 vccd1 sky130_fd_sc_hd__tapvpwrvgnd_1
XFILLER_0_96_147 vssd1 vssd1 vccd1 vccd1 sky130_fd_sc_hd__decap_8
XFILLER_0_77_350 vssd1 vssd1 vccd1 vccd1 sky130_fd_sc_hd__decap_3
XTAP_1059 vssd1 vccd1 sky130_fd_sc_hd__tapvpwrvgnd_1
XTAP_1048 vssd1 vccd1 sky130_fd_sc_hd__tapvpwrvgnd_1
XANTENNA__5070__A1 _5071_/A vssd1 vssd1 vccd1 vccd1 sky130_fd_sc_hd__diode_2
XANTENNA__5070__B2 _5064_/B vssd1 vssd1 vccd1 vccd1 sky130_fd_sc_hd__diode_2
XFILLER_0_107_113 vssd1 vssd1 vccd1 vccd1 sky130_fd_sc_hd__fill_2
XFILLER_0_52_217 vssd1 vssd1 vccd1 vccd1 sky130_fd_sc_hd__fill_2
XFILLER_0_20_136 vssd1 vssd1 vccd1 vccd1 sky130_fd_sc_hd__fill_2
XFILLER_0_20_147 vssd1 vssd1 vccd1 vccd1 sky130_fd_sc_hd__fill_2
XFILLER_0_57_19 vssd1 vssd1 vccd1 vccd1 sky130_fd_sc_hd__fill_2
XFILLER_0_28_214 vssd1 vssd1 vccd1 vccd1 sky130_fd_sc_hd__fill_2
XFILLER_0_138_293 vssd1 vssd1 vccd1 vccd1 sky130_fd_sc_hd__decap_8
XFILLER_0_113_57 vssd1 vssd1 vccd1 vccd1 sky130_fd_sc_hd__fill_2
XFILLER_0_83_375 vssd1 vssd1 vccd1 vccd1 sky130_ef_sc_hd__decap_12
XFILLER_0_43_206 vssd1 vssd1 vccd1 vccd1 sky130_fd_sc_hd__fill_2
X_3620_ _3620_/A _3620_/B _3620_/C vssd1 vssd1 vccd1 vccd1 _3621_/B sky130_fd_sc_hd__or3_1
XANTENNA__4789__B _4789_/B vssd1 vssd1 vccd1 vccd1 sky130_fd_sc_hd__diode_2
XANTENNA__4593__A1_N _5656_/A vssd1 vssd1 vccd1 vccd1 sky130_fd_sc_hd__diode_2
X_3551_ _3552_/A _3552_/B vssd1 vssd1 vccd1 vccd1 _3557_/B sky130_fd_sc_hd__and2b_1
XFILLER_0_3_325 vssd1 vssd1 vccd1 vccd1 sky130_fd_sc_hd__fill_2
X_6270_ _6253_/X _6267_/Y _6268_/Y _6269_/X _6257_/X vssd1 vssd1 vccd1 vccd1 _6270_/X
+ sky130_fd_sc_hd__a41o_1
X_3482_ _3482_/A _3482_/B vssd1 vssd1 vccd1 vccd1 _3485_/B sky130_fd_sc_hd__xor2_1
XANTENNA__5116__A2 _5115_/C vssd1 vssd1 vccd1 vccd1 sky130_fd_sc_hd__diode_2
XFILLER_0_11_169 vssd1 vssd1 vccd1 vccd1 sky130_fd_sc_hd__fill_2
X_5221_ _5179_/Y _5183_/A _5252_/B _5220_/X vssd1 vssd1 vccd1 vccd1 _5223_/A sky130_fd_sc_hd__a211oi_1
X_5152_ _4978_/A _4978_/C _4978_/B vssd1 vssd1 vccd1 vccd1 _5153_/C sky130_fd_sc_hd__a21bo_1
X_4103_ _4146_/B _4101_/C _4101_/A vssd1 vssd1 vccd1 vccd1 _4104_/C sky130_fd_sc_hd__a21o_1
XFILLER_0_44_7 vssd1 vssd1 vccd1 vccd1 sky130_fd_sc_hd__fill_2
X_5083_ _5083_/A _5083_/B _5122_/A _5083_/D vssd1 vssd1 vccd1 vccd1 _5122_/B sky130_fd_sc_hd__nand4_1
X_4034_ _5718_/A _4031_/X _4033_/X vssd1 vssd1 vccd1 vccd1 _4254_/B sky130_fd_sc_hd__a21bo_1
XFILLER_0_2_65 vssd1 vssd1 vccd1 vccd1 sky130_ef_sc_hd__decap_12
XANTENNA__3868__B _3961_/A vssd1 vssd1 vccd1 vccd1 sky130_fd_sc_hd__diode_2
XANTENNA__4971__C _5787_/A vssd1 vssd1 vccd1 vccd1 sky130_fd_sc_hd__diode_2
XFILLER_0_93_128 vssd1 vssd1 vccd1 vccd1 sky130_fd_sc_hd__fill_2
XFILLER_0_63_95 vssd1 vssd1 vccd1 vccd1 sky130_fd_sc_hd__decap_3
XANTENNA__5052__A1 _5051_/A vssd1 vssd1 vccd1 vccd1 sky130_fd_sc_hd__diode_2
X_5985_ _4842_/A _5984_/X _6037_/S vssd1 vssd1 vccd1 vccd1 _6665_/D sky130_fd_sc_hd__mux2_1
XPHY_109 vssd1 vssd1 vccd1 vccd1 sky130_fd_sc_hd__decap_3
XANTENNA__4045__A _5701_/A vssd1 vssd1 vccd1 vccd1 sky130_fd_sc_hd__diode_2
X_4936_ _4821_/A _4820_/B _4818_/X vssd1 vssd1 vccd1 vccd1 _4951_/A sky130_fd_sc_hd__a21o_1
XANTENNA_32 sstream_i[14] vssd1 vssd1 vccd1 vccd1 sky130_fd_sc_hd__diode_2
XANTENNA_10 sstream_i[10] vssd1 vssd1 vccd1 vccd1 sky130_fd_sc_hd__diode_2
XANTENNA_21 sstream_i[12] vssd1 vssd1 vccd1 vccd1 sky130_fd_sc_hd__diode_2
XFILLER_0_19_258 vssd1 vssd1 vccd1 vccd1 sky130_fd_sc_hd__fill_2
XANTENNA__6001__A0 _4966_/B vssd1 vssd1 vccd1 vccd1 sky130_fd_sc_hd__diode_2
X_4867_ _4865_/A _4865_/C _4865_/B vssd1 vssd1 vccd1 vccd1 _4869_/C sky130_fd_sc_hd__a21o_1
XANTENNA_43 sstream_i[15] vssd1 vssd1 vccd1 vccd1 sky130_fd_sc_hd__diode_2
XANTENNA_54 sstream_i[17] vssd1 vssd1 vccd1 vccd1 sky130_fd_sc_hd__diode_2
XANTENNA_65 sstream_i[21] vssd1 vssd1 vccd1 vccd1 sky130_fd_sc_hd__diode_2
X_6606_ _6732_/CLK _6606_/D fanout143/X vssd1 vssd1 vccd1 vccd1 tex_mport_o[49] sky130_fd_sc_hd__dfrtp_4
X_3818_ _3818_/A _3818_/B vssd1 vssd1 vccd1 vccd1 _3831_/A sky130_fd_sc_hd__xnor2_1
XFILLER_0_34_239 vssd1 vssd1 vccd1 vccd1 sky130_fd_sc_hd__decap_4
XANTENNA_87 sstream_i[31] vssd1 vssd1 vccd1 vccd1 sky130_fd_sc_hd__diode_2
XANTENNA_76 sstream_i[28] vssd1 vssd1 vccd1 vccd1 sky130_fd_sc_hd__diode_2
XANTENNA_98 sstream_i[5] vssd1 vssd1 vccd1 vccd1 sky130_fd_sc_hd__diode_2
X_6537_ _6855_/CLK _6537_/D vssd1 vssd1 vccd1 vccd1 hold50/A sky130_fd_sc_hd__dfxtp_1
XFILLER_0_6_174 vssd1 vssd1 vccd1 vccd1 sky130_fd_sc_hd__fill_2
X_4798_ _4743_/A _4743_/C _4743_/B vssd1 vssd1 vccd1 vccd1 _4800_/C sky130_fd_sc_hd__a21bo_1
XFILLER_0_104_149 vssd1 vssd1 vccd1 vccd1 sky130_fd_sc_hd__fill_2
X_3749_ _3747_/X _5276_/B _5299_/A _3749_/D vssd1 vssd1 vccd1 vccd1 _3750_/B sky130_fd_sc_hd__and4b_1
XFILLER_0_42_272 vssd1 vssd1 vccd1 vccd1 sky130_fd_sc_hd__fill_1
X_6468_ hold189/X sstream_i[26] _6472_/S vssd1 vssd1 vccd1 vccd1 _6859_/D sky130_fd_sc_hd__mux2_1
X_6399_ _6543_/Q hold70/A vssd1 vssd1 vccd1 vccd1 _6408_/A sky130_fd_sc_hd__nand2_1
X_5419_ _5418_/B _5418_/C _5418_/A vssd1 vssd1 vccd1 vccd1 _5419_/Y sky130_fd_sc_hd__a21oi_1
XFILLER_0_100_377 vssd1 vssd1 vccd1 vccd1 sky130_ef_sc_hd__decap_12
XANTENNA__4618__A1 _4638_/A vssd1 vssd1 vccd1 vccd1 sky130_fd_sc_hd__diode_2
XANTENNA__5815__B1 _5922_/S vssd1 vssd1 vccd1 vccd1 sky130_fd_sc_hd__diode_2
XANTENNA__4094__A2 _4527_/B vssd1 vssd1 vccd1 vccd1 sky130_fd_sc_hd__diode_2
XFILLER_0_69_125 vssd1 vssd1 vccd1 vccd1 sky130_fd_sc_hd__fill_2
XFILLER_0_69_169 vssd1 vssd1 vccd1 vccd1 sky130_fd_sc_hd__fill_1
XFILLER_0_84_128 vssd1 vssd1 vccd1 vccd1 sky130_fd_sc_hd__fill_2
XANTENNA_clkbuf_leaf_21_clk_i_A _6684_/CLK vssd1 vssd1 vccd1 vccd1 sky130_fd_sc_hd__diode_2
XFILLER_0_25_206 vssd1 vssd1 vccd1 vccd1 sky130_fd_sc_hd__fill_2
XFILLER_0_18_280 vssd1 vssd1 vccd1 vccd1 sky130_fd_sc_hd__fill_2
XANTENNA__3794__A _5081_/A vssd1 vssd1 vccd1 vccd1 sky130_fd_sc_hd__diode_2
XANTENNA__3944__D _4970_/B vssd1 vssd1 vccd1 vccd1 sky130_fd_sc_hd__diode_2
XFILLER_0_33_261 vssd1 vssd1 vccd1 vccd1 sky130_fd_sc_hd__decap_4
XFILLER_0_0_317 vssd1 vssd1 vccd1 vccd1 sky130_fd_sc_hd__fill_2
XTAP_607 vssd1 vccd1 sky130_fd_sc_hd__tapvpwrvgnd_1
XTAP_618 vssd1 vccd1 sky130_fd_sc_hd__tapvpwrvgnd_1
XTAP_629 vssd1 vccd1 sky130_fd_sc_hd__tapvpwrvgnd_1
XFILLER_0_108_68 vssd1 vssd1 vccd1 vccd1 sky130_fd_sc_hd__decap_3
XFILLER_0_88_401 vssd1 vssd1 vccd1 vccd1 sky130_fd_sc_hd__decap_6
XANTENNA__6345__A hold98/A vssd1 vssd1 vccd1 vccd1 sky130_fd_sc_hd__diode_2
XFILLER_0_17_88 vssd1 vssd1 vccd1 vccd1 sky130_fd_sc_hd__decap_3
XFILLER_0_48_309 vssd1 vssd1 vccd1 vccd1 sky130_ef_sc_hd__decap_12
XFILLER_0_124_45 vssd1 vssd1 vccd1 vccd1 sky130_fd_sc_hd__fill_2
XFILLER_0_33_43 vssd1 vssd1 vccd1 vccd1 sky130_fd_sc_hd__fill_2
XFILLER_0_130_3 vssd1 vssd1 vccd1 vccd1 sky130_fd_sc_hd__fill_1
XFILLER_0_118_208 vssd1 vssd1 vccd1 vccd1 sky130_fd_sc_hd__fill_1
X_5770_ tex_addr_i[12] _5770_/B vssd1 vssd1 vccd1 vccd1 _5771_/B sky130_fd_sc_hd__nor2_1
XFILLER_0_33_65 vssd1 vssd1 vccd1 vccd1 sky130_fd_sc_hd__fill_2
XANTENNA__3596__A1 _5081_/A vssd1 vssd1 vccd1 vccd1 sky130_fd_sc_hd__diode_2
XFILLER_0_33_87 vssd1 vssd1 vccd1 vccd1 sky130_fd_sc_hd__fill_2
XFILLER_0_33_98 vssd1 vssd1 vccd1 vccd1 sky130_fd_sc_hd__fill_1
XFILLER_0_56_342 vssd1 vssd1 vccd1 vccd1 sky130_fd_sc_hd__decap_6
X_4721_ _5049_/D _5666_/A vssd1 vssd1 vccd1 vccd1 _4723_/B sky130_fd_sc_hd__nand2_1
X_4652_ _4667_/B _4667_/C _4667_/A vssd1 vssd1 vccd1 vccd1 _4668_/A sky130_fd_sc_hd__o21a_1
XFILLER_0_71_334 vssd1 vssd1 vccd1 vccd1 sky130_fd_sc_hd__fill_2
XFILLER_0_56_397 vssd1 vssd1 vccd1 vccd1 sky130_fd_sc_hd__decap_8
XFILLER_0_3_111 vssd1 vssd1 vccd1 vccd1 sky130_fd_sc_hd__fill_1
X_3603_ _3626_/A _3626_/B vssd1 vssd1 vccd1 vccd1 _3605_/C sky130_fd_sc_hd__nor2_1
X_4583_ _5645_/B _4614_/C _4582_/D _5645_/A vssd1 vssd1 vccd1 vccd1 _4583_/Y sky130_fd_sc_hd__a22oi_1
XANTENNA__4312__B _4527_/B vssd1 vssd1 vccd1 vccd1 sky130_fd_sc_hd__diode_2
XFILLER_0_3_133 vssd1 vssd1 vccd1 vccd1 sky130_fd_sc_hd__fill_2
X_6322_ hold209/X _6231_/X _6322_/S vssd1 vssd1 vccd1 vccd1 _6803_/D sky130_fd_sc_hd__mux2_1
XANTENNA__4031__C _4841_/D vssd1 vssd1 vccd1 vccd1 sky130_fd_sc_hd__diode_2
X_3534_ _3534_/A _3534_/B _3533_/X vssd1 vssd1 vccd1 vccd1 _3540_/B sky130_fd_sc_hd__or3b_1
X_6253_ _3318_/Y _6843_/Q _6251_/Y _6252_/X vssd1 vssd1 vccd1 vccd1 _6253_/X sky130_fd_sc_hd__o211a_1
X_3465_ _3465_/A vssd1 vssd1 vccd1 vccd1 _3466_/D sky130_fd_sc_hd__inv_2
XANTENNA__4966__C _4966_/C vssd1 vssd1 vccd1 vccd1 sky130_fd_sc_hd__diode_2
X_5204_ _3999_/A _5106_/B _5107_/A _5110_/A vssd1 vssd1 vccd1 vccd1 _5210_/A sky130_fd_sc_hd__a31o_1
X_6184_ _6184_/A _6184_/B vssd1 vssd1 vccd1 vccd1 _6184_/X sky130_fd_sc_hd__or2_1
X_3396_ _3611_/A _3394_/Y _3395_/A vssd1 vssd1 vccd1 vccd1 _3409_/A sky130_fd_sc_hd__a21o_1
XFILLER_0_35_3 vssd1 vssd1 vccd1 vccd1 sky130_fd_sc_hd__decap_3
X_5135_ _4973_/A _4973_/C _4973_/B vssd1 vssd1 vccd1 vccd1 _5136_/C sky130_fd_sc_hd__a21bo_1
XFILLER_0_74_61 vssd1 vssd1 vccd1 vccd1 sky130_fd_sc_hd__fill_1
X_5066_ _6642_/Q _5067_/B vssd1 vssd1 vccd1 vccd1 _5068_/A sky130_fd_sc_hd__and2_1
XANTENNA__4076__A2 _4638_/A vssd1 vssd1 vccd1 vccd1 sky130_fd_sc_hd__diode_2
X_4017_ _4017_/A _4017_/B vssd1 vssd1 vccd1 vccd1 _5264_/B sky130_fd_sc_hd__nor2_1
XANTENNA__3598__B _5300_/A vssd1 vssd1 vccd1 vccd1 sky130_fd_sc_hd__diode_2
X_5968_ hold14/A hold99/A hold90/A _6885_/Q vssd1 vssd1 vccd1 vccd1 _5969_/D sky130_fd_sc_hd__or4_1
XFILLER_0_74_150 vssd1 vssd1 vccd1 vccd1 sky130_fd_sc_hd__fill_2
X_4919_ _4919_/A _4919_/B _4919_/C vssd1 vssd1 vccd1 vccd1 _4919_/Y sky130_fd_sc_hd__nand3_2
XFILLER_0_74_172 vssd1 vssd1 vccd1 vccd1 sky130_fd_sc_hd__decap_3
X_5899_ _5899_/A vssd1 vssd1 vccd1 vccd1 _5899_/Y sky130_fd_sc_hd__inv_2
XFILLER_0_117_285 vssd1 vssd1 vccd1 vccd1 sky130_fd_sc_hd__fill_2
Xclkbuf_2_2__f_clk_i clkbuf_0_clk_i/X vssd1 vssd1 vccd1 vccd1 clkbuf_leaf_9_clk_i/A
+ sky130_fd_sc_hd__clkbuf_16
XFILLER_0_120_406 vssd1 vssd1 vccd1 vccd1 sky130_fd_sc_hd__fill_1
XFILLER_0_30_253 vssd1 vssd1 vccd1 vccd1 sky130_fd_sc_hd__fill_2
XFILLER_0_100_141 vssd1 vssd1 vccd1 vccd1 sky130_fd_sc_hd__decap_3
XFILLER_0_30_286 vssd1 vssd1 vccd1 vccd1 sky130_ef_sc_hd__decap_12
XFILLER_0_89_209 vssd1 vssd1 vccd1 vccd1 sky130_fd_sc_hd__fill_1
XANTENNA__4775__B1 _4814_/D vssd1 vssd1 vccd1 vccd1 sky130_fd_sc_hd__diode_2
XFILLER_0_108_241 vssd1 vssd1 vccd1 vccd1 sky130_fd_sc_hd__fill_2
XFILLER_0_53_323 vssd1 vssd1 vccd1 vccd1 sky130_fd_sc_hd__fill_2
XFILLER_0_80_175 vssd1 vssd1 vccd1 vccd1 sky130_fd_sc_hd__fill_2
XFILLER_0_80_164 vssd1 vssd1 vccd1 vccd1 sky130_fd_sc_hd__fill_2
XFILLER_0_123_277 vssd1 vssd1 vccd1 vccd1 sky130_fd_sc_hd__decap_3
XFILLER_0_110_58 vssd1 vssd1 vccd1 vccd1 sky130_fd_sc_hd__decap_3
XFILLER_0_123_288 vssd1 vssd1 vccd1 vccd1 sky130_fd_sc_hd__fill_2
XFILLER_0_0_136 vssd1 vssd1 vccd1 vccd1 sky130_fd_sc_hd__fill_2
XFILLER_0_0_125 vssd1 vssd1 vccd1 vccd1 sky130_fd_sc_hd__decap_4
XFILLER_0_0_169 vssd1 vssd1 vccd1 vccd1 sky130_fd_sc_hd__fill_2
XTAP_404 vssd1 vccd1 sky130_fd_sc_hd__tapvpwrvgnd_1
XTAP_415 vssd1 vccd1 sky130_fd_sc_hd__tapvpwrvgnd_1
X_3250_ _5645_/A vssd1 vssd1 vccd1 vccd1 _3250_/Y sky130_fd_sc_hd__inv_2
XTAP_426 vssd1 vccd1 sky130_fd_sc_hd__tapvpwrvgnd_1
XTAP_437 vssd1 vccd1 sky130_fd_sc_hd__tapvpwrvgnd_1
XTAP_448 vssd1 vccd1 sky130_fd_sc_hd__tapvpwrvgnd_1
XTAP_459 vssd1 vccd1 sky130_fd_sc_hd__tapvpwrvgnd_1
XFILLER_0_28_54 vssd1 vssd1 vccd1 vccd1 sky130_fd_sc_hd__fill_2
X_6940_ vssd1 vssd1 vccd1 vccd1 _6940_/HI pix_mport_o[60] sky130_fd_sc_hd__conb_1
XFILLER_0_135_55 vssd1 vssd1 vccd1 vccd1 sky130_fd_sc_hd__fill_1
XFILLER_0_88_253 vssd1 vssd1 vccd1 vccd1 sky130_fd_sc_hd__fill_1
X_6871_ _6880_/CLK _6871_/D vssd1 vssd1 vccd1 vccd1 _6871_/Q sky130_fd_sc_hd__dfxtp_1
XFILLER_0_29_331 vssd1 vssd1 vccd1 vccd1 sky130_fd_sc_hd__fill_2
X_5822_ hold221/X _5821_/X _5923_/S vssd1 vssd1 vccd1 vccd1 _6638_/D sky130_fd_sc_hd__mux2_1
X_5753_ _5754_/B _5754_/C _5754_/A vssd1 vssd1 vccd1 vccd1 _5755_/A sky130_fd_sc_hd__o21ai_1
X_4704_ _4507_/B _4547_/A _4547_/B _4505_/X vssd1 vssd1 vccd1 vccd1 _4704_/Y sky130_fd_sc_hd__o31ai_1
XFILLER_0_8_258 vssd1 vssd1 vccd1 vccd1 sky130_fd_sc_hd__fill_2
XANTENNA__6014__S _6037_/S vssd1 vssd1 vccd1 vccd1 sky130_fd_sc_hd__diode_2
XFILLER_0_29_386 vssd1 vssd1 vccd1 vccd1 sky130_fd_sc_hd__decap_6
XFILLER_0_44_323 vssd1 vssd1 vccd1 vccd1 sky130_fd_sc_hd__decap_3
X_5684_ _5683_/A _5683_/B _5784_/S vssd1 vssd1 vccd1 vccd1 _5684_/Y sky130_fd_sc_hd__o21ai_1
XFILLER_0_71_131 vssd1 vssd1 vccd1 vccd1 sky130_fd_sc_hd__fill_1
XFILLER_0_71_120 vssd1 vssd1 vccd1 vccd1 sky130_fd_sc_hd__fill_2
XFILLER_0_60_85 vssd1 vssd1 vccd1 vccd1 sky130_fd_sc_hd__decap_4
X_4635_ _4635_/A _4635_/B vssd1 vssd1 vccd1 vccd1 _4667_/A sky130_fd_sc_hd__xor2_1
XANTENNA__4042__B _4432_/A vssd1 vssd1 vccd1 vccd1 sky130_fd_sc_hd__diode_2
X_4566_ _4566_/A _4566_/B _4566_/C vssd1 vssd1 vccd1 vccd1 _4568_/C sky130_fd_sc_hd__nand3_1
XFILLER_0_8_53 vssd1 vssd1 vccd1 vccd1 sky130_ef_sc_hd__decap_12
X_6305_ _6788_/Q hold42/X _6319_/S vssd1 vssd1 vccd1 vccd1 hold43/A sky130_fd_sc_hd__mux2_1
XFILLER_0_69_61 vssd1 vssd1 vccd1 vccd1 sky130_fd_sc_hd__decap_4
XFILLER_0_12_264 vssd1 vssd1 vccd1 vccd1 sky130_fd_sc_hd__fill_2
XFILLER_0_8_97 vssd1 vssd1 vccd1 vccd1 sky130_ef_sc_hd__decap_12
X_3517_ _5308_/A _3870_/A _5308_/B _5277_/B vssd1 vssd1 vccd1 vccd1 _3518_/B sky130_fd_sc_hd__nand4_1
X_4497_ _4485_/A _4485_/B _4528_/A vssd1 vssd1 vccd1 vccd1 _4498_/C sky130_fd_sc_hd__a21oi_1
XFILLER_0_12_297 vssd1 vssd1 vccd1 vccd1 sky130_fd_sc_hd__fill_1
XFILLER_0_12_286 vssd1 vssd1 vccd1 vccd1 sky130_fd_sc_hd__decap_3
X_6236_ _3305_/Y _6854_/Q _6853_/Q _3306_/Y vssd1 vssd1 vccd1 vccd1 _6236_/X sky130_fd_sc_hd__a22o_1
X_3448_ _3372_/Y _3374_/X _3449_/A _3447_/Y vssd1 vssd1 vccd1 vccd1 _3585_/A sky130_fd_sc_hd__a211oi_2
X_6167_ _6788_/Q hold22/A vssd1 vssd1 vccd1 vccd1 _6168_/B sky130_fd_sc_hd__nor2_1
XTAP_971 vssd1 vccd1 sky130_fd_sc_hd__tapvpwrvgnd_1
XTAP_960 vssd1 vccd1 sky130_fd_sc_hd__tapvpwrvgnd_1
X_3379_ _5306_/A _5049_/B _5272_/B _5286_/B vssd1 vssd1 vccd1 vccd1 _3379_/X sky130_fd_sc_hd__and4_1
XTAP_993 vssd1 vccd1 sky130_fd_sc_hd__tapvpwrvgnd_1
XTAP_982 vssd1 vccd1 sky130_fd_sc_hd__tapvpwrvgnd_1
X_5118_ _5754_/B _5118_/B vssd1 vssd1 vccd1 vccd1 _5137_/B sky130_fd_sc_hd__nand2_1
X_6098_ _6637_/Q hold246/X _6098_/S vssd1 vssd1 vccd1 vccd1 _6098_/X sky130_fd_sc_hd__mux2_1
X_5049_ _5049_/A _5049_/B _6677_/Q _5049_/D vssd1 vssd1 vccd1 vccd1 _5051_/C sky130_fd_sc_hd__nand4_4
XFILLER_0_94_201 vssd1 vssd1 vccd1 vccd1 sky130_fd_sc_hd__fill_1
XFILLER_0_94_234 vssd1 vssd1 vccd1 vccd1 sky130_fd_sc_hd__decap_3
XFILLER_0_79_286 vssd1 vssd1 vccd1 vccd1 sky130_fd_sc_hd__fill_2
XFILLER_0_54_109 vssd1 vssd1 vccd1 vccd1 sky130_fd_sc_hd__fill_2
XFILLER_0_47_150 vssd1 vssd1 vccd1 vccd1 sky130_fd_sc_hd__decap_3
XFILLER_0_47_161 vssd1 vssd1 vccd1 vccd1 sky130_fd_sc_hd__fill_2
XFILLER_0_35_334 vssd1 vssd1 vccd1 vccd1 sky130_fd_sc_hd__fill_2
XFILLER_0_50_315 vssd1 vssd1 vccd1 vccd1 sky130_fd_sc_hd__decap_3
XFILLER_0_62_153 vssd1 vssd1 vccd1 vccd1 sky130_fd_sc_hd__fill_2
XFILLER_0_120_203 vssd1 vssd1 vccd1 vccd1 sky130_fd_sc_hd__fill_2
XFILLER_0_105_277 vssd1 vssd1 vccd1 vccd1 sky130_fd_sc_hd__decap_3
XFILLER_0_62_197 vssd1 vssd1 vccd1 vccd1 sky130_fd_sc_hd__fill_1
XFILLER_0_120_258 vssd1 vssd1 vccd1 vccd1 sky130_fd_sc_hd__fill_2
XANTENNA__5064__A _5106_/A vssd1 vssd1 vccd1 vccd1 sky130_fd_sc_hd__diode_2
XFILLER_0_105_14 vssd1 vssd1 vccd1 vccd1 sky130_fd_sc_hd__fill_1
XANTENNA__4127__B _4488_/A vssd1 vssd1 vccd1 vccd1 sky130_fd_sc_hd__diode_2
XANTENNA__6749__SET_B fanout140/X vssd1 vssd1 vccd1 vccd1 sky130_fd_sc_hd__diode_2
XFILLER_0_128_314 vssd1 vssd1 vccd1 vccd1 sky130_fd_sc_hd__fill_2
XFILLER_0_105_69 vssd1 vssd1 vccd1 vccd1 sky130_fd_sc_hd__fill_2
XPHY_270 vssd1 vssd1 vccd1 vccd1 sky130_fd_sc_hd__decap_3
XFILLER_0_14_89 vssd1 vssd1 vccd1 vccd1 sky130_fd_sc_hd__fill_1
XANTENNA__4143__A _4476_/D vssd1 vssd1 vccd1 vccd1 sky130_fd_sc_hd__diode_2
XFILLER_0_38_183 vssd1 vssd1 vccd1 vccd1 sky130_fd_sc_hd__fill_1
XFILLER_0_136_380 vssd1 vssd1 vccd1 vccd1 sky130_ef_sc_hd__decap_12
XFILLER_0_121_57 vssd1 vssd1 vccd1 vccd1 sky130_fd_sc_hd__fill_2
XFILLER_0_30_33 vssd1 vssd1 vccd1 vccd1 sky130_fd_sc_hd__fill_1
XFILLER_0_30_44 vssd1 vssd1 vccd1 vccd1 sky130_fd_sc_hd__decap_3
XFILLER_0_53_164 vssd1 vssd1 vccd1 vccd1 sky130_fd_sc_hd__fill_2
X_4420_ _4414_/A _4414_/C _4414_/B vssd1 vssd1 vccd1 vccd1 _4420_/X sky130_fd_sc_hd__o21a_1
XFILLER_0_30_77 vssd1 vssd1 vccd1 vccd1 sky130_fd_sc_hd__fill_1
XFILLER_0_41_337 vssd1 vssd1 vccd1 vccd1 sky130_fd_sc_hd__fill_1
XFILLER_0_111_225 vssd1 vssd1 vccd1 vccd1 sky130_fd_sc_hd__fill_2
X_4351_ _6632_/Q _4407_/B vssd1 vssd1 vccd1 vccd1 _4409_/A sky130_fd_sc_hd__nand2_1
X_3302_ _6857_/Q vssd1 vssd1 vccd1 vccd1 _3302_/Y sky130_fd_sc_hd__inv_2
X_4282_ _4281_/A _4281_/C _4281_/B vssd1 vssd1 vccd1 vccd1 _4283_/C sky130_fd_sc_hd__a21o_1
X_6021_ tex_height_i[12] _6021_/B vssd1 vssd1 vccd1 vccd1 _6022_/C sky130_fd_sc_hd__nand2_1
XFILLER_0_39_86 vssd1 vssd1 vccd1 vccd1 sky130_fd_sc_hd__decap_4
XTAP_278 vssd1 vccd1 sky130_fd_sc_hd__tapvpwrvgnd_1
XTAP_289 vssd1 vccd1 sky130_fd_sc_hd__tapvpwrvgnd_1
XFILLER_0_55_74 vssd1 vssd1 vccd1 vccd1 sky130_fd_sc_hd__fill_1
XFILLER_0_55_85 vssd1 vssd1 vccd1 vccd1 sky130_fd_sc_hd__decap_4
X_6923_ vssd1 vssd1 vccd1 vccd1 _6923_/HI pix_mport_o[24] sky130_fd_sc_hd__conb_1
XANTENNA__5848__S _5922_/S vssd1 vssd1 vccd1 vccd1 sky130_fd_sc_hd__diode_2
XFILLER_0_119_314 vssd1 vssd1 vccd1 vccd1 sky130_fd_sc_hd__fill_2
Xfanout16 _6465_/S vssd1 vssd1 vccd1 vccd1 _6472_/S sky130_fd_sc_hd__clkbuf_8
X_6854_ _6855_/CLK _6854_/D vssd1 vssd1 vccd1 vccd1 _6854_/Q sky130_fd_sc_hd__dfxtp_1
Xfanout27 _6061_/S vssd1 vssd1 vccd1 vccd1 _6037_/S sky130_fd_sc_hd__clkbuf_8
Xfanout38 _6682_/Q vssd1 vssd1 vccd1 vccd1 _5272_/B sky130_fd_sc_hd__buf_4
XFILLER_0_119_369 vssd1 vssd1 vccd1 vccd1 sky130_fd_sc_hd__fill_1
X_6785_ _6802_/CLK hold56/X vssd1 vssd1 vccd1 vccd1 _6785_/Q sky130_fd_sc_hd__dfxtp_2
Xfanout49 _5049_/D vssd1 vssd1 vccd1 vccd1 _3961_/A sky130_fd_sc_hd__buf_4
X_3997_ _3996_/A _3996_/Y _3927_/Y _3940_/X vssd1 vssd1 vccd1 vccd1 _4013_/A sky130_fd_sc_hd__a211oi_4
X_5805_ _5803_/B _5803_/C _5803_/D tex_addr_i[15] vssd1 vssd1 vccd1 vccd1 _5812_/B
+ sky130_fd_sc_hd__o31a_1
X_5736_ _5736_/A vssd1 vssd1 vccd1 vccd1 _5738_/A sky130_fd_sc_hd__inv_2
XFILLER_0_17_345 vssd1 vssd1 vccd1 vccd1 sky130_fd_sc_hd__fill_1
XANTENNA__3595__C _5277_/B vssd1 vssd1 vccd1 vccd1 sky130_fd_sc_hd__diode_2
XFILLER_0_44_131 vssd1 vssd1 vccd1 vccd1 sky130_fd_sc_hd__fill_2
XFILLER_0_127_391 vssd1 vssd1 vccd1 vccd1 sky130_fd_sc_hd__fill_1
X_5667_ _5687_/C _5667_/B vssd1 vssd1 vccd1 vccd1 _5667_/Y sky130_fd_sc_hd__nand2_1
XFILLER_0_44_153 vssd1 vssd1 vccd1 vccd1 sky130_fd_sc_hd__decap_4
X_4618_ _4638_/A _4658_/D _4616_/B _4614_/X vssd1 vssd1 vccd1 vccd1 _4621_/A sky130_fd_sc_hd__a31o_1
XFILLER_0_4_250 vssd1 vssd1 vccd1 vccd1 sky130_fd_sc_hd__fill_2
X_5598_ _5440_/X tex_mport_o[61] _5598_/S vssd1 vssd1 vccd1 vccd1 _6618_/D sky130_fd_sc_hd__mux2_1
XANTENNA__3714__A1 _5081_/B vssd1 vssd1 vccd1 vccd1 sky130_fd_sc_hd__diode_2
XFILLER_0_4_294 vssd1 vssd1 vccd1 vccd1 sky130_fd_sc_hd__fill_2
X_4549_ _4541_/A _4541_/C _4541_/B vssd1 vssd1 vccd1 vccd1 _4574_/B sky130_fd_sc_hd__a21oi_1
X_6219_ _6218_/A _6218_/B _6224_/B vssd1 vssd1 vccd1 vccd1 _6219_/Y sky130_fd_sc_hd__o21ai_1
XANTENNA_fanout69_A _4971_/B vssd1 vssd1 vccd1 vccd1 sky130_fd_sc_hd__diode_2
XTAP_790 vssd1 vccd1 sky130_fd_sc_hd__tapvpwrvgnd_1
XFILLER_0_82_226 vssd1 vssd1 vccd1 vccd1 sky130_fd_sc_hd__decap_4
XFILLER_0_35_164 vssd1 vssd1 vccd1 vccd1 sky130_fd_sc_hd__fill_2
XFILLER_0_23_359 vssd1 vssd1 vccd1 vccd1 sky130_fd_sc_hd__fill_1
XFILLER_0_116_35 vssd1 vssd1 vccd1 vccd1 sky130_fd_sc_hd__decap_4
XFILLER_0_116_79 vssd1 vssd1 vccd1 vccd1 sky130_fd_sc_hd__fill_2
X_3920_ _3920_/A _3920_/B vssd1 vssd1 vccd1 vccd1 _3923_/B sky130_fd_sc_hd__xnor2_1
XANTENNA__3977__A _5049_/A vssd1 vssd1 vccd1 vccd1 sky130_fd_sc_hd__diode_2
XANTENNA__6353__A hold60/A vssd1 vssd1 vccd1 vccd1 sky130_fd_sc_hd__diode_2
XFILLER_0_58_245 vssd1 vssd1 vccd1 vccd1 sky130_fd_sc_hd__decap_6
X_3851_ _3852_/B _3852_/A vssd1 vssd1 vccd1 vccd1 _3851_/Y sky130_fd_sc_hd__nand2b_1
XFILLER_0_41_32 vssd1 vssd1 vccd1 vccd1 sky130_fd_sc_hd__fill_1
X_6570_ _6862_/CLK _6570_/D _6320_/C vssd1 vssd1 vccd1 vccd1 depth_mport_o[14] sky130_fd_sc_hd__dfrtp_4
X_3782_ _3735_/A _3735_/B _3735_/C vssd1 vssd1 vccd1 vccd1 _3782_/X sky130_fd_sc_hd__o21a_1
X_5521_ hold44/X sstream_i[112] _6472_/S vssd1 vssd1 vccd1 vccd1 _6554_/D sky130_fd_sc_hd__mux2_1
XFILLER_0_81_270 vssd1 vssd1 vccd1 vccd1 sky130_fd_sc_hd__fill_2
XFILLER_0_14_348 vssd1 vssd1 vccd1 vccd1 sky130_fd_sc_hd__fill_2
XFILLER_0_26_197 vssd1 vssd1 vccd1 vccd1 sky130_fd_sc_hd__fill_1
XFILLER_0_124_372 vssd1 vssd1 vccd1 vccd1 sky130_ef_sc_hd__decap_12
X_5452_ _5451_/B _5451_/C _6749_/Q vssd1 vssd1 vccd1 vccd1 _5452_/Y sky130_fd_sc_hd__a21oi_1
XFILLER_0_41_167 vssd1 vssd1 vccd1 vccd1 sky130_fd_sc_hd__fill_1
X_5383_ _5383_/A _5383_/B _5383_/C vssd1 vssd1 vccd1 vccd1 _5387_/A sky130_fd_sc_hd__and3_1
X_4403_ _4403_/A _4403_/B vssd1 vssd1 vccd1 vccd1 _4449_/B sky130_fd_sc_hd__xnor2_1
XFILLER_0_22_370 vssd1 vssd1 vccd1 vccd1 sky130_fd_sc_hd__fill_2
XANTENNA__4958__D _5081_/D vssd1 vssd1 vccd1 vccd1 sky130_fd_sc_hd__diode_2
X_4334_ _4334_/A _4334_/B vssd1 vssd1 vccd1 vccd1 _4335_/B sky130_fd_sc_hd__nor2_1
XFILLER_0_1_297 vssd1 vssd1 vccd1 vccd1 sky130_fd_sc_hd__fill_2
X_4265_ _4063_/A _4063_/C _4063_/B vssd1 vssd1 vccd1 vccd1 _4271_/B sky130_fd_sc_hd__a21o_1
X_6004_ _6008_/B _6004_/B vssd1 vssd1 vccd1 vccd1 _6004_/Y sky130_fd_sc_hd__nand2_1
XFILLER_0_66_73 vssd1 vssd1 vccd1 vccd1 sky130_fd_sc_hd__decap_3
X_4196_ _4196_/A _4196_/B _4196_/C vssd1 vssd1 vccd1 vccd1 _4203_/A sky130_fd_sc_hd__nand3_2
XTAP_1219 vssd1 vccd1 sky130_fd_sc_hd__tapvpwrvgnd_1
XTAP_1208 vssd1 vccd1 sky130_fd_sc_hd__tapvpwrvgnd_1
XFILLER_0_49_223 vssd1 vssd1 vccd1 vccd1 sky130_fd_sc_hd__fill_1
X_6906_ vssd1 vssd1 vccd1 vccd1 _6906_/HI depth_mport_o[67] sky130_fd_sc_hd__conb_1
X_6837_ _6855_/CLK _6837_/D vssd1 vssd1 vccd1 vccd1 _6837_/Q sky130_fd_sc_hd__dfxtp_1
XFILLER_0_64_248 vssd1 vssd1 vccd1 vccd1 sky130_fd_sc_hd__decap_4
XFILLER_0_9_375 vssd1 vssd1 vccd1 vccd1 sky130_ef_sc_hd__decap_12
X_6768_ _6830_/CLK _6768_/D fanout150/X vssd1 vssd1 vccd1 vccd1 pix_mport_o[40] sky130_fd_sc_hd__dfrtp_4
XFILLER_0_134_147 vssd1 vssd1 vccd1 vccd1 sky130_fd_sc_hd__fill_2
XFILLER_0_122_309 vssd1 vssd1 vccd1 vccd1 sky130_fd_sc_hd__fill_2
X_6699_ _6830_/CLK hold10/X vssd1 vssd1 vccd1 vccd1 hold9/A sky130_fd_sc_hd__dfxtp_1
X_5719_ _5718_/B _5718_/C _5718_/A vssd1 vssd1 vccd1 vccd1 _5720_/B sky130_fd_sc_hd__o21ai_1
XFILLER_0_72_281 vssd1 vssd1 vccd1 vccd1 sky130_fd_sc_hd__fill_1
XFILLER_0_32_101 vssd1 vssd1 vccd1 vccd1 sky130_fd_sc_hd__fill_1
XFILLER_0_115_372 vssd1 vssd1 vccd1 vccd1 sky130_fd_sc_hd__fill_1
XFILLER_0_115_361 vssd1 vssd1 vccd1 vccd1 sky130_fd_sc_hd__decap_3
XANTENNA__5688__A1 _5687_/B vssd1 vssd1 vccd1 vccd1 sky130_fd_sc_hd__diode_2
Xhold260 _6728_/Q vssd1 vssd1 vccd1 vccd1 hold260/X sky130_fd_sc_hd__dlygate4sd3_1
Xhold271 _6647_/Q vssd1 vssd1 vccd1 vccd1 hold271/X sky130_fd_sc_hd__dlygate4sd3_1
Xhold293 _6623_/Q vssd1 vssd1 vccd1 vccd1 hold293/X sky130_fd_sc_hd__dlygate4sd3_1
Xhold282 _6641_/Q vssd1 vssd1 vccd1 vccd1 hold282/X sky130_fd_sc_hd__dlygate4sd3_1
Xclkbuf_leaf_9_clk_i clkbuf_leaf_9_clk_i/A vssd1 vssd1 vccd1 vccd1 _6812_/CLK sky130_fd_sc_hd__clkbuf_16
XFILLER_0_99_134 vssd1 vssd1 vccd1 vccd1 sky130_fd_sc_hd__decap_4
XANTENNA_100 sstream_i[5] vssd1 vssd1 vccd1 vccd1 sky130_fd_sc_hd__diode_2
XFILLER_0_99_167 vssd1 vssd1 vccd1 vccd1 sky130_fd_sc_hd__fill_1
XANTENNA_111 sstream_i[8] vssd1 vssd1 vccd1 vccd1 sky130_fd_sc_hd__diode_2
XANTENNA_133 tex_addr_i[3] vssd1 vssd1 vccd1 vccd1 sky130_fd_sc_hd__diode_2
XANTENNA_122 tex_addr_i[11] vssd1 vssd1 vccd1 vccd1 sky130_fd_sc_hd__diode_2
XANTENNA_155 sstream_i[28] vssd1 vssd1 vccd1 vccd1 sky130_fd_sc_hd__diode_2
XANTENNA_144 tex_width_i[0] vssd1 vssd1 vccd1 vccd1 sky130_fd_sc_hd__diode_2
XFILLER_0_102_37 vssd1 vssd1 vccd1 vccd1 sky130_fd_sc_hd__fill_2
XFILLER_0_63_281 vssd1 vssd1 vccd1 vccd1 sky130_fd_sc_hd__fill_2
XFILLER_0_11_57 vssd1 vssd1 vccd1 vccd1 sky130_ef_sc_hd__decap_12
XFILLER_0_121_342 vssd1 vssd1 vccd1 vccd1 sky130_fd_sc_hd__fill_2
XANTENNA__4778__D _4966_/C vssd1 vssd1 vccd1 vccd1 sky130_fd_sc_hd__diode_2
XFILLER_0_121_386 vssd1 vssd1 vccd1 vccd1 sky130_fd_sc_hd__decap_6
XANTENNA_clkbuf_leaf_16_clk_i_A clkbuf_2_3__f_clk_i/X vssd1 vssd1 vccd1 vccd1 sky130_fd_sc_hd__diode_2
XANTENNA__4794__C _4942_/B vssd1 vssd1 vccd1 vccd1 sky130_fd_sc_hd__diode_2
X_4050_ _5311_/A _4433_/D vssd1 vssd1 vccd1 vccd1 _4052_/B sky130_fd_sc_hd__and2_1
X_4952_ _5059_/B _4951_/C _4951_/A vssd1 vssd1 vccd1 vccd1 _4952_/X sky130_fd_sc_hd__a21o_1
XANTENNA__4315__B _4841_/D vssd1 vssd1 vccd1 vccd1 sky130_fd_sc_hd__diode_2
X_3903_ _3895_/A _3901_/A _3895_/B _3902_/X vssd1 vssd1 vccd1 vccd1 _3936_/A sky130_fd_sc_hd__a31oi_1
XFILLER_0_52_53 vssd1 vssd1 vccd1 vccd1 sky130_fd_sc_hd__fill_1
X_4883_ _4754_/X _4761_/Y _4898_/A _4760_/A vssd1 vssd1 vccd1 vccd1 _4884_/B sky130_fd_sc_hd__o211ai_1
X_6622_ _6841_/CLK _6622_/D fanout145/X vssd1 vssd1 vccd1 vccd1 _6622_/Q sky130_fd_sc_hd__dfstp_1
X_3834_ _3835_/A _3835_/B _3835_/C vssd1 vssd1 vccd1 vccd1 _3846_/A sky130_fd_sc_hd__o21ai_4
X_6553_ _6862_/CLK _6553_/D vssd1 vssd1 vccd1 vccd1 _6553_/Q sky130_fd_sc_hd__dfxtp_1
XFILLER_0_104_309 vssd1 vssd1 vccd1 vccd1 sky130_fd_sc_hd__decap_3
X_3765_ _3765_/A _3848_/A vssd1 vssd1 vccd1 vccd1 _3770_/A sky130_fd_sc_hd__nand2_1
X_5504_ hold50/X sstream_i[95] _6464_/S vssd1 vssd1 vccd1 vccd1 _6537_/D sky130_fd_sc_hd__mux2_1
XANTENNA__4590__A1 _5666_/A vssd1 vssd1 vccd1 vccd1 sky130_fd_sc_hd__diode_2
XANTENNA__4331__A _4638_/A vssd1 vssd1 vccd1 vccd1 sky130_fd_sc_hd__diode_2
X_3696_ _3620_/C _3623_/X _3680_/Y _3703_/A vssd1 vssd1 vccd1 vccd1 _3696_/X sky130_fd_sc_hd__o211a_1
X_6484_ hold224/X sstream_i[42] _6486_/S vssd1 vssd1 vccd1 vccd1 _6875_/D sky130_fd_sc_hd__mux2_1
XANTENNA__4050__B _4433_/D vssd1 vssd1 vccd1 vccd1 sky130_fd_sc_hd__diode_2
XANTENNA_fanout119_A _4832_/C vssd1 vssd1 vccd1 vccd1 sky130_fd_sc_hd__diode_2
X_5435_ _5436_/B _5436_/C _6747_/Q vssd1 vssd1 vccd1 vccd1 _5435_/Y sky130_fd_sc_hd__a21oi_1
XFILLER_0_65_3 vssd1 vssd1 vccd1 vccd1 sky130_fd_sc_hd__decap_4
XANTENNA__5861__S _5923_/S vssd1 vssd1 vccd1 vccd1 sky130_fd_sc_hd__diode_2
X_5366_ _5366_/A _5366_/B vssd1 vssd1 vccd1 vccd1 _5384_/B sky130_fd_sc_hd__xor2_2
X_4317_ _4314_/X _4317_/B vssd1 vssd1 vccd1 vccd1 _4387_/B sky130_fd_sc_hd__and2b_1
X_5297_ _5276_/A _5286_/B _5296_/X vssd1 vssd1 vccd1 vccd1 _5297_/X sky130_fd_sc_hd__a21bo_1
X_4248_ _4082_/X _4090_/Y _4246_/X _4247_/Y vssd1 vssd1 vccd1 vccd1 _4248_/Y sky130_fd_sc_hd__a211oi_4
X_4179_ _4731_/B _4177_/X _4171_/X _4199_/A vssd1 vssd1 vccd1 vccd1 _4180_/B sky130_fd_sc_hd__a211o_1
XTAP_1038 vssd1 vccd1 sky130_fd_sc_hd__tapvpwrvgnd_1
XTAP_1027 vssd1 vccd1 sky130_fd_sc_hd__tapvpwrvgnd_1
XTAP_1016 vssd1 vccd1 sky130_fd_sc_hd__tapvpwrvgnd_1
XTAP_1005 vssd1 vccd1 sky130_fd_sc_hd__tapvpwrvgnd_1
XTAP_1049 vssd1 vccd1 sky130_fd_sc_hd__tapvpwrvgnd_1
XFILLER_0_77_373 vssd1 vssd1 vccd1 vccd1 sky130_ef_sc_hd__decap_12
XFILLER_0_37_204 vssd1 vssd1 vccd1 vccd1 sky130_fd_sc_hd__decap_3
XANTENNA__5070__A2 _5656_/A vssd1 vssd1 vccd1 vccd1 sky130_fd_sc_hd__diode_2
XFILLER_0_92_332 vssd1 vssd1 vccd1 vccd1 sky130_fd_sc_hd__decap_3
XFILLER_0_37_248 vssd1 vssd1 vccd1 vccd1 sky130_fd_sc_hd__fill_1
XFILLER_0_92_365 vssd1 vssd1 vccd1 vccd1 sky130_ef_sc_hd__decap_12
XANTENNA__6440__B _6440_/B vssd1 vssd1 vccd1 vccd1 sky130_fd_sc_hd__diode_2
XFILLER_0_45_281 vssd1 vssd1 vccd1 vccd1 sky130_fd_sc_hd__decap_3
XFILLER_0_60_240 vssd1 vssd1 vccd1 vccd1 sky130_ef_sc_hd__decap_12
XFILLER_0_103_364 vssd1 vssd1 vccd1 vccd1 sky130_ef_sc_hd__decap_12
XFILLER_0_73_19 vssd1 vssd1 vccd1 vccd1 sky130_fd_sc_hd__fill_1
XFILLER_0_87_104 vssd1 vssd1 vccd1 vccd1 sky130_fd_sc_hd__decap_3
XFILLER_0_68_362 vssd1 vssd1 vccd1 vccd1 sky130_fd_sc_hd__fill_2
XPHY_90 vssd1 vssd1 vccd1 vccd1 sky130_fd_sc_hd__decap_3
XFILLER_0_22_45 vssd1 vssd1 vccd1 vccd1 sky130_fd_sc_hd__fill_2
XFILLER_0_83_387 vssd1 vssd1 vccd1 vccd1 sky130_fd_sc_hd__decap_4
XFILLER_0_113_117 vssd1 vssd1 vccd1 vccd1 sky130_fd_sc_hd__fill_2
X_3550_ _3961_/A _5300_/A _3548_/B _3546_/X vssd1 vssd1 vccd1 vccd1 _3552_/B sky130_fd_sc_hd__a31o_1
XANTENNA__4789__C _4789_/C vssd1 vssd1 vccd1 vccd1 sky130_fd_sc_hd__diode_2
XANTENNA__4151__A _4736_/B vssd1 vssd1 vccd1 vccd1 sky130_fd_sc_hd__diode_2
XFILLER_0_3_337 vssd1 vssd1 vccd1 vccd1 sky130_fd_sc_hd__fill_1
XFILLER_0_3_359 vssd1 vssd1 vccd1 vccd1 sky130_fd_sc_hd__fill_2
XFILLER_0_51_273 vssd1 vssd1 vccd1 vccd1 sky130_fd_sc_hd__fill_2
XFILLER_0_121_150 vssd1 vssd1 vccd1 vccd1 sky130_fd_sc_hd__fill_2
XFILLER_0_11_126 vssd1 vssd1 vccd1 vccd1 sky130_fd_sc_hd__fill_2
X_3481_ _5051_/A _6688_/Q vssd1 vssd1 vccd1 vccd1 _3482_/B sky130_fd_sc_hd__nand2_1
X_5220_ _5252_/A _5218_/Y _5111_/X _5113_/Y vssd1 vssd1 vccd1 vccd1 _5220_/X sky130_fd_sc_hd__o211a_1
X_5151_ _5139_/A _5139_/C _5139_/B vssd1 vssd1 vccd1 vccd1 _5153_/B sky130_fd_sc_hd__a21o_1
X_4102_ _4102_/A _4102_/B vssd1 vssd1 vccd1 vccd1 _4104_/B sky130_fd_sc_hd__nand2_1
X_5082_ _5081_/A _5081_/C _5081_/D _5081_/B vssd1 vssd1 vccd1 vccd1 _5083_/D sky130_fd_sc_hd__a22o_1
X_4033_ _4842_/A _5718_/A _4841_/D _5732_/A vssd1 vssd1 vccd1 vccd1 _4033_/X sky130_fd_sc_hd__a22o_1
XANTENNA__4326__A _5311_/A vssd1 vssd1 vccd1 vccd1 sky130_fd_sc_hd__diode_2
XFILLER_0_78_137 vssd1 vssd1 vccd1 vccd1 sky130_fd_sc_hd__decap_3
XFILLER_0_2_77 vssd1 vssd1 vccd1 vccd1 sky130_fd_sc_hd__decap_6
XANTENNA__4971__D _4971_/D vssd1 vssd1 vccd1 vccd1 sky130_fd_sc_hd__diode_2
XFILLER_0_93_118 vssd1 vssd1 vccd1 vccd1 sky130_fd_sc_hd__decap_3
XFILLER_0_19_215 vssd1 vssd1 vccd1 vccd1 sky130_fd_sc_hd__fill_2
XANTENNA__5052__A2 _6678_/Q vssd1 vssd1 vccd1 vccd1 sky130_fd_sc_hd__diode_2
X_5984_ _5983_/Y hold137/X _6038_/C vssd1 vssd1 vccd1 vccd1 _5984_/X sky130_fd_sc_hd__mux2_1
XFILLER_0_86_192 vssd1 vssd1 vccd1 vccd1 sky130_fd_sc_hd__fill_2
XANTENNA__5856__S _5923_/S vssd1 vssd1 vccd1 vccd1 sky130_fd_sc_hd__diode_2
X_4935_ _4935_/A _4935_/B vssd1 vssd1 vccd1 vccd1 _4993_/A sky130_fd_sc_hd__xnor2_1
XANTENNA_11 sstream_i[10] vssd1 vssd1 vccd1 vccd1 sky130_fd_sc_hd__diode_2
XANTENNA_22 sstream_i[12] vssd1 vssd1 vccd1 vccd1 sky130_fd_sc_hd__diode_2
X_4866_ _4866_/A _4866_/B vssd1 vssd1 vccd1 vccd1 _4869_/B sky130_fd_sc_hd__xnor2_2
XANTENNA_33 sstream_i[14] vssd1 vssd1 vccd1 vccd1 sky130_fd_sc_hd__diode_2
XANTENNA_55 sstream_i[18] vssd1 vssd1 vccd1 vccd1 sky130_fd_sc_hd__diode_2
XANTENNA_66 sstream_i[22] vssd1 vssd1 vccd1 vccd1 sky130_fd_sc_hd__diode_2
XANTENNA_44 sstream_i[16] vssd1 vssd1 vccd1 vccd1 sky130_fd_sc_hd__diode_2
X_6605_ _6751_/CLK _6605_/D _5937_/A vssd1 vssd1 vccd1 vccd1 tex_mport_o[48] sky130_fd_sc_hd__dfrtp_4
XFILLER_0_6_153 vssd1 vssd1 vccd1 vccd1 sky130_fd_sc_hd__fill_2
X_3817_ _3735_/Y _3782_/X _3800_/Y _3815_/X vssd1 vssd1 vccd1 vccd1 _3838_/B sky130_fd_sc_hd__o211ai_4
XFILLER_0_27_281 vssd1 vssd1 vccd1 vccd1 sky130_fd_sc_hd__fill_1
X_4797_ _4796_/B _4796_/C _4796_/A vssd1 vssd1 vccd1 vccd1 _4800_/B sky130_fd_sc_hd__a21o_1
XANTENNA_88 sstream_i[31] vssd1 vssd1 vccd1 vccd1 sky130_fd_sc_hd__diode_2
XANTENNA_77 sstream_i[29] vssd1 vssd1 vccd1 vccd1 sky130_fd_sc_hd__diode_2
XANTENNA_99 sstream_i[5] vssd1 vssd1 vccd1 vccd1 sky130_fd_sc_hd__diode_2
X_6536_ _6855_/CLK _6536_/D vssd1 vssd1 vccd1 vccd1 hold76/A sky130_fd_sc_hd__dfxtp_1
XFILLER_0_103_80 vssd1 vssd1 vccd1 vccd1 sky130_fd_sc_hd__decap_3
XANTENNA__4061__A _5311_/A vssd1 vssd1 vccd1 vccd1 sky130_fd_sc_hd__diode_2
X_3748_ _5299_/A _5276_/B _3746_/Y _3747_/X vssd1 vssd1 vccd1 vccd1 _3750_/A sky130_fd_sc_hd__o2bb2a_1
XFILLER_0_42_251 vssd1 vssd1 vccd1 vccd1 sky130_fd_sc_hd__fill_1
XFILLER_0_112_150 vssd1 vssd1 vccd1 vccd1 sky130_fd_sc_hd__fill_2
X_6467_ hold180/X sstream_i[25] _6472_/S vssd1 vssd1 vccd1 vccd1 _6858_/D sky130_fd_sc_hd__mux2_1
X_3679_ _3678_/A _3678_/Y _3612_/Y _3624_/X vssd1 vssd1 vccd1 vccd1 _3694_/A sky130_fd_sc_hd__a211oi_2
XFILLER_0_42_284 vssd1 vssd1 vccd1 vccd1 sky130_fd_sc_hd__fill_1
X_6398_ _6393_/A _6393_/B _6397_/Y vssd1 vssd1 vccd1 vccd1 _6403_/A sky130_fd_sc_hd__o21ai_1
XANTENNA__5512__A0 hold70/X vssd1 vssd1 vccd1 vccd1 sky130_fd_sc_hd__diode_2
XFILLER_0_88_93 vssd1 vssd1 vccd1 vccd1 sky130_fd_sc_hd__fill_2
XFILLER_0_2_381 vssd1 vssd1 vccd1 vccd1 sky130_ef_sc_hd__decap_12
X_5418_ _5418_/A _5418_/B _5418_/C vssd1 vssd1 vccd1 vccd1 _5418_/X sky130_fd_sc_hd__and3_1
X_5349_ _6742_/Q _5445_/C _5349_/C vssd1 vssd1 vccd1 vccd1 _5349_/X sky130_fd_sc_hd__and3_1
XANTENNA__6068__A1 _6551_/Q vssd1 vssd1 vccd1 vccd1 sky130_fd_sc_hd__diode_2
XFILLER_0_100_389 vssd1 vssd1 vccd1 vccd1 sky130_ef_sc_hd__decap_12
XANTENNA__4618__A2 _4658_/D vssd1 vssd1 vccd1 vccd1 sky130_fd_sc_hd__diode_2
XANTENNA_fanout51_A _5083_/A vssd1 vssd1 vccd1 vccd1 sky130_fd_sc_hd__diode_2
Xclkbuf_leaf_12_clk_i clkbuf_2_3__f_clk_i/X vssd1 vssd1 vccd1 vccd1 _6818_/CLK sky130_fd_sc_hd__clkbuf_16
XFILLER_0_108_401 vssd1 vssd1 vccd1 vccd1 sky130_fd_sc_hd__decap_6
XFILLER_0_77_192 vssd1 vssd1 vccd1 vccd1 sky130_fd_sc_hd__fill_1
XFILLER_0_65_332 vssd1 vssd1 vccd1 vccd1 sky130_fd_sc_hd__fill_2
XFILLER_0_135_220 vssd1 vssd1 vccd1 vccd1 sky130_fd_sc_hd__fill_2
XFILLER_0_65_365 vssd1 vssd1 vccd1 vccd1 sky130_ef_sc_hd__decap_12
Xclkbuf_leaf_27_clk_i clkbuf_leaf_1_clk_i/A vssd1 vssd1 vccd1 vccd1 _6677_/CLK sky130_fd_sc_hd__clkbuf_16
XANTENNA__3794__B _5081_/B vssd1 vssd1 vccd1 vccd1 sky130_fd_sc_hd__diode_2
XANTENNA__5751__B1 _5796_/A vssd1 vssd1 vccd1 vccd1 sky130_fd_sc_hd__diode_2
XFILLER_0_33_273 vssd1 vssd1 vccd1 vccd1 sky130_fd_sc_hd__decap_6
XFILLER_0_0_307 vssd1 vssd1 vccd1 vccd1 sky130_fd_sc_hd__fill_1
XTAP_608 vssd1 vccd1 sky130_fd_sc_hd__tapvpwrvgnd_1
XTAP_619 vssd1 vccd1 sky130_fd_sc_hd__tapvpwrvgnd_1
XANTENNA__6345__B hold75/A vssd1 vssd1 vccd1 vccd1 sky130_fd_sc_hd__diode_2
XFILLER_0_75_118 vssd1 vssd1 vccd1 vccd1 sky130_fd_sc_hd__fill_2
XFILLER_0_33_11 vssd1 vssd1 vccd1 vccd1 sky130_fd_sc_hd__decap_3
XFILLER_0_68_192 vssd1 vssd1 vccd1 vccd1 sky130_fd_sc_hd__fill_2
XANTENNA__3985__A _5093_/A vssd1 vssd1 vccd1 vccd1 sky130_fd_sc_hd__diode_2
XFILLER_0_33_55 vssd1 vssd1 vccd1 vccd1 sky130_fd_sc_hd__fill_1
XANTENNA__3596__A2 _5277_/B vssd1 vssd1 vccd1 vccd1 sky130_fd_sc_hd__diode_2
XANTENNA__5990__A0 _4971_/B vssd1 vssd1 vccd1 vccd1 sky130_fd_sc_hd__diode_2
X_4720_ _4432_/A _5049_/D _4719_/B _4716_/X vssd1 vssd1 vccd1 vccd1 _4723_/A sky130_fd_sc_hd__a31o_1
XFILLER_0_126_242 vssd1 vssd1 vccd1 vccd1 sky130_fd_sc_hd__fill_1
XFILLER_0_123_3 vssd1 vssd1 vccd1 vccd1 sky130_fd_sc_hd__fill_2
X_4651_ _4664_/A _4664_/B vssd1 vssd1 vccd1 vccd1 _4667_/C sky130_fd_sc_hd__nor2_1
XFILLER_0_83_184 vssd1 vssd1 vccd1 vccd1 sky130_fd_sc_hd__decap_4
XFILLER_0_83_173 vssd1 vssd1 vccd1 vccd1 sky130_fd_sc_hd__fill_2
XFILLER_0_71_368 vssd1 vssd1 vccd1 vccd1 sky130_fd_sc_hd__fill_2
X_3602_ _3602_/A _3602_/B vssd1 vssd1 vccd1 vccd1 _3626_/B sky130_fd_sc_hd__xnor2_1
XFILLER_0_126_297 vssd1 vssd1 vccd1 vccd1 sky130_fd_sc_hd__fill_1
X_4582_ _5645_/A _5645_/B _4614_/C _4582_/D vssd1 vssd1 vccd1 vccd1 _4582_/X sky130_fd_sc_hd__and4_1
X_6321_ _3265_/Y hold204/X _6231_/X _6807_/Q _6320_/X vssd1 vssd1 vccd1 vccd1 _6322_/S
+ sky130_fd_sc_hd__o221a_1
XANTENNA__6636__SET_B fanout140/X vssd1 vssd1 vccd1 vccd1 sky130_fd_sc_hd__diode_2
X_3533_ _3531_/B _3545_/B _3531_/A vssd1 vssd1 vccd1 vccd1 _3533_/X sky130_fd_sc_hd__a21bo_1
X_6252_ _6252_/A _6844_/Q vssd1 vssd1 vccd1 vccd1 _6252_/X sky130_fd_sc_hd__or2_1
X_3464_ _5296_/A _5276_/A _5272_/B _5286_/B vssd1 vssd1 vccd1 vccd1 _3465_/A sky130_fd_sc_hd__and4_1
X_6183_ _6190_/B _6183_/B vssd1 vssd1 vccd1 vccd1 _6183_/Y sky130_fd_sc_hd__nand2_1
XANTENNA__4966__D _5115_/C vssd1 vssd1 vccd1 vccd1 sky130_fd_sc_hd__diode_2
X_5203_ _5203_/A _5203_/B vssd1 vssd1 vccd1 vccd1 _5238_/A sky130_fd_sc_hd__xor2_2
X_3395_ _3395_/A _3395_/B vssd1 vssd1 vccd1 vccd1 _3611_/B sky130_fd_sc_hd__or2_1
X_5134_ _3947_/A _3947_/C _3947_/B vssd1 vssd1 vccd1 vccd1 _5136_/B sky130_fd_sc_hd__a21o_1
XFILLER_0_58_85 vssd1 vssd1 vccd1 vccd1 sky130_fd_sc_hd__fill_1
X_5065_ _5065_/A _5065_/B vssd1 vssd1 vccd1 vccd1 _5067_/B sky130_fd_sc_hd__xnor2_1
XFILLER_0_74_73 vssd1 vssd1 vccd1 vccd1 sky130_fd_sc_hd__fill_2
XFILLER_0_28_3 vssd1 vssd1 vccd1 vccd1 sky130_fd_sc_hd__decap_8
X_4016_ _4007_/X _4009_/Y _4017_/A _4015_/Y vssd1 vssd1 vccd1 vccd1 _4017_/B sky130_fd_sc_hd__a211oi_2
X_5967_ hold20/A hold19/A hold74/A hold97/A vssd1 vssd1 vccd1 vccd1 _5969_/C sky130_fd_sc_hd__or4_1
XFILLER_0_90_94 vssd1 vssd1 vccd1 vccd1 sky130_fd_sc_hd__fill_2
X_4918_ _4886_/Y _4892_/X _4904_/C _4904_/Y vssd1 vssd1 vccd1 vccd1 _4919_/C sky130_fd_sc_hd__o211ai_2
XFILLER_0_117_242 vssd1 vssd1 vccd1 vccd1 sky130_fd_sc_hd__fill_1
XFILLER_0_62_313 vssd1 vssd1 vccd1 vccd1 sky130_fd_sc_hd__fill_2
X_5898_ tex_addr_i[24] tex_addr_i[25] tex_addr_i[26] tex_addr_i[27] _5919_/B vssd1
+ vssd1 vccd1 vccd1 _5899_/A sky130_fd_sc_hd__o41a_1
X_4849_ _4847_/A _4847_/C _4847_/B vssd1 vssd1 vccd1 vccd1 _4850_/C sky130_fd_sc_hd__a21o_1
XFILLER_0_132_245 vssd1 vssd1 vccd1 vccd1 sky130_fd_sc_hd__decap_4
XFILLER_0_132_234 vssd1 vssd1 vccd1 vccd1 sky130_fd_sc_hd__fill_2
XFILLER_0_99_92 vssd1 vssd1 vccd1 vccd1 sky130_fd_sc_hd__decap_3
XFILLER_0_15_240 vssd1 vssd1 vccd1 vccd1 sky130_fd_sc_hd__fill_2
X_6519_ _6834_/CLK _6519_/D vssd1 vssd1 vccd1 vccd1 _6519_/Q sky130_fd_sc_hd__dfxtp_1
XFILLER_0_15_284 vssd1 vssd1 vccd1 vccd1 sky130_fd_sc_hd__fill_2
XFILLER_0_100_197 vssd1 vssd1 vccd1 vccd1 sky130_fd_sc_hd__decap_4
XFILLER_0_85_405 vssd1 vssd1 vccd1 vccd1 sky130_fd_sc_hd__fill_2
XFILLER_0_38_365 vssd1 vssd1 vccd1 vccd1 sky130_fd_sc_hd__decap_3
XANTENNA__4775__A1 _5115_/C vssd1 vssd1 vccd1 vccd1 sky130_fd_sc_hd__diode_2
XANTENNA__4775__B2 _4774_/B vssd1 vssd1 vccd1 vccd1 sky130_fd_sc_hd__diode_2
XANTENNA__5972__A0 _4527_/B vssd1 vssd1 vccd1 vccd1 sky130_fd_sc_hd__diode_2
XFILLER_0_65_151 vssd1 vssd1 vccd1 vccd1 sky130_fd_sc_hd__fill_2
XFILLER_0_53_313 vssd1 vssd1 vccd1 vccd1 sky130_fd_sc_hd__decap_3
XFILLER_0_123_245 vssd1 vssd1 vccd1 vccd1 sky130_fd_sc_hd__fill_2
XFILLER_0_110_15 vssd1 vssd1 vccd1 vccd1 sky130_fd_sc_hd__fill_2
XFILLER_0_80_187 vssd1 vssd1 vccd1 vccd1 sky130_fd_sc_hd__fill_2
XFILLER_0_21_221 vssd1 vssd1 vccd1 vccd1 sky130_fd_sc_hd__decap_3
XFILLER_0_61_390 vssd1 vssd1 vccd1 vccd1 sky130_fd_sc_hd__fill_2
XANTENNA__6120__S _6223_/B vssd1 vssd1 vccd1 vccd1 sky130_fd_sc_hd__diode_2
XFILLER_0_0_159 vssd1 vssd1 vccd1 vccd1 sky130_fd_sc_hd__decap_3
XTAP_405 vssd1 vccd1 sky130_fd_sc_hd__tapvpwrvgnd_1
XFILLER_0_21_276 vssd1 vssd1 vccd1 vccd1 sky130_fd_sc_hd__fill_2
XFILLER_0_119_24 vssd1 vssd1 vccd1 vccd1 sky130_fd_sc_hd__fill_1
XTAP_416 vssd1 vccd1 sky130_fd_sc_hd__tapvpwrvgnd_1
XTAP_427 vssd1 vccd1 sky130_fd_sc_hd__tapvpwrvgnd_1
XTAP_438 vssd1 vccd1 sky130_fd_sc_hd__tapvpwrvgnd_1
XTAP_449 vssd1 vccd1 sky130_fd_sc_hd__tapvpwrvgnd_1
XFILLER_0_28_11 vssd1 vssd1 vccd1 vccd1 sky130_fd_sc_hd__decap_3
XFILLER_0_119_57 vssd1 vssd1 vccd1 vccd1 sky130_fd_sc_hd__fill_1
XFILLER_0_28_66 vssd1 vssd1 vccd1 vccd1 sky130_fd_sc_hd__fill_2
XFILLER_0_28_77 vssd1 vssd1 vccd1 vccd1 sky130_fd_sc_hd__fill_1
X_6870_ _6880_/CLK _6870_/D vssd1 vssd1 vccd1 vccd1 _6870_/Q sky130_fd_sc_hd__dfxtp_1
XFILLER_0_44_98 vssd1 vssd1 vccd1 vccd1 sky130_fd_sc_hd__fill_2
X_5821_ _5422_/X _5820_/X _5922_/S vssd1 vssd1 vccd1 vccd1 _5821_/X sky130_fd_sc_hd__mux2_1
X_5752_ hold192/X _5751_/X _5844_/S vssd1 vssd1 vccd1 vccd1 _6631_/D sky130_fd_sc_hd__mux2_1
XANTENNA__4026__D _4814_/D vssd1 vssd1 vccd1 vccd1 sky130_fd_sc_hd__diode_2
X_4703_ _5364_/A _5364_/B _5363_/A _4702_/Y vssd1 vssd1 vccd1 vccd1 _5389_/B sky130_fd_sc_hd__a31o_2
X_5683_ _5683_/A _5683_/B vssd1 vssd1 vccd1 vccd1 _5695_/B sky130_fd_sc_hd__and2_1
XFILLER_0_60_75 vssd1 vssd1 vccd1 vccd1 sky130_fd_sc_hd__fill_2
X_4634_ _4629_/A _4633_/X _4629_/Y vssd1 vssd1 vccd1 vccd1 _4654_/A sky130_fd_sc_hd__a21o_1
X_4565_ _4566_/A _4566_/B _4566_/C vssd1 vssd1 vccd1 vccd1 _4595_/A sky130_fd_sc_hd__and3_1
XFILLER_0_12_221 vssd1 vssd1 vccd1 vccd1 sky130_fd_sc_hd__fill_2
XFILLER_0_8_65 vssd1 vssd1 vccd1 vccd1 sky130_ef_sc_hd__decap_12
X_6304_ _6787_/Q hold80/X _6319_/S vssd1 vssd1 vccd1 vccd1 hold81/A sky130_fd_sc_hd__mux2_1
XFILLER_0_69_84 vssd1 vssd1 vccd1 vccd1 sky130_fd_sc_hd__fill_2
XFILLER_0_12_243 vssd1 vssd1 vccd1 vccd1 sky130_fd_sc_hd__fill_2
X_3516_ _3870_/A _5308_/B _5277_/B _5308_/A vssd1 vssd1 vccd1 vccd1 _3518_/A sky130_fd_sc_hd__a22o_1
XANTENNA_fanout101_A _5311_/A vssd1 vssd1 vccd1 vccd1 sky130_fd_sc_hd__diode_2
X_4496_ _4496_/A _4496_/B vssd1 vssd1 vccd1 vccd1 _4498_/B sky130_fd_sc_hd__xnor2_1
X_6235_ _6234_/A _6856_/Q _3304_/Y _6855_/Q vssd1 vssd1 vccd1 vccd1 _6276_/A sky130_fd_sc_hd__a22o_1
X_3447_ _3447_/A _3447_/B _3447_/C vssd1 vssd1 vccd1 vccd1 _3447_/Y sky130_fd_sc_hd__nor3_1
X_6166_ _6788_/Q hold22/A vssd1 vssd1 vccd1 vccd1 _6168_/A sky130_fd_sc_hd__and2_1
XTAP_961 vssd1 vccd1 sky130_fd_sc_hd__tapvpwrvgnd_1
XTAP_950 vssd1 vccd1 sky130_fd_sc_hd__tapvpwrvgnd_1
X_3378_ _3384_/A _3384_/B vssd1 vssd1 vccd1 vccd1 _3391_/A sky130_fd_sc_hd__or2_1
XTAP_994 vssd1 vccd1 sky130_fd_sc_hd__tapvpwrvgnd_1
XTAP_983 vssd1 vccd1 sky130_fd_sc_hd__tapvpwrvgnd_1
XTAP_972 vssd1 vccd1 sky130_fd_sc_hd__tapvpwrvgnd_1
XFILLER_0_85_72 vssd1 vssd1 vccd1 vccd1 sky130_fd_sc_hd__fill_2
X_6097_ _6636_/Q hold244/X _6098_/S vssd1 vssd1 vccd1 vccd1 _6097_/X sky130_fd_sc_hd__mux2_1
X_5117_ _5115_/X _5117_/B vssd1 vssd1 vccd1 vccd1 _5137_/A sky130_fd_sc_hd__and2b_1
X_5048_ _5048_/A _5048_/B vssd1 vssd1 vccd1 vccd1 _5056_/A sky130_fd_sc_hd__xor2_1
XFILLER_0_79_232 vssd1 vssd1 vccd1 vccd1 sky130_fd_sc_hd__decap_4
XFILLER_0_67_405 vssd1 vssd1 vccd1 vccd1 sky130_fd_sc_hd__fill_2
XFILLER_0_39_118 vssd1 vssd1 vccd1 vccd1 sky130_fd_sc_hd__fill_2
XFILLER_0_39_129 vssd1 vssd1 vccd1 vccd1 sky130_fd_sc_hd__fill_1
XANTENNA__4514__A _4942_/B vssd1 vssd1 vccd1 vccd1 sky130_fd_sc_hd__diode_2
XFILLER_0_47_173 vssd1 vssd1 vccd1 vccd1 sky130_fd_sc_hd__fill_2
XFILLER_0_35_346 vssd1 vssd1 vccd1 vccd1 sky130_fd_sc_hd__fill_2
XFILLER_0_47_195 vssd1 vssd1 vccd1 vccd1 sky130_fd_sc_hd__fill_1
XFILLER_0_105_212 vssd1 vssd1 vccd1 vccd1 sky130_fd_sc_hd__fill_2
XANTENNA__5706__B1 _5796_/A vssd1 vssd1 vccd1 vccd1 sky130_fd_sc_hd__diode_2
XFILLER_0_7_281 vssd1 vssd1 vccd1 vccd1 sky130_fd_sc_hd__fill_1
XFILLER_0_7_270 vssd1 vssd1 vccd1 vccd1 sky130_fd_sc_hd__fill_2
XFILLER_0_50_305 vssd1 vssd1 vccd1 vccd1 sky130_fd_sc_hd__decap_3
XFILLER_0_50_327 vssd1 vssd1 vccd1 vccd1 sky130_fd_sc_hd__decap_3
XFILLER_0_50_338 vssd1 vssd1 vccd1 vccd1 sky130_fd_sc_hd__decap_3
XANTENNA__5064__B _5064_/B vssd1 vssd1 vccd1 vccd1 sky130_fd_sc_hd__diode_2
XFILLER_0_85_202 vssd1 vssd1 vccd1 vccd1 sky130_fd_sc_hd__fill_1
XFILLER_0_85_235 vssd1 vssd1 vccd1 vccd1 sky130_fd_sc_hd__fill_2
XFILLER_0_128_326 vssd1 vssd1 vccd1 vccd1 sky130_fd_sc_hd__fill_1
XPHY_260 vssd1 vssd1 vccd1 vccd1 sky130_fd_sc_hd__decap_3
XFILLER_0_128_359 vssd1 vssd1 vccd1 vccd1 sky130_fd_sc_hd__fill_2
XFILLER_0_26_302 vssd1 vssd1 vccd1 vccd1 sky130_fd_sc_hd__decap_6
XFILLER_0_26_313 vssd1 vssd1 vccd1 vccd1 sky130_fd_sc_hd__decap_3
XFILLER_0_38_173 vssd1 vssd1 vccd1 vccd1 sky130_fd_sc_hd__fill_2
XPHY_271 vssd1 vssd1 vccd1 vccd1 sky130_fd_sc_hd__decap_3
XANTENNA__4143__B _5718_/B vssd1 vssd1 vccd1 vccd1 sky130_fd_sc_hd__diode_2
XFILLER_0_30_12 vssd1 vssd1 vccd1 vccd1 sky130_fd_sc_hd__fill_2
XFILLER_0_38_195 vssd1 vssd1 vccd1 vccd1 sky130_fd_sc_hd__fill_1
XFILLER_0_136_392 vssd1 vssd1 vccd1 vccd1 sky130_ef_sc_hd__decap_12
XFILLER_0_53_154 vssd1 vssd1 vccd1 vccd1 sky130_fd_sc_hd__decap_4
XANTENNA__6370__B1 _6440_/B vssd1 vssd1 vccd1 vccd1 sky130_fd_sc_hd__diode_2
XFILLER_0_30_67 vssd1 vssd1 vccd1 vccd1 sky130_fd_sc_hd__decap_3
XFILLER_0_30_89 vssd1 vssd1 vccd1 vccd1 sky130_fd_sc_hd__fill_2
XFILLER_0_53_198 vssd1 vssd1 vccd1 vccd1 sky130_fd_sc_hd__fill_2
XFILLER_0_111_215 vssd1 vssd1 vccd1 vccd1 sky130_fd_sc_hd__fill_2
X_4350_ _4350_/A _4350_/B vssd1 vssd1 vccd1 vccd1 _4407_/B sky130_fd_sc_hd__xnor2_1
X_3301_ depth_mport_i[25] vssd1 vssd1 vccd1 vccd1 _3301_/Y sky130_fd_sc_hd__inv_2
X_4281_ _4281_/A _4281_/B _4281_/C vssd1 vssd1 vccd1 vccd1 _4283_/B sky130_fd_sc_hd__nand3_1
X_6020_ tex_height_i[12] _6021_/B vssd1 vssd1 vccd1 vccd1 _6026_/B sky130_fd_sc_hd__or2_1
XTAP_279 vssd1 vccd1 sky130_fd_sc_hd__tapvpwrvgnd_1
X_6922_ vssd1 vssd1 vccd1 vccd1 _6922_/HI pix_mport_o[23] sky130_fd_sc_hd__conb_1
XFILLER_0_49_405 vssd1 vssd1 vccd1 vccd1 sky130_fd_sc_hd__fill_2
X_6853_ _6853_/CLK _6853_/D vssd1 vssd1 vccd1 vccd1 _6853_/Q sky130_fd_sc_hd__dfxtp_1
XFILLER_0_76_213 vssd1 vssd1 vccd1 vccd1 sky130_ef_sc_hd__decap_12
XFILLER_0_119_326 vssd1 vssd1 vccd1 vccd1 sky130_fd_sc_hd__fill_1
Xfanout17 _5468_/X vssd1 vssd1 vccd1 vccd1 _6465_/S sky130_fd_sc_hd__clkbuf_4
XFILLER_0_76_257 vssd1 vssd1 vccd1 vccd1 sky130_fd_sc_hd__decap_8
XFILLER_0_71_41 vssd1 vssd1 vccd1 vccd1 sky130_fd_sc_hd__decap_3
Xfanout28 _5844_/S vssd1 vssd1 vccd1 vccd1 _5923_/S sky130_fd_sc_hd__buf_6
X_5804_ _5804_/A vssd1 vssd1 vccd1 vccd1 _5806_/A sky130_fd_sc_hd__inv_2
X_6784_ _6862_/CLK _6784_/D _6320_/C vssd1 vssd1 vccd1 vccd1 _6784_/Q sky130_fd_sc_hd__dfrtp_4
XFILLER_0_76_279 vssd1 vssd1 vccd1 vccd1 sky130_ef_sc_hd__decap_12
XFILLER_0_71_96 vssd1 vssd1 vccd1 vccd1 sky130_fd_sc_hd__decap_4
Xfanout39 hold299/X vssd1 vssd1 vccd1 vccd1 _5273_/B sky130_fd_sc_hd__buf_4
X_3996_ _3996_/A _4004_/B _3996_/C _3996_/D vssd1 vssd1 vccd1 vccd1 _3996_/Y sky130_fd_sc_hd__nand4_4
XFILLER_0_134_307 vssd1 vssd1 vccd1 vccd1 sky130_fd_sc_hd__fill_1
X_5735_ tex_addr_i[9] _5737_/B vssd1 vssd1 vccd1 vccd1 _5736_/A sky130_fd_sc_hd__nand2_2
XANTENNA__3595__D _5118_/B vssd1 vssd1 vccd1 vccd1 sky130_fd_sc_hd__diode_2
XFILLER_0_17_335 vssd1 vssd1 vccd1 vccd1 sky130_fd_sc_hd__fill_1
X_5666_ _5666_/A _5666_/B vssd1 vssd1 vccd1 vccd1 _5667_/B sky130_fd_sc_hd__nand2_1
XFILLER_0_17_357 vssd1 vssd1 vccd1 vccd1 sky130_fd_sc_hd__decap_3
X_4617_ _4638_/A _4658_/D vssd1 vssd1 vccd1 vccd1 _4655_/B sky130_fd_sc_hd__nand2_1
XFILLER_0_4_240 vssd1 vssd1 vccd1 vccd1 sky130_fd_sc_hd__fill_2
XFILLER_0_44_187 vssd1 vssd1 vccd1 vccd1 sky130_fd_sc_hd__decap_3
XFILLER_0_4_262 vssd1 vssd1 vccd1 vccd1 sky130_fd_sc_hd__fill_2
X_5597_ _5444_/B tex_mport_o[60] _5601_/S vssd1 vssd1 vccd1 vccd1 _6617_/D sky130_fd_sc_hd__mux2_1
X_4548_ _4545_/A _4543_/X _4535_/X _4537_/Y vssd1 vssd1 vccd1 vccd1 _4548_/X sky130_fd_sc_hd__o211a_1
XANTENNA__3714__A2 _5273_/A vssd1 vssd1 vccd1 vccd1 sky130_fd_sc_hd__diode_2
X_4479_ _4473_/A _4473_/B _4473_/C vssd1 vssd1 vccd1 vccd1 _4480_/C sky130_fd_sc_hd__a21o_1
X_6218_ _6218_/A _6218_/B vssd1 vssd1 vccd1 vccd1 _6218_/X sky130_fd_sc_hd__and2_1
X_6149_ _6149_/A _6149_/B vssd1 vssd1 vccd1 vccd1 _6150_/B sky130_fd_sc_hd__nand2_1
XTAP_791 vssd1 vccd1 sky130_fd_sc_hd__tapvpwrvgnd_1
XTAP_780 vssd1 vccd1 sky130_fd_sc_hd__tapvpwrvgnd_1
XFILLER_0_82_205 vssd1 vssd1 vccd1 vccd1 sky130_fd_sc_hd__fill_1
XFILLER_0_67_279 vssd1 vssd1 vccd1 vccd1 sky130_fd_sc_hd__fill_1
XFILLER_0_118_381 vssd1 vssd1 vccd1 vccd1 sky130_ef_sc_hd__decap_12
XFILLER_0_35_198 vssd1 vssd1 vccd1 vccd1 sky130_fd_sc_hd__fill_2
XFILLER_0_50_102 vssd1 vssd1 vccd1 vccd1 sky130_fd_sc_hd__fill_2
XFILLER_0_50_179 vssd1 vssd1 vccd1 vccd1 sky130_fd_sc_hd__fill_1
XFILLER_0_31_393 vssd1 vssd1 vccd1 vccd1 sky130_ef_sc_hd__decap_12
XFILLER_0_101_281 vssd1 vssd1 vccd1 vccd1 sky130_fd_sc_hd__fill_2
XFILLER_0_25_45 vssd1 vssd1 vccd1 vccd1 sky130_fd_sc_hd__fill_2
XANTENNA__3977__B _5049_/B vssd1 vssd1 vccd1 vccd1 sky130_fd_sc_hd__diode_2
XANTENNA__6353__B _6539_/Q vssd1 vssd1 vccd1 vccd1 sky130_fd_sc_hd__diode_2
XFILLER_0_132_24 vssd1 vssd1 vccd1 vccd1 sky130_fd_sc_hd__fill_2
XANTENNA_clkbuf_leaf_12_clk_i_A clkbuf_2_3__f_clk_i/X vssd1 vssd1 vccd1 vccd1 sky130_fd_sc_hd__diode_2
XFILLER_0_73_216 vssd1 vssd1 vccd1 vccd1 sky130_fd_sc_hd__fill_2
X_3850_ _3850_/A _3850_/B vssd1 vssd1 vccd1 vccd1 _3852_/B sky130_fd_sc_hd__xor2_1
XFILLER_0_73_238 vssd1 vssd1 vccd1 vccd1 sky130_fd_sc_hd__fill_1
X_3781_ _3758_/A _3758_/B _3757_/X vssd1 vssd1 vccd1 vccd1 _3781_/X sky130_fd_sc_hd__o21ba_1
XFILLER_0_26_121 vssd1 vssd1 vccd1 vccd1 sky130_fd_sc_hd__decap_3
XFILLER_0_41_55 vssd1 vssd1 vccd1 vccd1 sky130_fd_sc_hd__fill_1
XFILLER_0_41_66 vssd1 vssd1 vccd1 vccd1 sky130_fd_sc_hd__fill_1
X_5520_ _6335_/B sstream_i[111] _6465_/S vssd1 vssd1 vccd1 vccd1 _6553_/D sky130_fd_sc_hd__mux2_1
XFILLER_0_14_305 vssd1 vssd1 vccd1 vccd1 sky130_fd_sc_hd__decap_3
XFILLER_0_124_384 vssd1 vssd1 vccd1 vccd1 sky130_ef_sc_hd__decap_12
X_5451_ _6749_/Q _5451_/B _5451_/C vssd1 vssd1 vccd1 vccd1 _5451_/X sky130_fd_sc_hd__and3_1
X_5382_ _6725_/Q _5382_/B vssd1 vssd1 vccd1 vccd1 _5383_/C sky130_fd_sc_hd__xnor2_1
X_4402_ _4403_/B _4403_/A vssd1 vssd1 vccd1 vccd1 _4405_/A sky130_fd_sc_hd__nand2b_1
X_4333_ _4789_/B _4736_/D _4774_/B _4776_/A vssd1 vssd1 vccd1 vccd1 _4334_/B sky130_fd_sc_hd__and4_1
X_4264_ _4264_/A _4264_/B _4264_/C vssd1 vssd1 vccd1 vccd1 _4264_/X sky130_fd_sc_hd__and3_1
XFILLER_0_5_55 vssd1 vssd1 vccd1 vccd1 sky130_fd_sc_hd__fill_1
X_6003_ tex_height_i[7] _6002_/C tex_height_i[8] vssd1 vssd1 vccd1 vccd1 _6004_/B
+ sky130_fd_sc_hd__o21ai_1
XFILLER_0_66_85 vssd1 vssd1 vccd1 vccd1 sky130_fd_sc_hd__fill_2
X_4195_ _4194_/A _4194_/B _4201_/A vssd1 vssd1 vccd1 vccd1 _4196_/C sky130_fd_sc_hd__a21o_1
X_6905_ vssd1 vssd1 vccd1 vccd1 _6905_/HI depth_mport_o[65] sky130_fd_sc_hd__conb_1
XTAP_1209 vssd1 vccd1 sky130_fd_sc_hd__tapvpwrvgnd_1
XFILLER_0_89_393 vssd1 vssd1 vccd1 vccd1 sky130_ef_sc_hd__decap_12
XFILLER_0_10_3 vssd1 vssd1 vccd1 vccd1 sky130_ef_sc_hd__decap_12
XANTENNA__3887__B _6683_/Q vssd1 vssd1 vccd1 vccd1 sky130_fd_sc_hd__diode_2
XANTENNA__5082__B1 _5081_/D vssd1 vssd1 vccd1 vccd1 sky130_fd_sc_hd__diode_2
XFILLER_0_106_80 vssd1 vssd1 vccd1 vccd1 sky130_fd_sc_hd__fill_2
XANTENNA__3632__A1 _5081_/A vssd1 vssd1 vccd1 vccd1 sky130_fd_sc_hd__diode_2
XFILLER_0_49_246 vssd1 vssd1 vccd1 vccd1 sky130_fd_sc_hd__decap_8
XFILLER_0_119_123 vssd1 vssd1 vccd1 vccd1 sky130_fd_sc_hd__fill_2
X_6836_ _6855_/CLK _6836_/D vssd1 vssd1 vccd1 vccd1 _6836_/Q sky130_fd_sc_hd__dfxtp_1
XFILLER_0_64_205 vssd1 vssd1 vccd1 vccd1 sky130_fd_sc_hd__fill_2
XFILLER_0_9_321 vssd1 vssd1 vccd1 vccd1 sky130_fd_sc_hd__fill_1
XFILLER_0_49_279 vssd1 vssd1 vccd1 vccd1 sky130_fd_sc_hd__fill_1
X_6767_ _6827_/CLK _6767_/D fanout150/X vssd1 vssd1 vccd1 vccd1 pix_mport_o[39] sky130_fd_sc_hd__dfrtp_4
X_5718_ _5718_/A _5718_/B _5718_/C vssd1 vssd1 vccd1 vccd1 _5732_/B sky130_fd_sc_hd__or3_1
XFILLER_0_9_387 vssd1 vssd1 vccd1 vccd1 sky130_fd_sc_hd__decap_4
X_3979_ _5051_/A _5071_/A _3979_/C _3979_/D vssd1 vssd1 vccd1 vccd1 _3979_/X sky130_fd_sc_hd__and4_2
XANTENNA__6334__A0 hold200/X vssd1 vssd1 vccd1 vccd1 sky130_fd_sc_hd__diode_2
X_6698_ _6792_/CLK _6698_/D vssd1 vssd1 vccd1 vccd1 hold45/A sky130_fd_sc_hd__dfxtp_1
XFILLER_0_17_198 vssd1 vssd1 vccd1 vccd1 sky130_fd_sc_hd__fill_2
X_5649_ _5649_/A _5649_/B _5649_/C vssd1 vssd1 vccd1 vccd1 _5650_/B sky130_fd_sc_hd__nand3_1
XFILLER_0_130_365 vssd1 vssd1 vccd1 vccd1 sky130_ef_sc_hd__decap_12
Xhold261 _6090_/X vssd1 vssd1 vccd1 vccd1 _6728_/D sky130_fd_sc_hd__dlygate4sd3_1
Xhold250 _6635_/Q vssd1 vssd1 vccd1 vccd1 hold250/X sky130_fd_sc_hd__dlygate4sd3_1
XFILLER_0_13_393 vssd1 vssd1 vccd1 vccd1 sky130_ef_sc_hd__decap_12
Xhold283 _6646_/Q vssd1 vssd1 vccd1 vccd1 hold283/X sky130_fd_sc_hd__dlygate4sd3_1
Xhold294 _6640_/Q vssd1 vssd1 vccd1 vccd1 hold294/X sky130_fd_sc_hd__dlygate4sd3_1
Xhold272 _6738_/Q vssd1 vssd1 vccd1 vccd1 hold272/X sky130_fd_sc_hd__dlygate4sd3_1
XFILLER_0_87_308 vssd1 vssd1 vccd1 vccd1 sky130_fd_sc_hd__fill_1
XANTENNA__3871__A1 _5083_/A vssd1 vssd1 vccd1 vccd1 sky130_fd_sc_hd__diode_2
XANTENNA_101 sstream_i[5] vssd1 vssd1 vccd1 vccd1 sky130_fd_sc_hd__diode_2
XANTENNA_112 sstream_i[8] vssd1 vssd1 vccd1 vccd1 sky130_fd_sc_hd__diode_2
XANTENNA_134 tex_addr_i[3] vssd1 vssd1 vccd1 vccd1 sky130_fd_sc_hd__diode_2
XANTENNA_123 tex_addr_i[11] vssd1 vssd1 vccd1 vccd1 sky130_fd_sc_hd__diode_2
XANTENNA_156 sstream_i[28] vssd1 vssd1 vccd1 vccd1 sky130_fd_sc_hd__diode_2
XFILLER_0_95_352 vssd1 vssd1 vccd1 vccd1 sky130_ef_sc_hd__decap_12
XANTENNA_145 tex_width_i[13] vssd1 vssd1 vccd1 vccd1 sky130_fd_sc_hd__diode_2
XFILLER_0_106_351 vssd1 vssd1 vccd1 vccd1 sky130_ef_sc_hd__decap_12
XFILLER_0_23_113 vssd1 vssd1 vccd1 vccd1 sky130_fd_sc_hd__fill_1
XFILLER_0_11_69 vssd1 vssd1 vccd1 vccd1 sky130_ef_sc_hd__decap_12
XFILLER_0_23_135 vssd1 vssd1 vccd1 vccd1 sky130_fd_sc_hd__fill_2
XFILLER_0_23_146 vssd1 vssd1 vccd1 vccd1 sky130_fd_sc_hd__fill_2
XANTENNA__4140__C _4614_/C vssd1 vssd1 vccd1 vccd1 sky130_fd_sc_hd__diode_2
XANTENNA__4794__D _5083_/A vssd1 vssd1 vccd1 vccd1 sky130_fd_sc_hd__diode_2
XFILLER_0_127_57 vssd1 vssd1 vccd1 vccd1 sky130_fd_sc_hd__fill_1
XANTENNA__6364__A hold98/A vssd1 vssd1 vccd1 vccd1 sky130_fd_sc_hd__diode_2
XFILLER_0_36_99 vssd1 vssd1 vccd1 vccd1 sky130_fd_sc_hd__decap_3
XANTENNA__4811__B1 _4966_/C vssd1 vssd1 vccd1 vccd1 sky130_fd_sc_hd__diode_2
X_4951_ _4951_/A _5059_/B _4951_/C vssd1 vssd1 vccd1 vccd1 _5191_/A sky130_fd_sc_hd__nand3_2
X_3902_ _3929_/B _3929_/A vssd1 vssd1 vccd1 vccd1 _3902_/X sky130_fd_sc_hd__and2b_1
X_4882_ _4880_/A _4880_/Y _4881_/Y _4868_/X vssd1 vssd1 vccd1 vccd1 _4886_/A sky130_fd_sc_hd__a211oi_4
X_6621_ _6834_/CLK _6621_/D fanout145/X vssd1 vssd1 vccd1 vccd1 _6621_/Q sky130_fd_sc_hd__dfrtp_1
X_3833_ _3833_/A _3833_/B vssd1 vssd1 vccd1 vccd1 _3835_/C sky130_fd_sc_hd__xor2_2
XANTENNA__6303__S _6319_/S vssd1 vssd1 vccd1 vccd1 sky130_fd_sc_hd__diode_2
XFILLER_0_61_208 vssd1 vssd1 vccd1 vccd1 sky130_fd_sc_hd__decap_4
X_6552_ _6864_/CLK _6552_/D vssd1 vssd1 vccd1 vccd1 _6552_/Q sky130_fd_sc_hd__dfxtp_1
X_3764_ _6647_/Q _3847_/B vssd1 vssd1 vccd1 vccd1 _3848_/A sky130_fd_sc_hd__nand2_1
XFILLER_0_42_400 vssd1 vssd1 vccd1 vccd1 sky130_fd_sc_hd__decap_6
XFILLER_0_61_219 vssd1 vssd1 vccd1 vccd1 sky130_fd_sc_hd__fill_2
X_5503_ hold76/X sstream_i[94] _6464_/S vssd1 vssd1 vccd1 vccd1 _6536_/D sky130_fd_sc_hd__mux2_1
XANTENNA__4331__B _4433_/D vssd1 vssd1 vccd1 vccd1 sky130_fd_sc_hd__diode_2
X_3695_ _3680_/Y _3703_/A _3620_/C _3623_/X vssd1 vssd1 vccd1 vccd1 _3698_/A sky130_fd_sc_hd__a211oi_2
XANTENNA__5119__A1 _5286_/A vssd1 vssd1 vccd1 vccd1 sky130_fd_sc_hd__diode_2
X_6483_ hold190/X sstream_i[41] _6486_/S vssd1 vssd1 vccd1 vccd1 _6874_/D sky130_fd_sc_hd__mux2_1
XFILLER_0_112_343 vssd1 vssd1 vccd1 vccd1 sky130_fd_sc_hd__fill_1
X_5434_ _5436_/B _5436_/C vssd1 vssd1 vccd1 vccd1 _5434_/X sky130_fd_sc_hd__and2_1
X_5365_ _5365_/A _5365_/B vssd1 vssd1 vccd1 vccd1 _5385_/B sky130_fd_sc_hd__xnor2_2
XFILLER_0_77_40 vssd1 vssd1 vccd1 vccd1 sky130_fd_sc_hd__fill_2
XFILLER_0_10_363 vssd1 vssd1 vccd1 vccd1 sky130_fd_sc_hd__fill_1
XANTENNA__6614__RESET_B fanout140/X vssd1 vssd1 vccd1 vccd1 sky130_fd_sc_hd__diode_2
XFILLER_0_58_3 vssd1 vssd1 vccd1 vccd1 sky130_fd_sc_hd__decap_4
X_4316_ _4958_/B _4688_/C _4658_/D _5718_/A vssd1 vssd1 vccd1 vccd1 _4317_/B sky130_fd_sc_hd__a22o_1
XFILLER_0_77_95 vssd1 vssd1 vccd1 vccd1 sky130_fd_sc_hd__fill_2
X_5296_ _5296_/A _5296_/B vssd1 vssd1 vccd1 vccd1 _5296_/X sky130_fd_sc_hd__and2_1
X_4247_ _4230_/X _4231_/Y _4242_/Y _4245_/Y vssd1 vssd1 vccd1 vccd1 _4247_/Y sky130_fd_sc_hd__a211oi_2
X_4178_ _4171_/X _4199_/A _4731_/B _4177_/X vssd1 vssd1 vccd1 vccd1 _4178_/X sky130_fd_sc_hd__o211a_1
XFILLER_0_117_90 vssd1 vssd1 vccd1 vccd1 sky130_fd_sc_hd__fill_2
XTAP_1028 vssd1 vccd1 sky130_fd_sc_hd__tapvpwrvgnd_1
XTAP_1017 vssd1 vccd1 sky130_fd_sc_hd__tapvpwrvgnd_1
XTAP_1006 vssd1 vccd1 sky130_fd_sc_hd__tapvpwrvgnd_1
XTAP_1039 vssd1 vccd1 sky130_fd_sc_hd__tapvpwrvgnd_1
X_6819_ _6827_/CLK _6819_/D fanout151/X vssd1 vssd1 vccd1 vccd1 depth_mport_o[41]
+ sky130_fd_sc_hd__dfrtp_4
XFILLER_0_77_385 vssd1 vssd1 vccd1 vccd1 sky130_fd_sc_hd__decap_6
XFILLER_0_9_140 vssd1 vssd1 vccd1 vccd1 sky130_fd_sc_hd__fill_2
XFILLER_0_92_377 vssd1 vssd1 vccd1 vccd1 sky130_ef_sc_hd__decap_12
XANTENNA__3369__B1 _5296_/B vssd1 vssd1 vccd1 vccd1 sky130_fd_sc_hd__diode_2
XFILLER_0_9_173 vssd1 vssd1 vccd1 vccd1 sky130_fd_sc_hd__decap_3
XFILLER_0_60_274 vssd1 vssd1 vccd1 vccd1 sky130_fd_sc_hd__fill_1
XFILLER_0_103_376 vssd1 vssd1 vccd1 vccd1 sky130_ef_sc_hd__decap_12
XFILLER_0_138_251 vssd1 vssd1 vccd1 vccd1 sky130_fd_sc_hd__fill_1
XPHY_80 vssd1 vssd1 vccd1 vccd1 sky130_fd_sc_hd__decap_3
XPHY_91 vssd1 vssd1 vccd1 vccd1 sky130_fd_sc_hd__decap_3
XFILLER_0_83_344 vssd1 vssd1 vccd1 vccd1 sky130_fd_sc_hd__decap_4
XANTENNA__6123__S _6223_/B vssd1 vssd1 vccd1 vccd1 sky130_fd_sc_hd__diode_2
XANTENNA__4432__A _4432_/A vssd1 vssd1 vccd1 vccd1 sky130_fd_sc_hd__diode_2
XANTENNA__4789__D _5064_/B vssd1 vssd1 vccd1 vccd1 sky130_fd_sc_hd__diode_2
XANTENNA__4151__B _4736_/D vssd1 vssd1 vccd1 vccd1 sky130_fd_sc_hd__diode_2
XFILLER_0_106_181 vssd1 vssd1 vccd1 vccd1 sky130_fd_sc_hd__fill_2
XFILLER_0_11_105 vssd1 vssd1 vccd1 vccd1 sky130_fd_sc_hd__decap_6
X_3480_ _3480_/A _3480_/B vssd1 vssd1 vccd1 vccd1 _3482_/A sky130_fd_sc_hd__nor2_1
X_5150_ _5145_/A _5145_/C _5145_/B vssd1 vssd1 vccd1 vccd1 _5150_/Y sky130_fd_sc_hd__o21ai_2
X_4101_ _4101_/A _4146_/B _4101_/C vssd1 vssd1 vccd1 vccd1 _4104_/A sky130_fd_sc_hd__nand3_1
X_5081_ _5081_/A _5081_/B _5081_/C _5081_/D vssd1 vssd1 vccd1 vccd1 _5122_/A sky130_fd_sc_hd__nand4_1
X_4032_ _4582_/D _5718_/B vssd1 vssd1 vccd1 vccd1 _4254_/A sky130_fd_sc_hd__nand2_1
XFILLER_0_47_65 vssd1 vssd1 vccd1 vccd1 sky130_fd_sc_hd__fill_2
XFILLER_0_78_116 vssd1 vssd1 vccd1 vccd1 sky130_fd_sc_hd__fill_2
XANTENNA__3511__A _5273_/A vssd1 vssd1 vccd1 vccd1 sky130_fd_sc_hd__diode_2
XANTENNA__4326__B _4551_/D vssd1 vssd1 vccd1 vccd1 sky130_fd_sc_hd__diode_2
XFILLER_0_63_64 vssd1 vssd1 vccd1 vccd1 sky130_fd_sc_hd__decap_3
XFILLER_0_63_53 vssd1 vssd1 vccd1 vccd1 sky130_fd_sc_hd__decap_3
XANTENNA__3868__D _5081_/D vssd1 vssd1 vccd1 vccd1 sky130_fd_sc_hd__diode_2
X_5983_ _5983_/A _5987_/B vssd1 vssd1 vccd1 vccd1 _5983_/Y sky130_fd_sc_hd__nand2_1
X_4934_ _4935_/B _4935_/A vssd1 vssd1 vccd1 vccd1 _4934_/X sky130_fd_sc_hd__and2b_1
XANTENNA__4045__C _4476_/D vssd1 vssd1 vccd1 vccd1 sky130_fd_sc_hd__diode_2
XANTENNA_12 sstream_i[10] vssd1 vssd1 vccd1 vccd1 sky130_fd_sc_hd__diode_2
XANTENNA_23 sstream_i[12] vssd1 vssd1 vccd1 vccd1 sky130_fd_sc_hd__diode_2
XFILLER_0_19_249 vssd1 vssd1 vccd1 vccd1 sky130_fd_sc_hd__decap_3
X_4865_ _4865_/A _4865_/B _4865_/C vssd1 vssd1 vccd1 vccd1 _4869_/A sky130_fd_sc_hd__nand3_4
XANTENNA_34 sstream_i[14] vssd1 vssd1 vccd1 vccd1 sky130_fd_sc_hd__diode_2
Xclkbuf_leaf_8_clk_i clkbuf_leaf_9_clk_i/A vssd1 vssd1 vccd1 vccd1 _6862_/CLK sky130_fd_sc_hd__clkbuf_16
XANTENNA_56 sstream_i[19] vssd1 vssd1 vccd1 vccd1 sky130_fd_sc_hd__diode_2
XANTENNA_45 sstream_i[16] vssd1 vssd1 vccd1 vccd1 sky130_fd_sc_hd__diode_2
X_6604_ _6734_/CLK _6604_/D fanout144/X vssd1 vssd1 vccd1 vccd1 tex_mport_o[47] sky130_fd_sc_hd__dfrtp_4
XANTENNA_fanout131_A _5754_/B vssd1 vssd1 vccd1 vccd1 sky130_fd_sc_hd__diode_2
XFILLER_0_6_121 vssd1 vssd1 vccd1 vccd1 sky130_ef_sc_hd__decap_12
X_3816_ _3800_/Y _3815_/X _3735_/Y _3782_/X vssd1 vssd1 vccd1 vccd1 _3838_/A sky130_fd_sc_hd__a211o_2
XFILLER_0_34_208 vssd1 vssd1 vccd1 vccd1 sky130_fd_sc_hd__fill_1
X_4796_ _4796_/A _4796_/B _4796_/C vssd1 vssd1 vccd1 vccd1 _4800_/A sky130_fd_sc_hd__nand3_1
XFILLER_0_132_405 vssd1 vssd1 vccd1 vccd1 sky130_fd_sc_hd__fill_2
XANTENNA_67 sstream_i[23] vssd1 vssd1 vccd1 vccd1 sky130_fd_sc_hd__diode_2
XANTENNA_89 sstream_i[3] vssd1 vssd1 vccd1 vccd1 sky130_fd_sc_hd__diode_2
XANTENNA_78 sstream_i[2] vssd1 vssd1 vccd1 vccd1 sky130_fd_sc_hd__diode_2
X_6535_ _6855_/CLK _6535_/D vssd1 vssd1 vccd1 vccd1 hold27/A sky130_fd_sc_hd__dfxtp_1
XFILLER_0_104_107 vssd1 vssd1 vccd1 vccd1 sky130_fd_sc_hd__fill_2
XFILLER_0_103_92 vssd1 vssd1 vccd1 vccd1 sky130_fd_sc_hd__fill_1
XANTENNA__4061__B _4476_/D vssd1 vssd1 vccd1 vccd1 sky130_fd_sc_hd__diode_2
X_3747_ _5290_/A _5327_/A _6686_/Q _6687_/Q vssd1 vssd1 vccd1 vccd1 _3747_/X sky130_fd_sc_hd__and4_1
XFILLER_0_104_129 vssd1 vssd1 vccd1 vccd1 sky130_fd_sc_hd__fill_1
XFILLER_0_88_72 vssd1 vssd1 vccd1 vccd1 sky130_fd_sc_hd__decap_4
X_3678_ _3678_/A _3678_/B _3687_/B _3678_/D vssd1 vssd1 vccd1 vccd1 _3678_/Y sky130_fd_sc_hd__nand4_4
X_6466_ hold117/X sstream_i[24] _6493_/S vssd1 vssd1 vccd1 vccd1 _6857_/D sky130_fd_sc_hd__mux2_1
X_6397_ _6391_/A _6410_/A _6390_/A vssd1 vssd1 vccd1 vccd1 _6397_/Y sky130_fd_sc_hd__a21oi_1
XFILLER_0_100_302 vssd1 vssd1 vccd1 vccd1 sky130_fd_sc_hd__decap_4
XFILLER_0_88_83 vssd1 vssd1 vccd1 vccd1 sky130_fd_sc_hd__fill_1
XFILLER_0_2_393 vssd1 vssd1 vccd1 vccd1 sky130_ef_sc_hd__decap_12
X_5417_ _5418_/B _5418_/C vssd1 vssd1 vccd1 vccd1 _5417_/X sky130_fd_sc_hd__and2_1
XFILLER_0_112_195 vssd1 vssd1 vccd1 vccd1 sky130_fd_sc_hd__fill_1
XFILLER_0_100_357 vssd1 vssd1 vccd1 vccd1 sky130_fd_sc_hd__decap_6
X_5348_ _5445_/C _5349_/C _6742_/Q vssd1 vssd1 vccd1 vccd1 _5348_/Y sky130_fd_sc_hd__a21oi_1
X_5279_ _5279_/A _5279_/B vssd1 vssd1 vccd1 vccd1 _5280_/B sky130_fd_sc_hd__xnor2_2
XFILLER_0_84_108 vssd1 vssd1 vccd1 vccd1 sky130_fd_sc_hd__fill_2
XFILLER_0_65_322 vssd1 vssd1 vccd1 vccd1 sky130_fd_sc_hd__fill_1
XFILLER_0_80_314 vssd1 vssd1 vccd1 vccd1 sky130_fd_sc_hd__fill_2
XFILLER_0_65_377 vssd1 vssd1 vccd1 vccd1 sky130_ef_sc_hd__decap_12
XANTENNA__3794__C _5766_/A vssd1 vssd1 vccd1 vccd1 sky130_fd_sc_hd__diode_2
XFILLER_0_123_405 vssd1 vssd1 vccd1 vccd1 sky130_fd_sc_hd__fill_2
XANTENNA__5751__B2 _5574_/B vssd1 vssd1 vccd1 vccd1 sky130_fd_sc_hd__diode_2
XFILLER_0_80_369 vssd1 vssd1 vccd1 vccd1 sky130_ef_sc_hd__decap_12
XANTENNA__5083__A _5083_/A vssd1 vssd1 vccd1 vccd1 sky130_fd_sc_hd__diode_2
XTAP_609 vssd1 vccd1 sky130_fd_sc_hd__tapvpwrvgnd_1
XFILLER_0_17_24 vssd1 vssd1 vccd1 vccd1 sky130_ef_sc_hd__decap_12
XANTENNA__6118__S _6223_/B vssd1 vssd1 vccd1 vccd1 sky130_fd_sc_hd__diode_2
XANTENNA__4427__A _5687_/B vssd1 vssd1 vccd1 vccd1 sky130_fd_sc_hd__diode_2
XFILLER_0_33_34 vssd1 vssd1 vccd1 vccd1 sky130_fd_sc_hd__decap_3
XANTENNA__3985__B _6682_/Q vssd1 vssd1 vccd1 vccd1 sky130_fd_sc_hd__diode_2
XFILLER_0_56_333 vssd1 vssd1 vccd1 vccd1 sky130_fd_sc_hd__fill_1
XFILLER_0_56_355 vssd1 vssd1 vccd1 vccd1 sky130_fd_sc_hd__fill_2
X_4650_ _4650_/A _4650_/B vssd1 vssd1 vccd1 vccd1 _4664_/B sky130_fd_sc_hd__xnor2_2
XFILLER_0_116_3 vssd1 vssd1 vccd1 vccd1 sky130_fd_sc_hd__fill_2
XFILLER_0_114_405 vssd1 vssd1 vccd1 vccd1 sky130_fd_sc_hd__fill_2
X_3601_ _3601_/A _3601_/B vssd1 vssd1 vccd1 vccd1 _3626_/A sky130_fd_sc_hd__xor2_1
X_6320_ _6783_/Q _6784_/Q _6320_/C vssd1 vssd1 vccd1 vccd1 _6320_/X sky130_fd_sc_hd__and3b_1
X_4581_ _4581_/A _4595_/A vssd1 vssd1 vccd1 vccd1 _4628_/A sky130_fd_sc_hd__xnor2_1
XFILLER_0_3_113 vssd1 vssd1 vccd1 vccd1 sky130_ef_sc_hd__decap_12
X_3532_ _3870_/A _5300_/A vssd1 vssd1 vccd1 vccd1 _3545_/B sky130_fd_sc_hd__and2_1
XFILLER_0_3_146 vssd1 vssd1 vccd1 vccd1 sky130_fd_sc_hd__fill_1
XFILLER_0_24_296 vssd1 vssd1 vccd1 vccd1 sky130_fd_sc_hd__fill_2
XANTENNA__6298__A2 _6440_/B vssd1 vssd1 vccd1 vccd1 sky130_fd_sc_hd__diode_2
X_6251_ _6251_/A vssd1 vssd1 vccd1 vccd1 _6251_/Y sky130_fd_sc_hd__inv_2
X_3463_ _5296_/A _5272_/B _5286_/B _5276_/A vssd1 vssd1 vccd1 vccd1 _3466_/C sky130_fd_sc_hd__a22o_1
X_6182_ _6182_/A _6182_/B vssd1 vssd1 vccd1 vccd1 _6183_/B sky130_fd_sc_hd__nand2_1
X_5202_ _5203_/B _5203_/A vssd1 vssd1 vccd1 vccd1 _5445_/A sky130_fd_sc_hd__nand2b_1
X_3394_ _3395_/B vssd1 vssd1 vccd1 vccd1 _3394_/Y sky130_fd_sc_hd__inv_2
X_5133_ _3956_/A _3956_/C _3956_/B vssd1 vssd1 vccd1 vccd1 _5141_/B sky130_fd_sc_hd__a21o_1
X_5064_ _5106_/A _5064_/B vssd1 vssd1 vccd1 vccd1 _5065_/B sky130_fd_sc_hd__nand2_1
X_4015_ _3932_/X _3939_/Y _4013_/A _4012_/Y vssd1 vssd1 vccd1 vccd1 _4015_/Y sky130_fd_sc_hd__a211oi_2
XANTENNA__6222__A2 _6224_/B vssd1 vssd1 vccd1 vccd1 sky130_fd_sc_hd__diode_2
X_5966_ hold18/A hold28/A _6503_/Q hold47/A vssd1 vssd1 vccd1 vccd1 _5969_/B sky130_fd_sc_hd__or4_1
XFILLER_0_47_300 vssd1 vssd1 vccd1 vccd1 sky130_fd_sc_hd__fill_2
XFILLER_0_47_322 vssd1 vssd1 vccd1 vccd1 sky130_ef_sc_hd__decap_12
XFILLER_0_74_141 vssd1 vssd1 vccd1 vccd1 sky130_fd_sc_hd__fill_2
X_5897_ _5897_/A _5897_/B vssd1 vssd1 vccd1 vccd1 _5902_/A sky130_fd_sc_hd__nand2_1
X_4917_ _4917_/A _4917_/B vssd1 vssd1 vccd1 vccd1 _4919_/B sky130_fd_sc_hd__xnor2_1
XFILLER_0_47_366 vssd1 vssd1 vccd1 vccd1 sky130_fd_sc_hd__fill_2
XFILLER_0_47_377 vssd1 vssd1 vccd1 vccd1 sky130_ef_sc_hd__decap_12
X_4848_ _4848_/A _4848_/B vssd1 vssd1 vccd1 vccd1 _4850_/B sky130_fd_sc_hd__xnor2_2
XFILLER_0_105_405 vssd1 vssd1 vccd1 vccd1 sky130_fd_sc_hd__fill_2
X_4779_ _4970_/B _4822_/B vssd1 vssd1 vccd1 vccd1 _4860_/A sky130_fd_sc_hd__nand2_1
X_6518_ _6834_/CLK _6518_/D vssd1 vssd1 vccd1 vccd1 _6518_/Q sky130_fd_sc_hd__dfxtp_1
XFILLER_0_15_296 vssd1 vssd1 vccd1 vccd1 sky130_ef_sc_hd__decap_12
XFILLER_0_30_222 vssd1 vssd1 vccd1 vccd1 sky130_fd_sc_hd__fill_2
X_6449_ hold122/X sstream_i[7] _6464_/S vssd1 vssd1 vccd1 vccd1 _6840_/D sky130_fd_sc_hd__mux2_1
XFILLER_0_97_233 vssd1 vssd1 vccd1 vccd1 sky130_ef_sc_hd__decap_12
XANTENNA__4775__A2 _4958_/B vssd1 vssd1 vccd1 vccd1 sky130_fd_sc_hd__diode_2
XFILLER_0_65_163 vssd1 vssd1 vccd1 vccd1 sky130_fd_sc_hd__fill_2
XFILLER_0_38_377 vssd1 vssd1 vccd1 vccd1 sky130_fd_sc_hd__fill_2
XFILLER_0_110_38 vssd1 vssd1 vccd1 vccd1 sky130_fd_sc_hd__fill_2
XFILLER_0_21_244 vssd1 vssd1 vccd1 vccd1 sky130_fd_sc_hd__decap_4
XFILLER_0_0_149 vssd1 vssd1 vccd1 vccd1 sky130_fd_sc_hd__fill_2
XTAP_406 vssd1 vccd1 sky130_fd_sc_hd__tapvpwrvgnd_1
XFILLER_0_119_14 vssd1 vssd1 vccd1 vccd1 sky130_fd_sc_hd__fill_2
XTAP_417 vssd1 vccd1 sky130_fd_sc_hd__tapvpwrvgnd_1
XTAP_428 vssd1 vccd1 sky130_fd_sc_hd__tapvpwrvgnd_1
XTAP_439 vssd1 vccd1 sky130_fd_sc_hd__tapvpwrvgnd_1
XFILLER_0_28_34 vssd1 vssd1 vccd1 vccd1 sky130_fd_sc_hd__fill_2
XFILLER_0_135_24 vssd1 vssd1 vccd1 vccd1 sky130_fd_sc_hd__fill_2
XFILLER_0_88_244 vssd1 vssd1 vccd1 vccd1 sky130_fd_sc_hd__fill_2
XFILLER_0_76_406 vssd1 vssd1 vccd1 vccd1 sky130_fd_sc_hd__fill_1
X_5820_ _5824_/B _5820_/B vssd1 vssd1 vccd1 vccd1 _5820_/X sky130_fd_sc_hd__xor2_1
X_5751_ _5761_/B _5750_/X _5796_/A _5574_/B vssd1 vssd1 vccd1 vccd1 _5751_/X sky130_fd_sc_hd__a2bb2o_1
XFILLER_0_29_344 vssd1 vssd1 vccd1 vccd1 sky130_fd_sc_hd__decap_6
XFILLER_0_29_355 vssd1 vssd1 vccd1 vccd1 sky130_fd_sc_hd__decap_4
X_4702_ _4608_/Y _4701_/B _4578_/X vssd1 vssd1 vccd1 vccd1 _4702_/Y sky130_fd_sc_hd__a21oi_1
XFILLER_0_8_238 vssd1 vssd1 vccd1 vccd1 sky130_fd_sc_hd__fill_1
XFILLER_0_44_303 vssd1 vssd1 vccd1 vccd1 sky130_fd_sc_hd__fill_2
X_5682_ _5682_/A vssd1 vssd1 vccd1 vccd1 _5683_/B sky130_fd_sc_hd__inv_2
XFILLER_0_71_111 vssd1 vssd1 vccd1 vccd1 sky130_fd_sc_hd__fill_1
XFILLER_0_60_98 vssd1 vssd1 vccd1 vccd1 sky130_fd_sc_hd__fill_2
XFILLER_0_114_213 vssd1 vssd1 vccd1 vccd1 sky130_fd_sc_hd__fill_2
X_4633_ _4633_/A _4633_/B vssd1 vssd1 vccd1 vccd1 _4633_/X sky130_fd_sc_hd__xor2_1
XANTENNA__6311__S _6315_/S vssd1 vssd1 vccd1 vccd1 sky130_fd_sc_hd__diode_2
X_4564_ _5656_/A _4614_/C _4554_/A _4554_/C vssd1 vssd1 vccd1 vccd1 _4566_/C sky130_fd_sc_hd__a22o_1
XFILLER_0_71_188 vssd1 vssd1 vccd1 vccd1 sky130_fd_sc_hd__decap_4
XFILLER_0_12_211 vssd1 vssd1 vccd1 vccd1 sky130_fd_sc_hd__decap_6
X_6303_ hold112/X hold104/X _6319_/S vssd1 vssd1 vccd1 vccd1 _6786_/D sky130_fd_sc_hd__mux2_1
XFILLER_0_69_74 vssd1 vssd1 vccd1 vccd1 sky130_fd_sc_hd__fill_1
XFILLER_0_8_77 vssd1 vssd1 vccd1 vccd1 sky130_fd_sc_hd__decap_6
X_3515_ _3515_/A vssd1 vssd1 vccd1 vccd1 _3527_/A sky130_fd_sc_hd__inv_2
X_6234_ _6234_/A _6856_/Q vssd1 vssd1 vccd1 vccd1 _6234_/X sky130_fd_sc_hd__or2_1
XFILLER_0_122_290 vssd1 vssd1 vccd1 vccd1 sky130_fd_sc_hd__fill_2
Xclkbuf_leaf_11_clk_i clkbuf_2_3__f_clk_i/X vssd1 vssd1 vccd1 vccd1 _6802_/CLK sky130_fd_sc_hd__clkbuf_16
X_4495_ _4496_/A _4496_/B vssd1 vssd1 vccd1 vccd1 _4495_/X sky130_fd_sc_hd__or2_1
X_3446_ _3447_/A _3447_/B _3447_/C vssd1 vssd1 vccd1 vccd1 _3449_/A sky130_fd_sc_hd__o21a_1
X_6165_ pix_mport_o[42] _6207_/B _6184_/A _6164_/Y vssd1 vssd1 vccd1 vccd1 _6770_/D
+ sky130_fd_sc_hd__a22o_1
XTAP_962 vssd1 vccd1 sky130_fd_sc_hd__tapvpwrvgnd_1
XTAP_951 vssd1 vccd1 sky130_fd_sc_hd__tapvpwrvgnd_1
XTAP_940 vssd1 vccd1 sky130_fd_sc_hd__tapvpwrvgnd_1
X_3377_ _5051_/A _5276_/B _3370_/C _3370_/D vssd1 vssd1 vccd1 vccd1 _3384_/B sky130_fd_sc_hd__a22oi_1
XFILLER_0_40_3 vssd1 vssd1 vccd1 vccd1 sky130_fd_sc_hd__fill_2
XTAP_995 vssd1 vccd1 sky130_fd_sc_hd__tapvpwrvgnd_1
XTAP_984 vssd1 vccd1 sky130_fd_sc_hd__tapvpwrvgnd_1
XTAP_973 vssd1 vccd1 sky130_fd_sc_hd__tapvpwrvgnd_1
X_6096_ _6635_/Q hold248/X _6098_/S vssd1 vssd1 vccd1 vccd1 _6096_/X sky130_fd_sc_hd__mux2_1
Xclkbuf_leaf_26_clk_i clkbuf_leaf_1_clk_i/A vssd1 vssd1 vccd1 vccd1 _6683_/CLK sky130_fd_sc_hd__clkbuf_16
X_5116_ _5766_/A _5115_/C _5115_/D _5115_/B vssd1 vssd1 vccd1 vccd1 _5117_/B sky130_fd_sc_hd__a22o_1
XANTENNA__4067__A _4816_/A vssd1 vssd1 vccd1 vccd1 sky130_fd_sc_hd__diode_2
X_5047_ _5093_/A _5064_/B vssd1 vssd1 vccd1 vccd1 _5048_/B sky130_fd_sc_hd__nand2_1
XFILLER_0_79_211 vssd1 vssd1 vccd1 vccd1 sky130_fd_sc_hd__fill_1
XFILLER_0_39_108 vssd1 vssd1 vccd1 vccd1 sky130_fd_sc_hd__fill_2
XANTENNA__5597__S _5601_/S vssd1 vssd1 vccd1 vccd1 sky130_fd_sc_hd__diode_2
XFILLER_0_94_225 vssd1 vssd1 vccd1 vccd1 sky130_fd_sc_hd__fill_2
X_5949_ _5947_/A tex_height_i[13] _5963_/A _5946_/Y _5948_/X vssd1 vssd1 vccd1 vccd1
+ _5949_/X sky130_fd_sc_hd__o221a_1
XFILLER_0_137_349 vssd1 vssd1 vccd1 vccd1 sky130_fd_sc_hd__fill_2
XANTENNA__4514__B _5687_/B vssd1 vssd1 vccd1 vccd1 sky130_fd_sc_hd__diode_2
XFILLER_0_62_100 vssd1 vssd1 vccd1 vccd1 sky130_fd_sc_hd__fill_2
XANTENNA__4530__A _5666_/A vssd1 vssd1 vccd1 vccd1 sky130_fd_sc_hd__diode_2
XFILLER_0_120_238 vssd1 vssd1 vccd1 vccd1 sky130_fd_sc_hd__fill_2
XFILLER_0_58_406 vssd1 vssd1 vccd1 vccd1 sky130_fd_sc_hd__fill_1
XFILLER_0_85_225 vssd1 vssd1 vccd1 vccd1 sky130_fd_sc_hd__fill_2
XFILLER_0_85_258 vssd1 vssd1 vccd1 vccd1 sky130_fd_sc_hd__fill_2
XFILLER_0_14_69 vssd1 vssd1 vccd1 vccd1 sky130_fd_sc_hd__fill_1
XPHY_261 vssd1 vssd1 vccd1 vccd1 sky130_fd_sc_hd__decap_3
XPHY_250 vssd1 vssd1 vccd1 vccd1 sky130_fd_sc_hd__decap_3
XPHY_272 vssd1 vssd1 vccd1 vccd1 sky130_fd_sc_hd__decap_3
XFILLER_0_5_208 vssd1 vssd1 vccd1 vccd1 sky130_fd_sc_hd__fill_2
XFILLER_0_30_24 vssd1 vssd1 vccd1 vccd1 sky130_fd_sc_hd__fill_2
X_3300_ depth_mport_i[26] vssd1 vssd1 vccd1 vccd1 _3300_/Y sky130_fd_sc_hd__inv_2
X_4280_ _4072_/A _4072_/C _4072_/B vssd1 vssd1 vccd1 vccd1 _4281_/C sky130_fd_sc_hd__a21o_1
XFILLER_0_39_55 vssd1 vssd1 vccd1 vccd1 sky130_fd_sc_hd__fill_1
XFILLER_0_39_99 vssd1 vssd1 vccd1 vccd1 sky130_fd_sc_hd__fill_2
XFILLER_0_55_54 vssd1 vssd1 vccd1 vccd1 sky130_fd_sc_hd__fill_2
XFILLER_0_55_65 vssd1 vssd1 vccd1 vccd1 sky130_fd_sc_hd__fill_1
X_6921_ vssd1 vssd1 vccd1 vccd1 _6921_/HI pix_mport_o[22] sky130_fd_sc_hd__conb_1
X_6852_ _6863_/CLK _6852_/D vssd1 vssd1 vccd1 vccd1 _6852_/Q sky130_fd_sc_hd__dfxtp_1
XANTENNA__6306__S _6319_/S vssd1 vssd1 vccd1 vccd1 sky130_fd_sc_hd__diode_2
XFILLER_0_76_225 vssd1 vssd1 vccd1 vccd1 sky130_fd_sc_hd__fill_2
Xfanout18 _6333_/S vssd1 vssd1 vccd1 vccd1 _6440_/B sky130_fd_sc_hd__buf_4
Xfanout29 _5654_/S vssd1 vssd1 vccd1 vccd1 _5844_/S sky130_fd_sc_hd__buf_8
XFILLER_0_76_236 vssd1 vssd1 vccd1 vccd1 sky130_fd_sc_hd__fill_2
XFILLER_0_71_53 vssd1 vssd1 vccd1 vccd1 sky130_fd_sc_hd__decap_3
X_5803_ tex_addr_i[15] _5803_/B _5803_/C _5803_/D vssd1 vssd1 vccd1 vccd1 _5804_/A
+ sky130_fd_sc_hd__or4_4
X_6783_ _6812_/CLK _6783_/D _6320_/C vssd1 vssd1 vccd1 vccd1 _6783_/Q sky130_fd_sc_hd__dfrtp_4
XFILLER_0_91_206 vssd1 vssd1 vccd1 vccd1 sky130_fd_sc_hd__fill_1
XFILLER_0_17_303 vssd1 vssd1 vccd1 vccd1 sky130_fd_sc_hd__decap_8
XFILLER_0_29_152 vssd1 vssd1 vccd1 vccd1 sky130_fd_sc_hd__fill_2
X_3995_ _3923_/X _3941_/Y _3973_/A _3972_/Y vssd1 vssd1 vccd1 vccd1 _3996_/D sky130_fd_sc_hd__a211o_1
X_5734_ _5733_/Y _6515_/Q _5768_/S vssd1 vssd1 vccd1 vccd1 _5737_/B sky130_fd_sc_hd__mux2_1
XFILLER_0_29_185 vssd1 vssd1 vccd1 vccd1 sky130_fd_sc_hd__decap_6
XFILLER_0_127_393 vssd1 vssd1 vccd1 vccd1 sky130_ef_sc_hd__decap_12
XFILLER_0_127_371 vssd1 vssd1 vccd1 vccd1 sky130_ef_sc_hd__decap_12
X_5665_ _5666_/A _5666_/B vssd1 vssd1 vccd1 vccd1 _5687_/C sky130_fd_sc_hd__or2_1
XFILLER_0_32_306 vssd1 vssd1 vccd1 vccd1 sky130_fd_sc_hd__fill_2
X_4616_ _4614_/X _4616_/B vssd1 vssd1 vccd1 vccd1 _4655_/A sky130_fd_sc_hd__nand2b_1
XFILLER_0_88_3 vssd1 vssd1 vccd1 vccd1 sky130_fd_sc_hd__fill_1
XFILLER_0_111_70 vssd1 vssd1 vccd1 vccd1 sky130_fd_sc_hd__decap_3
X_5596_ _5434_/X tex_mport_o[59] _5598_/S vssd1 vssd1 vccd1 vccd1 _6616_/D sky130_fd_sc_hd__mux2_1
XFILLER_0_102_249 vssd1 vssd1 vccd1 vccd1 sky130_fd_sc_hd__decap_3
X_4547_ _4547_/A _4547_/B vssd1 vssd1 vccd1 vccd1 _5389_/A sky130_fd_sc_hd__xor2_2
XANTENNA__5880__S _5923_/S vssd1 vssd1 vccd1 vccd1 sky130_fd_sc_hd__diode_2
X_4478_ _4478_/A _4478_/B vssd1 vssd1 vccd1 vccd1 _4480_/B sky130_fd_sc_hd__xnor2_1
X_6217_ fb_i _6217_/B vssd1 vssd1 vccd1 vccd1 _6218_/B sky130_fd_sc_hd__xnor2_1
X_3429_ _3432_/D vssd1 vssd1 vccd1 vccd1 _3429_/Y sky130_fd_sc_hd__inv_2
X_6148_ _6786_/Q _6788_/Q vssd1 vssd1 vccd1 vccd1 _6149_/B sky130_fd_sc_hd__or2_1
XTAP_770 vssd1 vccd1 sky130_fd_sc_hd__tapvpwrvgnd_1
XTAP_792 vssd1 vccd1 sky130_fd_sc_hd__tapvpwrvgnd_1
XTAP_781 vssd1 vccd1 sky130_fd_sc_hd__tapvpwrvgnd_1
X_6079_ hold84/X hold78/X _6315_/S vssd1 vssd1 vccd1 vccd1 _6717_/D sky130_fd_sc_hd__mux2_1
XFILLER_0_67_225 vssd1 vssd1 vccd1 vccd1 sky130_fd_sc_hd__fill_2
XFILLER_0_67_214 vssd1 vssd1 vccd1 vccd1 sky130_fd_sc_hd__fill_2
XFILLER_0_75_291 vssd1 vssd1 vccd1 vccd1 sky130_fd_sc_hd__decap_8
XFILLER_0_35_122 vssd1 vssd1 vccd1 vccd1 sky130_fd_sc_hd__fill_2
XFILLER_0_118_393 vssd1 vssd1 vccd1 vccd1 sky130_ef_sc_hd__decap_12
XFILLER_0_90_250 vssd1 vssd1 vccd1 vccd1 sky130_fd_sc_hd__fill_2
XFILLER_0_133_363 vssd1 vssd1 vccd1 vccd1 sky130_fd_sc_hd__fill_1
XFILLER_0_50_136 vssd1 vssd1 vccd1 vccd1 sky130_fd_sc_hd__fill_2
XANTENNA__5091__A _5091_/A vssd1 vssd1 vccd1 vccd1 sky130_fd_sc_hd__diode_2
XANTENNA__6126__S _6224_/B vssd1 vssd1 vccd1 vccd1 sky130_fd_sc_hd__diode_2
XANTENNA__3977__C _6678_/Q vssd1 vssd1 vccd1 vccd1 sky130_fd_sc_hd__diode_2
XFILLER_0_58_203 vssd1 vssd1 vccd1 vccd1 sky130_fd_sc_hd__fill_2
XFILLER_0_58_225 vssd1 vssd1 vccd1 vccd1 sky130_fd_sc_hd__fill_2
XFILLER_0_58_236 vssd1 vssd1 vccd1 vccd1 sky130_fd_sc_hd__fill_2
XFILLER_0_128_146 vssd1 vssd1 vccd1 vccd1 sky130_fd_sc_hd__fill_1
X_3780_ _3771_/A _3771_/B _3771_/C vssd1 vssd1 vccd1 vccd1 _3780_/Y sky130_fd_sc_hd__o21ai_1
XFILLER_0_41_45 vssd1 vssd1 vccd1 vccd1 sky130_fd_sc_hd__fill_2
XFILLER_0_109_393 vssd1 vssd1 vccd1 vccd1 sky130_ef_sc_hd__decap_12
XFILLER_0_41_103 vssd1 vssd1 vccd1 vccd1 sky130_fd_sc_hd__fill_2
X_5450_ _5443_/Y _5444_/X _5448_/Y _5449_/X vssd1 vssd1 vccd1 vccd1 _5456_/B sky130_fd_sc_hd__o22a_1
X_4401_ _4488_/A _4476_/D vssd1 vssd1 vccd1 vccd1 _4403_/B sky130_fd_sc_hd__nand2_1
XFILLER_0_124_396 vssd1 vssd1 vccd1 vccd1 sky130_fd_sc_hd__decap_8
X_5381_ _6724_/Q _5567_/B vssd1 vssd1 vccd1 vccd1 _5383_/B sky130_fd_sc_hd__xnor2_1
XFILLER_0_22_350 vssd1 vssd1 vccd1 vccd1 sky130_fd_sc_hd__fill_1
XFILLER_0_41_169 vssd1 vssd1 vccd1 vccd1 sky130_fd_sc_hd__fill_1
X_4332_ _4736_/D _4774_/B _4776_/A _4736_/B vssd1 vssd1 vccd1 vccd1 _4334_/A sky130_fd_sc_hd__a22oi_1
XFILLER_0_1_277 vssd1 vssd1 vccd1 vccd1 sky130_fd_sc_hd__decap_3
X_4263_ _4236_/A _4236_/C _4236_/B vssd1 vssd1 vccd1 vccd1 _4264_/C sky130_fd_sc_hd__a21o_1
XANTENNA__4106__B1 _5049_/D vssd1 vssd1 vccd1 vccd1 sky130_fd_sc_hd__diode_2
X_6002_ tex_height_i[8] tex_height_i[7] _6002_/C vssd1 vssd1 vccd1 vccd1 _6008_/B
+ sky130_fd_sc_hd__or3_1
XANTENNA__5854__B1 _5599_/A vssd1 vssd1 vccd1 vccd1 sky130_fd_sc_hd__diode_2
X_4194_ _4194_/A _4194_/B _4201_/A vssd1 vssd1 vccd1 vccd1 _4196_/B sky130_fd_sc_hd__nand3_1
X_6904_ vssd1 vssd1 vccd1 vccd1 _6904_/HI depth_mport_o[63] sky130_fd_sc_hd__conb_1
XANTENNA__6036__S _6038_/C vssd1 vssd1 vccd1 vccd1 sky130_fd_sc_hd__diode_2
XANTENNA__3887__C _5299_/A vssd1 vssd1 vccd1 vccd1 sky130_fd_sc_hd__diode_2
XANTENNA__5082__A1 _5081_/A vssd1 vssd1 vccd1 vccd1 sky130_fd_sc_hd__diode_2
XANTENNA__5082__B2 _5081_/B vssd1 vssd1 vccd1 vccd1 sky130_fd_sc_hd__diode_2
XFILLER_0_82_85 vssd1 vssd1 vccd1 vccd1 sky130_fd_sc_hd__fill_2
XANTENNA__3632__A2 _5300_/A vssd1 vssd1 vccd1 vccd1 sky130_fd_sc_hd__diode_2
XFILLER_0_49_225 vssd1 vssd1 vccd1 vccd1 sky130_fd_sc_hd__decap_3
XFILLER_0_119_113 vssd1 vssd1 vccd1 vccd1 sky130_fd_sc_hd__decap_4
X_6835_ _6855_/CLK _6835_/D vssd1 vssd1 vccd1 vccd1 _6835_/Q sky130_fd_sc_hd__dfxtp_1
XFILLER_0_119_146 vssd1 vssd1 vccd1 vccd1 sky130_fd_sc_hd__fill_2
X_6766_ _6802_/CLK _6766_/D fanout150/X vssd1 vssd1 vccd1 vccd1 pix_mport_o[38] sky130_fd_sc_hd__dfrtp_4
XFILLER_0_64_239 vssd1 vssd1 vccd1 vccd1 sky130_fd_sc_hd__fill_1
XFILLER_0_9_344 vssd1 vssd1 vccd1 vccd1 sky130_fd_sc_hd__decap_3
X_3978_ _5049_/B _6678_/Q _6677_/Q _5049_/A vssd1 vssd1 vccd1 vccd1 _3979_/D sky130_fd_sc_hd__a22o_1
X_5717_ hold292/X _5716_/X _5844_/S vssd1 vssd1 vccd1 vccd1 _6628_/D sky130_fd_sc_hd__mux2_1
XFILLER_0_17_133 vssd1 vssd1 vccd1 vccd1 sky130_fd_sc_hd__fill_2
XFILLER_0_17_144 vssd1 vssd1 vccd1 vccd1 sky130_fd_sc_hd__fill_2
X_6697_ _6830_/CLK _6697_/D vssd1 vssd1 vccd1 vccd1 hold42/A sky130_fd_sc_hd__dfxtp_1
XFILLER_0_72_272 vssd1 vssd1 vccd1 vccd1 sky130_fd_sc_hd__fill_1
XFILLER_0_17_177 vssd1 vssd1 vccd1 vccd1 sky130_fd_sc_hd__fill_2
XFILLER_0_115_385 vssd1 vssd1 vccd1 vccd1 sky130_fd_sc_hd__decap_6
XFILLER_0_115_352 vssd1 vssd1 vccd1 vccd1 sky130_fd_sc_hd__decap_4
X_5648_ _5649_/B _5649_/C _5649_/A vssd1 vssd1 vccd1 vccd1 _5648_/Y sky130_fd_sc_hd__a21oi_1
X_5579_ _5395_/X tex_mport_o[46] _5598_/S vssd1 vssd1 vccd1 vccd1 _6603_/D sky130_fd_sc_hd__mux2_1
XFILLER_0_20_309 vssd1 vssd1 vccd1 vccd1 sky130_fd_sc_hd__decap_4
XFILLER_0_130_377 vssd1 vssd1 vccd1 vccd1 sky130_ef_sc_hd__decap_12
Xhold240 _6555_/Q vssd1 vssd1 vccd1 vccd1 hold240/X sky130_fd_sc_hd__dlygate4sd3_1
XFILLER_0_13_383 vssd1 vssd1 vccd1 vccd1 sky130_fd_sc_hd__decap_8
Xhold251 _6668_/Q vssd1 vssd1 vccd1 vccd1 hold251/X sky130_fd_sc_hd__dlygate4sd3_1
Xhold262 _6745_/Q vssd1 vssd1 vccd1 vccd1 hold262/X sky130_fd_sc_hd__dlygate4sd3_1
Xhold295 _6671_/Q vssd1 vssd1 vccd1 vccd1 hold295/X sky130_fd_sc_hd__dlygate4sd3_1
Xhold284 _6648_/Q vssd1 vssd1 vccd1 vccd1 hold284/X sky130_fd_sc_hd__dlygate4sd3_1
XFILLER_0_40_191 vssd1 vssd1 vccd1 vccd1 sky130_fd_sc_hd__fill_2
Xhold273 _6100_/X vssd1 vssd1 vccd1 vccd1 _6738_/D sky130_fd_sc_hd__dlygate4sd3_1
XANTENNA__3871__A2 _3961_/A vssd1 vssd1 vccd1 vccd1 sky130_fd_sc_hd__diode_2
XANTENNA_102 sstream_i[5] vssd1 vssd1 vccd1 vccd1 sky130_fd_sc_hd__diode_2
XANTENNA_113 sstream_i[9] vssd1 vssd1 vccd1 vccd1 sky130_fd_sc_hd__diode_2
XANTENNA_124 tex_addr_i[12] vssd1 vssd1 vccd1 vccd1 sky130_fd_sc_hd__diode_2
XFILLER_0_95_320 vssd1 vssd1 vccd1 vccd1 sky130_fd_sc_hd__fill_2
XANTENNA_135 tex_addr_i[5] vssd1 vssd1 vccd1 vccd1 sky130_fd_sc_hd__diode_2
XANTENNA_146 tex_width_i[1] vssd1 vssd1 vccd1 vccd1 sky130_fd_sc_hd__diode_2
XANTENNA_157 tex_addr_i[17] vssd1 vssd1 vccd1 vccd1 sky130_fd_sc_hd__diode_2
XFILLER_0_95_364 vssd1 vssd1 vccd1 vccd1 sky130_ef_sc_hd__decap_12
XANTENNA__5785__S _5844_/S vssd1 vssd1 vccd1 vccd1 sky130_fd_sc_hd__diode_2
XFILLER_0_11_15 vssd1 vssd1 vccd1 vccd1 sky130_ef_sc_hd__decap_12
XFILLER_0_133_160 vssd1 vssd1 vccd1 vccd1 sky130_fd_sc_hd__fill_1
XFILLER_0_106_363 vssd1 vssd1 vccd1 vccd1 sky130_fd_sc_hd__fill_1
XFILLER_0_87_19 vssd1 vssd1 vccd1 vccd1 sky130_fd_sc_hd__fill_2
XFILLER_0_23_169 vssd1 vssd1 vccd1 vccd1 sky130_fd_sc_hd__fill_2
XANTENNA__4140__D _4822_/B vssd1 vssd1 vccd1 vccd1 sky130_fd_sc_hd__diode_2
XFILLER_0_127_47 vssd1 vssd1 vccd1 vccd1 sky130_fd_sc_hd__fill_1
XFILLER_0_78_309 vssd1 vssd1 vccd1 vccd1 sky130_fd_sc_hd__fill_1
XANTENNA__6364__B hold53/A vssd1 vssd1 vccd1 vccd1 sky130_fd_sc_hd__diode_2
XANTENNA__4811__A1 _4971_/D vssd1 vssd1 vccd1 vccd1 sky130_fd_sc_hd__diode_2
XANTENNA__4811__B2 _4970_/B vssd1 vssd1 vccd1 vccd1 sky130_fd_sc_hd__diode_2
X_4950_ _4949_/A _4949_/B _4941_/X vssd1 vssd1 vccd1 vccd1 _4951_/C sky130_fd_sc_hd__o21bai_1
X_3901_ _3901_/A _3901_/B vssd1 vssd1 vccd1 vccd1 _3929_/B sky130_fd_sc_hd__xor2_2
X_4881_ _4869_/A _4869_/C _4869_/B vssd1 vssd1 vccd1 vccd1 _4881_/Y sky130_fd_sc_hd__a21oi_2
X_3832_ _3875_/A _3875_/B vssd1 vssd1 vccd1 vccd1 _3832_/Y sky130_fd_sc_hd__nor2_1
X_6620_ _6751_/CLK _6620_/D fanout139/X vssd1 vssd1 vccd1 vccd1 tex_mport_o[63] sky130_fd_sc_hd__dfrtp_4
XFILLER_0_52_77 vssd1 vssd1 vccd1 vccd1 sky130_fd_sc_hd__fill_1
X_6551_ _6864_/CLK _6551_/D vssd1 vssd1 vccd1 vccd1 _6551_/Q sky130_fd_sc_hd__dfxtp_1
X_5502_ hold27/X sstream_i[93] _5502_/S vssd1 vssd1 vccd1 vccd1 _6535_/D sky130_fd_sc_hd__mux2_1
XFILLER_0_6_336 vssd1 vssd1 vccd1 vccd1 sky130_fd_sc_hd__fill_2
XANTENNA__3509__A _5286_/A vssd1 vssd1 vccd1 vccd1 sky130_fd_sc_hd__diode_2
X_3763_ _3765_/A _3763_/B vssd1 vssd1 vccd1 vccd1 _3847_/B sky130_fd_sc_hd__and2_1
XFILLER_0_112_300 vssd1 vssd1 vccd1 vccd1 sky130_fd_sc_hd__fill_2
XFILLER_0_14_147 vssd1 vssd1 vccd1 vccd1 sky130_fd_sc_hd__decap_4
XFILLER_0_14_114 vssd1 vssd1 vccd1 vccd1 sky130_fd_sc_hd__fill_1
X_3694_ _3694_/A _3694_/B _3694_/C vssd1 vssd1 vccd1 vccd1 _3703_/A sky130_fd_sc_hd__or3_1
XANTENNA__5119__A2 _4776_/A vssd1 vssd1 vccd1 vccd1 sky130_fd_sc_hd__diode_2
X_6482_ hold183/X sstream_i[40] _6493_/S vssd1 vssd1 vccd1 vccd1 _6873_/D sky130_fd_sc_hd__mux2_1
XFILLER_0_14_158 vssd1 vssd1 vccd1 vccd1 sky130_fd_sc_hd__decap_4
X_5433_ _5433_/A _5433_/B _5594_/B vssd1 vssd1 vccd1 vccd1 _5436_/C sky130_fd_sc_hd__or3_1
XFILLER_0_112_355 vssd1 vssd1 vccd1 vccd1 sky130_fd_sc_hd__fill_2
X_5364_ _5364_/A _5364_/B vssd1 vssd1 vccd1 vccd1 _5728_/B sky130_fd_sc_hd__xor2_2
X_4315_ _5718_/B _4841_/D vssd1 vssd1 vccd1 vccd1 _4387_/A sky130_fd_sc_hd__nand2_1
XANTENNA__3550__A1 _3961_/A vssd1 vssd1 vccd1 vccd1 sky130_fd_sc_hd__diode_2
X_5295_ _5295_/A _5295_/B vssd1 vssd1 vccd1 vccd1 _5333_/A sky130_fd_sc_hd__xnor2_4
X_4246_ _4242_/Y _4245_/Y _4230_/X _4231_/Y vssd1 vssd1 vccd1 vccd1 _4246_/X sky130_fd_sc_hd__o211a_2
X_4177_ _4433_/D _4816_/B _4731_/A _4176_/D vssd1 vssd1 vccd1 vccd1 _4177_/X sky130_fd_sc_hd__a22o_1
XTAP_1029 vssd1 vccd1 sky130_fd_sc_hd__tapvpwrvgnd_1
XTAP_1018 vssd1 vccd1 sky130_fd_sc_hd__tapvpwrvgnd_1
XTAP_1007 vssd1 vccd1 sky130_fd_sc_hd__tapvpwrvgnd_1
XFILLER_0_96_139 vssd1 vssd1 vccd1 vccd1 sky130_fd_sc_hd__fill_1
X_6818_ _6818_/CLK _6818_/D fanout150/X vssd1 vssd1 vccd1 vccd1 depth_mport_o[40]
+ sky130_fd_sc_hd__dfrtp_4
XFILLER_0_92_312 vssd1 vssd1 vccd1 vccd1 sky130_fd_sc_hd__fill_2
XANTENNA__3369__A1 _5049_/A vssd1 vssd1 vccd1 vccd1 sky130_fd_sc_hd__diode_2
XFILLER_0_9_185 vssd1 vssd1 vccd1 vccd1 sky130_fd_sc_hd__fill_2
XFILLER_0_92_389 vssd1 vssd1 vccd1 vccd1 sky130_ef_sc_hd__decap_12
X_6749_ _6751_/CLK _6749_/D fanout140/X vssd1 vssd1 vccd1 vccd1 _6749_/Q sky130_fd_sc_hd__dfstp_1
XFILLER_0_5_391 vssd1 vssd1 vccd1 vccd1 sky130_fd_sc_hd__fill_1
XFILLER_0_60_253 vssd1 vssd1 vccd1 vccd1 sky130_fd_sc_hd__decap_4
XFILLER_0_60_264 vssd1 vssd1 vccd1 vccd1 sky130_fd_sc_hd__decap_3
XFILLER_0_130_141 vssd1 vssd1 vccd1 vccd1 sky130_fd_sc_hd__fill_2
XFILLER_0_20_128 vssd1 vssd1 vccd1 vccd1 sky130_fd_sc_hd__fill_2
XFILLER_0_130_174 vssd1 vssd1 vccd1 vccd1 sky130_fd_sc_hd__fill_1
XFILLER_0_103_388 vssd1 vssd1 vccd1 vccd1 sky130_fd_sc_hd__decap_4
XFILLER_0_13_191 vssd1 vssd1 vccd1 vccd1 sky130_fd_sc_hd__decap_6
XANTENNA__5046__A1 _5272_/B vssd1 vssd1 vccd1 vccd1 sky130_fd_sc_hd__diode_2
XFILLER_0_87_139 vssd1 vssd1 vccd1 vccd1 sky130_fd_sc_hd__fill_2
XFILLER_0_28_206 vssd1 vssd1 vccd1 vccd1 sky130_fd_sc_hd__fill_2
XFILLER_0_95_194 vssd1 vssd1 vccd1 vccd1 sky130_fd_sc_hd__decap_4
XPHY_70 vssd1 vssd1 vccd1 vccd1 sky130_fd_sc_hd__decap_3
XPHY_81 vssd1 vssd1 vccd1 vccd1 sky130_fd_sc_hd__decap_3
XPHY_92 vssd1 vssd1 vccd1 vccd1 sky130_fd_sc_hd__decap_3
XFILLER_0_138_285 vssd1 vssd1 vccd1 vccd1 sky130_fd_sc_hd__fill_2
XANTENNA__4432__B _4518_/D vssd1 vssd1 vccd1 vccd1 sky130_fd_sc_hd__diode_2
XFILLER_0_113_108 vssd1 vssd1 vccd1 vccd1 sky130_fd_sc_hd__fill_2
XFILLER_0_36_283 vssd1 vssd1 vccd1 vccd1 sky130_fd_sc_hd__fill_1
XANTENNA__4151__C _4944_/B vssd1 vssd1 vccd1 vccd1 sky130_fd_sc_hd__diode_2
XFILLER_0_106_193 vssd1 vssd1 vccd1 vccd1 sky130_fd_sc_hd__decap_3
XFILLER_0_11_117 vssd1 vssd1 vccd1 vccd1 sky130_fd_sc_hd__decap_6
X_4100_ _4970_/B _5718_/B _4146_/A _4099_/D vssd1 vssd1 vccd1 vccd1 _4101_/C sky130_fd_sc_hd__a22o_1
X_5080_ _4822_/B _5115_/D _4968_/B _4966_/X vssd1 vssd1 vccd1 vccd1 _5085_/A sky130_fd_sc_hd__a31o_1
XFILLER_0_47_33 vssd1 vssd1 vccd1 vccd1 sky130_fd_sc_hd__fill_1
XFILLER_0_47_55 vssd1 vssd1 vccd1 vccd1 sky130_fd_sc_hd__fill_1
X_4031_ _4842_/A _5732_/A _4841_/D vssd1 vssd1 vccd1 vccd1 _4031_/X sky130_fd_sc_hd__and3_1
XANTENNA__3999__A _3999_/A vssd1 vssd1 vccd1 vccd1 sky130_fd_sc_hd__diode_2
XFILLER_0_78_106 vssd1 vssd1 vccd1 vccd1 sky130_fd_sc_hd__fill_1
X_5982_ tex_height_i[3] _5982_/B vssd1 vssd1 vccd1 vccd1 _5987_/B sky130_fd_sc_hd__or2_1
XFILLER_0_93_109 vssd1 vssd1 vccd1 vccd1 sky130_fd_sc_hd__decap_3
XANTENNA__3599__A1 _5081_/B vssd1 vssd1 vccd1 vccd1 sky130_fd_sc_hd__diode_2
X_4933_ _4933_/A _4933_/B vssd1 vssd1 vccd1 vccd1 _4935_/B sky130_fd_sc_hd__xnor2_1
XANTENNA__6314__S _6319_/S vssd1 vssd1 vccd1 vccd1 sky130_fd_sc_hd__diode_2
XFILLER_0_86_172 vssd1 vssd1 vccd1 vccd1 sky130_fd_sc_hd__fill_2
XANTENNA__4045__D _4433_/D vssd1 vssd1 vccd1 vccd1 sky130_fd_sc_hd__diode_2
XANTENNA_13 sstream_i[11] vssd1 vssd1 vccd1 vccd1 sky130_fd_sc_hd__diode_2
X_4864_ _4850_/A _4850_/C _4850_/B vssd1 vssd1 vccd1 vccd1 _4865_/C sky130_fd_sc_hd__a21o_1
XANTENNA_35 sstream_i[14] vssd1 vssd1 vccd1 vccd1 sky130_fd_sc_hd__diode_2
XANTENNA_57 sstream_i[19] vssd1 vssd1 vccd1 vccd1 sky130_fd_sc_hd__diode_2
XANTENNA_46 sstream_i[16] vssd1 vssd1 vccd1 vccd1 sky130_fd_sc_hd__diode_2
XANTENNA_24 sstream_i[12] vssd1 vssd1 vccd1 vccd1 sky130_fd_sc_hd__diode_2
X_6603_ _6802_/CLK _6603_/D fanout142/X vssd1 vssd1 vccd1 vccd1 tex_mport_o[46] sky130_fd_sc_hd__dfrtp_4
XFILLER_0_6_144 vssd1 vssd1 vccd1 vccd1 sky130_fd_sc_hd__fill_2
XFILLER_0_6_133 vssd1 vssd1 vccd1 vccd1 sky130_fd_sc_hd__decap_6
X_3815_ _3815_/A _3815_/B _3815_/C vssd1 vssd1 vccd1 vccd1 _3815_/X sky130_fd_sc_hd__or3_4
XFILLER_0_27_261 vssd1 vssd1 vccd1 vccd1 sky130_fd_sc_hd__decap_3
X_4795_ _4942_/A _4794_/B _4942_/B _5083_/A vssd1 vssd1 vccd1 vccd1 _4796_/C sky130_fd_sc_hd__a22o_1
XANTENNA_68 sstream_i[23] vssd1 vssd1 vccd1 vccd1 sky130_fd_sc_hd__diode_2
XANTENNA_79 sstream_i[2] vssd1 vssd1 vccd1 vccd1 sky130_fd_sc_hd__diode_2
X_6534_ _6855_/CLK _6534_/D vssd1 vssd1 vccd1 vccd1 hold15/A sky130_fd_sc_hd__dfxtp_1
XANTENNA_fanout124_A _5766_/A vssd1 vssd1 vccd1 vccd1 sky130_fd_sc_hd__diode_2
X_3746_ _3749_/D vssd1 vssd1 vccd1 vccd1 _3746_/Y sky130_fd_sc_hd__inv_2
X_6465_ hold167/X sstream_i[23] _6465_/S vssd1 vssd1 vccd1 vccd1 _6856_/D sky130_fd_sc_hd__mux2_1
X_3677_ _3687_/A _3675_/X _3664_/X _3672_/Y vssd1 vssd1 vccd1 vccd1 _3678_/D sky130_fd_sc_hd__a211o_1
X_5416_ _5416_/A _5416_/B _5428_/B vssd1 vssd1 vccd1 vccd1 _5418_/C sky130_fd_sc_hd__nand3_1
X_6396_ depth_mport_o[46] _6441_/B _6404_/A _6395_/Y vssd1 vssd1 vccd1 vccd1 _6824_/D
+ sky130_fd_sc_hd__o22a_1
X_5347_ _5445_/C _5349_/C vssd1 vssd1 vccd1 vccd1 _5588_/B sky130_fd_sc_hd__and2_2
X_5278_ _5278_/A _5278_/B vssd1 vssd1 vccd1 vccd1 _5279_/B sky130_fd_sc_hd__xnor2_1
X_4229_ _4230_/A _4230_/B _4230_/C vssd1 vssd1 vccd1 vccd1 _4229_/Y sky130_fd_sc_hd__nor3_1
XANTENNA__3421__B _5286_/B vssd1 vssd1 vccd1 vccd1 sky130_fd_sc_hd__diode_2
XANTENNA_fanout37_A _6683_/Q vssd1 vssd1 vccd1 vccd1 sky130_fd_sc_hd__diode_2
XFILLER_0_92_120 vssd1 vssd1 vccd1 vccd1 sky130_fd_sc_hd__fill_1
XFILLER_0_92_153 vssd1 vssd1 vccd1 vccd1 sky130_fd_sc_hd__fill_2
XFILLER_0_65_389 vssd1 vssd1 vccd1 vccd1 sky130_fd_sc_hd__decap_3
XFILLER_0_92_197 vssd1 vssd1 vccd1 vccd1 sky130_fd_sc_hd__decap_8
XANTENNA__3762__A1 _3999_/A vssd1 vssd1 vccd1 vccd1 sky130_fd_sc_hd__diode_2
XFILLER_0_0_309 vssd1 vssd1 vccd1 vccd1 sky130_fd_sc_hd__fill_2
XANTENNA__5083__B _5083_/B vssd1 vssd1 vccd1 vccd1 sky130_fd_sc_hd__diode_2
XANTENNA__5811__B _5919_/B vssd1 vssd1 vccd1 vccd1 sky130_fd_sc_hd__diode_2
XFILLER_0_17_36 vssd1 vssd1 vccd1 vccd1 sky130_ef_sc_hd__decap_12
XANTENNA__4427__B _4614_/C vssd1 vssd1 vccd1 vccd1 sky130_fd_sc_hd__diode_2
XFILLER_0_33_24 vssd1 vssd1 vccd1 vccd1 sky130_fd_sc_hd__fill_2
XFILLER_0_33_57 vssd1 vssd1 vccd1 vccd1 sky130_fd_sc_hd__fill_2
XFILLER_0_56_323 vssd1 vssd1 vccd1 vccd1 sky130_fd_sc_hd__decap_3
XFILLER_0_83_164 vssd1 vssd1 vccd1 vccd1 sky130_fd_sc_hd__fill_2
X_4580_ _4580_/A _4580_/B vssd1 vssd1 vccd1 vccd1 _4609_/A sky130_fd_sc_hd__nand2_1
X_3600_ _3601_/A _3601_/B vssd1 vssd1 vccd1 vccd1 _3605_/B sky130_fd_sc_hd__and2b_1
XFILLER_0_109_3 vssd1 vssd1 vccd1 vccd1 sky130_fd_sc_hd__fill_2
X_3531_ _3531_/A _3531_/B vssd1 vssd1 vccd1 vccd1 _3545_/A sky130_fd_sc_hd__nand2_1
XFILLER_0_3_125 vssd1 vssd1 vccd1 vccd1 sky130_fd_sc_hd__decap_6
X_6250_ _6252_/A _6844_/Q _3318_/Y _6843_/Q vssd1 vssd1 vccd1 vccd1 _6251_/A sky130_fd_sc_hd__a22o_1
X_3462_ _3462_/A _3554_/A vssd1 vssd1 vccd1 vccd1 _3471_/A sky130_fd_sc_hd__or2_1
X_6181_ _6182_/A _6182_/B vssd1 vssd1 vccd1 vccd1 _6190_/B sky130_fd_sc_hd__or2_1
X_3393_ _3393_/A _3393_/B _3393_/C vssd1 vssd1 vccd1 vccd1 _3395_/B sky130_fd_sc_hd__nor3_1
X_5201_ _5201_/A _5201_/B vssd1 vssd1 vccd1 vccd1 _5203_/B sky130_fd_sc_hd__nor2_1
XFILLER_0_58_54 vssd1 vssd1 vccd1 vccd1 sky130_fd_sc_hd__decap_3
X_5132_ _3973_/A _3973_/C _3973_/B vssd1 vssd1 vccd1 vccd1 _5132_/Y sky130_fd_sc_hd__o21ai_1
XANTENNA__6309__S _6319_/S vssd1 vssd1 vccd1 vccd1 sky130_fd_sc_hd__diode_2
XANTENNA__3808__A2 _5320_/A vssd1 vssd1 vccd1 vccd1 sky130_fd_sc_hd__diode_2
X_5063_ _5093_/A _5064_/B _5045_/X _4938_/X _6682_/Q vssd1 vssd1 vccd1 vccd1 _5065_/A
+ sky130_fd_sc_hd__a32o_1
X_4014_ _4013_/A _4012_/Y _3932_/X _3939_/Y vssd1 vssd1 vccd1 vccd1 _4017_/A sky130_fd_sc_hd__o211a_1
X_5965_ _6892_/Q _6891_/Q hold36/A hold85/A vssd1 vssd1 vccd1 vccd1 _5969_/A sky130_fd_sc_hd__or4_1
X_4916_ _4917_/B _4917_/A vssd1 vssd1 vccd1 vccd1 _4916_/X sky130_fd_sc_hd__and2b_1
X_5896_ tex_addr_i[28] _5913_/B vssd1 vssd1 vccd1 vccd1 _5897_/B sky130_fd_sc_hd__nand2_1
XFILLER_0_59_194 vssd1 vssd1 vccd1 vccd1 sky130_fd_sc_hd__fill_2
XFILLER_0_62_304 vssd1 vssd1 vccd1 vccd1 sky130_fd_sc_hd__decap_4
XFILLER_0_47_389 vssd1 vssd1 vccd1 vccd1 sky130_fd_sc_hd__decap_3
X_4847_ _4847_/A _4847_/B _4847_/C vssd1 vssd1 vccd1 vccd1 _4850_/A sky130_fd_sc_hd__nand3_1
XFILLER_0_74_197 vssd1 vssd1 vccd1 vccd1 sky130_fd_sc_hd__fill_2
XFILLER_0_15_220 vssd1 vssd1 vccd1 vccd1 sky130_fd_sc_hd__fill_1
XFILLER_0_132_225 vssd1 vssd1 vccd1 vccd1 sky130_fd_sc_hd__decap_3
XFILLER_0_99_72 vssd1 vssd1 vccd1 vccd1 sky130_fd_sc_hd__decap_3
X_4778_ _4971_/B _4971_/D _4966_/A _4966_/C vssd1 vssd1 vccd1 vccd1 _4778_/X sky130_fd_sc_hd__and4_1
X_6517_ _6834_/CLK _6517_/D vssd1 vssd1 vccd1 vccd1 _6517_/Q sky130_fd_sc_hd__dfxtp_1
XFILLER_0_15_275 vssd1 vssd1 vccd1 vccd1 sky130_fd_sc_hd__fill_2
X_3729_ _3645_/X _3729_/B _3729_/C vssd1 vssd1 vccd1 vccd1 _3755_/A sky130_fd_sc_hd__and3b_1
XFILLER_0_30_212 vssd1 vssd1 vccd1 vccd1 sky130_fd_sc_hd__fill_1
X_6448_ hold119/X sstream_i[6] _6464_/S vssd1 vssd1 vccd1 vccd1 _6839_/D sky130_fd_sc_hd__mux2_1
X_6379_ _6378_/A _6392_/A _6441_/B vssd1 vssd1 vccd1 vccd1 _6379_/X sky130_fd_sc_hd__o21a_1
XFILLER_0_100_133 vssd1 vssd1 vccd1 vccd1 sky130_fd_sc_hd__decap_6
XANTENNA__3416__B _5286_/A vssd1 vssd1 vccd1 vccd1 sky130_fd_sc_hd__diode_2
XANTENNA__6738__SET_B fanout140/X vssd1 vssd1 vccd1 vccd1 sky130_fd_sc_hd__diode_2
XFILLER_0_97_245 vssd1 vssd1 vccd1 vccd1 sky130_ef_sc_hd__decap_12
XFILLER_0_80_123 vssd1 vssd1 vccd1 vccd1 sky130_fd_sc_hd__fill_2
XANTENNA__6757__RESET_B fanout149/X vssd1 vssd1 vccd1 vccd1 sky130_fd_sc_hd__diode_2
XFILLER_0_53_359 vssd1 vssd1 vccd1 vccd1 sky130_fd_sc_hd__decap_4
XFILLER_0_123_269 vssd1 vssd1 vccd1 vccd1 sky130_fd_sc_hd__fill_2
XFILLER_0_95_19 vssd1 vssd1 vccd1 vccd1 sky130_fd_sc_hd__fill_1
XTAP_407 vssd1 vccd1 sky130_fd_sc_hd__tapvpwrvgnd_1
XTAP_418 vssd1 vccd1 sky130_fd_sc_hd__tapvpwrvgnd_1
XTAP_429 vssd1 vccd1 sky130_fd_sc_hd__tapvpwrvgnd_1
XFILLER_0_28_24 vssd1 vssd1 vccd1 vccd1 sky130_fd_sc_hd__fill_2
XFILLER_0_28_46 vssd1 vssd1 vccd1 vccd1 sky130_fd_sc_hd__fill_2
XANTENNA__6129__S _6224_/B vssd1 vssd1 vccd1 vccd1 sky130_fd_sc_hd__diode_2
Xclkbuf_leaf_7_clk_i clkbuf_leaf_9_clk_i/A vssd1 vssd1 vccd1 vccd1 _6853_/CLK sky130_fd_sc_hd__clkbuf_16
XFILLER_0_135_69 vssd1 vssd1 vccd1 vccd1 sky130_fd_sc_hd__fill_2
XFILLER_0_44_67 vssd1 vssd1 vccd1 vccd1 sky130_fd_sc_hd__fill_2
X_5750_ _5747_/X _5748_/X _5796_/A vssd1 vssd1 vccd1 vccd1 _5750_/X sky130_fd_sc_hd__a21o_1
XTAP_1190 vssd1 vccd1 sky130_fd_sc_hd__tapvpwrvgnd_1
X_4701_ _4578_/X _4701_/B vssd1 vssd1 vccd1 vccd1 _5363_/A sky130_fd_sc_hd__and2b_1
X_5681_ _5695_/A _5681_/B vssd1 vssd1 vccd1 vccd1 _5682_/A sky130_fd_sc_hd__or2_1
X_4632_ _4631_/A _4631_/B _4631_/C vssd1 vssd1 vccd1 vccd1 _4697_/B sky130_fd_sc_hd__a21oi_1
XFILLER_0_56_186 vssd1 vssd1 vccd1 vccd1 sky130_fd_sc_hd__fill_1
XFILLER_0_114_225 vssd1 vssd1 vccd1 vccd1 sky130_fd_sc_hd__fill_1
XFILLER_0_44_359 vssd1 vssd1 vccd1 vccd1 sky130_fd_sc_hd__fill_2
X_4563_ _4563_/A _4563_/B vssd1 vssd1 vccd1 vccd1 _4566_/B sky130_fd_sc_hd__nor2_1
XFILLER_0_71_178 vssd1 vssd1 vccd1 vccd1 sky130_fd_sc_hd__decap_6
X_6302_ _6785_/Q hold55/X _6319_/S vssd1 vssd1 vccd1 vccd1 hold56/A sky130_fd_sc_hd__mux2_1
X_4494_ _4494_/A _4494_/B vssd1 vssd1 vccd1 vccd1 _4496_/B sky130_fd_sc_hd__xnor2_1
X_3514_ _3514_/A _3514_/B vssd1 vssd1 vccd1 vccd1 _3515_/A sky130_fd_sc_hd__xnor2_1
X_6233_ _6783_/Q _6784_/Q _3265_/Y _6441_/B _6232_/X vssd1 vssd1 vccd1 vccd1 _6233_/X
+ sky130_fd_sc_hd__a221o_1
XFILLER_0_12_278 vssd1 vssd1 vccd1 vccd1 sky130_fd_sc_hd__decap_3
X_3445_ _3445_/A _3445_/B vssd1 vssd1 vccd1 vccd1 _3447_/C sky130_fd_sc_hd__and2_1
X_6164_ _6163_/A _6163_/B _6207_/B vssd1 vssd1 vccd1 vccd1 _6164_/Y sky130_fd_sc_hd__a21oi_1
XTAP_952 vssd1 vccd1 sky130_fd_sc_hd__tapvpwrvgnd_1
XTAP_941 vssd1 vccd1 sky130_fd_sc_hd__tapvpwrvgnd_1
XTAP_930 vssd1 vccd1 sky130_fd_sc_hd__tapvpwrvgnd_1
XFILLER_0_85_52 vssd1 vssd1 vccd1 vccd1 sky130_fd_sc_hd__decap_4
X_3376_ _3393_/A _3393_/B _3393_/C vssd1 vssd1 vccd1 vccd1 _3395_/A sky130_fd_sc_hd__o21a_1
XTAP_996 vssd1 vccd1 sky130_fd_sc_hd__tapvpwrvgnd_1
XTAP_985 vssd1 vccd1 sky130_fd_sc_hd__tapvpwrvgnd_1
XTAP_974 vssd1 vccd1 sky130_fd_sc_hd__tapvpwrvgnd_1
XTAP_963 vssd1 vccd1 sky130_fd_sc_hd__tapvpwrvgnd_1
XANTENNA__4348__A _4488_/A vssd1 vssd1 vccd1 vccd1 sky130_fd_sc_hd__diode_2
XANTENNA__3252__A _5656_/A vssd1 vssd1 vccd1 vccd1 sky130_fd_sc_hd__diode_2
X_6095_ hold236/X hold270/X _6095_/S vssd1 vssd1 vccd1 vccd1 _6733_/D sky130_fd_sc_hd__mux2_1
X_5115_ _5273_/A _5115_/B _5115_/C _5115_/D vssd1 vssd1 vccd1 vccd1 _5115_/X sky130_fd_sc_hd__and4_1
XFILLER_0_33_3 vssd1 vssd1 vccd1 vccd1 sky130_fd_sc_hd__fill_2
X_5046_ _5272_/B _4938_/X _5045_/X vssd1 vssd1 vccd1 vccd1 _5048_/A sky130_fd_sc_hd__a21bo_1
XFILLER_0_79_223 vssd1 vssd1 vccd1 vccd1 sky130_fd_sc_hd__fill_1
XANTENNA__4067__B _4794_/B vssd1 vssd1 vccd1 vccd1 sky130_fd_sc_hd__diode_2
XFILLER_0_79_256 vssd1 vssd1 vccd1 vccd1 sky130_fd_sc_hd__fill_2
XFILLER_0_79_245 vssd1 vssd1 vccd1 vccd1 sky130_fd_sc_hd__fill_2
X_5948_ _5948_/A tex_height_i[14] vssd1 vssd1 vccd1 vccd1 _5948_/X sky130_fd_sc_hd__or2_1
XFILLER_0_35_326 vssd1 vssd1 vccd1 vccd1 sky130_fd_sc_hd__decap_3
X_5879_ _5342_/Y _5878_/Y _5922_/S vssd1 vssd1 vccd1 vccd1 _5879_/X sky130_fd_sc_hd__mux2_1
XFILLER_0_62_112 vssd1 vssd1 vccd1 vccd1 sky130_fd_sc_hd__fill_1
XFILLER_0_105_225 vssd1 vssd1 vccd1 vccd1 sky130_fd_sc_hd__fill_2
XFILLER_0_62_134 vssd1 vssd1 vccd1 vccd1 sky130_fd_sc_hd__decap_4
XFILLER_0_62_145 vssd1 vssd1 vccd1 vccd1 sky130_fd_sc_hd__fill_2
XANTENNA__4142__A1 _4551_/D vssd1 vssd1 vccd1 vccd1 sky130_fd_sc_hd__diode_2
XANTENNA__4142__B2 _4518_/D vssd1 vssd1 vccd1 vccd1 sky130_fd_sc_hd__diode_2
XANTENNA__5642__A1 _5796_/A vssd1 vssd1 vccd1 vccd1 sky130_fd_sc_hd__diode_2
XFILLER_0_14_15 vssd1 vssd1 vccd1 vccd1 sky130_ef_sc_hd__decap_12
XFILLER_0_85_248 vssd1 vssd1 vccd1 vccd1 sky130_fd_sc_hd__fill_1
XFILLER_0_38_131 vssd1 vssd1 vccd1 vccd1 sky130_fd_sc_hd__decap_3
XPHY_251 vssd1 vssd1 vccd1 vccd1 sky130_fd_sc_hd__decap_3
XPHY_240 vssd1 vssd1 vccd1 vccd1 sky130_fd_sc_hd__decap_3
XPHY_273 vssd1 vssd1 vccd1 vccd1 sky130_fd_sc_hd__decap_3
XPHY_262 vssd1 vssd1 vccd1 vccd1 sky130_fd_sc_hd__decap_3
XFILLER_0_38_197 vssd1 vssd1 vccd1 vccd1 sky130_fd_sc_hd__fill_2
XFILLER_0_121_38 vssd1 vssd1 vccd1 vccd1 sky130_fd_sc_hd__decap_3
XFILLER_0_30_36 vssd1 vssd1 vccd1 vccd1 sky130_fd_sc_hd__fill_2
XFILLER_0_53_145 vssd1 vssd1 vccd1 vccd1 sky130_fd_sc_hd__decap_3
XANTENNA__4721__A _5049_/D vssd1 vssd1 vccd1 vccd1 sky130_fd_sc_hd__diode_2
XFILLER_0_111_206 vssd1 vssd1 vccd1 vccd1 sky130_fd_sc_hd__decap_6
XANTENNA__6721__SET_B fanout145/X vssd1 vssd1 vccd1 vccd1 sky130_fd_sc_hd__diode_2
XANTENNA__5698__S _5844_/S vssd1 vssd1 vccd1 vccd1 sky130_fd_sc_hd__diode_2
X_6920_ vssd1 vssd1 vccd1 vccd1 _6920_/HI pix_mport_o[21] sky130_fd_sc_hd__conb_1
XANTENNA__3644__B1 _5276_/A vssd1 vssd1 vccd1 vccd1 sky130_fd_sc_hd__diode_2
X_6851_ _6863_/CLK _6851_/D vssd1 vssd1 vccd1 vccd1 _6851_/Q sky130_fd_sc_hd__dfxtp_2
Xfanout19 _6315_/S vssd1 vssd1 vccd1 vccd1 _6319_/S sky130_fd_sc_hd__clkbuf_8
XFILLER_0_71_32 vssd1 vssd1 vccd1 vccd1 sky130_fd_sc_hd__fill_1
X_5802_ tex_width_i[15] _5802_/B _5802_/C vssd1 vssd1 vccd1 vccd1 _5803_/D sky130_fd_sc_hd__nor3_2
X_6782_ _6812_/CLK _6782_/D _6320_/C vssd1 vssd1 vccd1 vccd1 _6782_/Q sky130_fd_sc_hd__dfrtp_4
XFILLER_0_71_87 vssd1 vssd1 vccd1 vccd1 sky130_fd_sc_hd__fill_2
X_3994_ _4004_/A _3992_/X _3981_/Y _3988_/X vssd1 vssd1 vccd1 vccd1 _3996_/C sky130_fd_sc_hd__a211o_1
XFILLER_0_134_309 vssd1 vssd1 vccd1 vccd1 sky130_fd_sc_hd__fill_2
XFILLER_0_84_292 vssd1 vssd1 vccd1 vccd1 sky130_fd_sc_hd__decap_3
X_5733_ _5754_/C _5733_/B vssd1 vssd1 vccd1 vccd1 _5733_/Y sky130_fd_sc_hd__nand2_1
XFILLER_0_44_123 vssd1 vssd1 vccd1 vccd1 sky130_fd_sc_hd__fill_2
XANTENNA__6608__RESET_B _5937_/A vssd1 vssd1 vccd1 vccd1 sky130_fd_sc_hd__diode_2
XFILLER_0_127_383 vssd1 vssd1 vccd1 vccd1 sky130_fd_sc_hd__decap_8
X_5664_ hold293/X _5663_/Y _5844_/S vssd1 vssd1 vccd1 vccd1 _6623_/D sky130_fd_sc_hd__mux2_1
X_5595_ tex_mport_o[58] _5598_/S _5594_/Y _5588_/C vssd1 vssd1 vccd1 vccd1 _6615_/D
+ sky130_fd_sc_hd__a22o_1
X_4615_ _5645_/A _4614_/C _4637_/D _5645_/B vssd1 vssd1 vccd1 vccd1 _4616_/B sky130_fd_sc_hd__a22o_1
XFILLER_0_32_318 vssd1 vssd1 vccd1 vccd1 sky130_fd_sc_hd__fill_2
XFILLER_0_44_167 vssd1 vssd1 vccd1 vccd1 sky130_fd_sc_hd__fill_2
XFILLER_0_44_178 vssd1 vssd1 vccd1 vccd1 sky130_fd_sc_hd__fill_2
X_4546_ _4547_/A _4547_/B vssd1 vssd1 vccd1 vccd1 _4546_/Y sky130_fd_sc_hd__nor2_1
XFILLER_0_4_253 vssd1 vssd1 vccd1 vccd1 sky130_fd_sc_hd__fill_2
XFILLER_0_110_250 vssd1 vssd1 vccd1 vccd1 sky130_fd_sc_hd__fill_2
X_4477_ _4477_/A _4477_/B vssd1 vssd1 vccd1 vccd1 _4478_/B sky130_fd_sc_hd__nor2_1
XFILLER_0_40_384 vssd1 vssd1 vccd1 vccd1 sky130_ef_sc_hd__decap_12
X_6216_ hold49/A _6212_/B _6215_/Y vssd1 vssd1 vccd1 vccd1 _6217_/B sky130_fd_sc_hd__o21a_1
X_3428_ _5327_/A _6690_/Q _6691_/Q _5290_/A vssd1 vssd1 vccd1 vccd1 _3432_/D sky130_fd_sc_hd__a22o_1
X_6147_ _6786_/Q _6788_/Q vssd1 vssd1 vccd1 vccd1 _6149_/A sky130_fd_sc_hd__nand2_1
XTAP_760 vssd1 vccd1 sky130_fd_sc_hd__tapvpwrvgnd_1
X_3359_ _3397_/A _6688_/Q _5299_/A _3359_/D vssd1 vssd1 vccd1 vccd1 _3397_/B sky130_fd_sc_hd__and4b_1
XTAP_793 vssd1 vccd1 sky130_fd_sc_hd__tapvpwrvgnd_1
XTAP_782 vssd1 vccd1 sky130_fd_sc_hd__tapvpwrvgnd_1
XTAP_771 vssd1 vccd1 sky130_fd_sc_hd__tapvpwrvgnd_1
XANTENNA__3413__C _5273_/A vssd1 vssd1 vccd1 vccd1 sky130_fd_sc_hd__diode_2
XANTENNA__3883__B1 _5276_/B vssd1 vssd1 vccd1 vccd1 sky130_fd_sc_hd__diode_2
X_6078_ hold79/X hold66/X _6315_/S vssd1 vssd1 vccd1 vccd1 _6716_/D sky130_fd_sc_hd__mux2_1
XANTENNA__5624__B2 _4822_/B vssd1 vssd1 vccd1 vccd1 sky130_fd_sc_hd__diode_2
X_5029_ _5018_/Y _5027_/X _4230_/B _4229_/Y vssd1 vssd1 vccd1 vccd1 _5029_/X sky130_fd_sc_hd__a211o_1
XANTENNA__3710__A _5300_/A vssd1 vssd1 vccd1 vccd1 sky130_fd_sc_hd__diode_2
XFILLER_0_125_309 vssd1 vssd1 vccd1 vccd1 sky130_fd_sc_hd__fill_2
XFILLER_0_35_156 vssd1 vssd1 vccd1 vccd1 sky130_fd_sc_hd__fill_2
XFILLER_0_23_307 vssd1 vssd1 vccd1 vccd1 sky130_fd_sc_hd__fill_2
XFILLER_0_101_272 vssd1 vssd1 vccd1 vccd1 sky130_fd_sc_hd__fill_2
XFILLER_0_101_261 vssd1 vssd1 vccd1 vccd1 sky130_fd_sc_hd__fill_2
XFILLER_0_101_294 vssd1 vssd1 vccd1 vccd1 sky130_fd_sc_hd__decap_3
XANTENNA__5091__B _5091_/B vssd1 vssd1 vccd1 vccd1 sky130_fd_sc_hd__diode_2
XFILLER_0_116_49 vssd1 vssd1 vccd1 vccd1 sky130_fd_sc_hd__fill_2
XFILLER_0_25_36 vssd1 vssd1 vccd1 vccd1 sky130_fd_sc_hd__decap_3
XANTENNA__4716__A _4736_/B vssd1 vssd1 vccd1 vccd1 sky130_fd_sc_hd__diode_2
XFILLER_0_98_373 vssd1 vssd1 vccd1 vccd1 sky130_ef_sc_hd__decap_12
Xclkbuf_leaf_10_clk_i clkbuf_leaf_9_clk_i/A vssd1 vssd1 vccd1 vccd1 _6863_/CLK sky130_fd_sc_hd__clkbuf_16
XANTENNA__6772__RESET_B fanout153/X vssd1 vssd1 vccd1 vccd1 sky130_fd_sc_hd__diode_2
XFILLER_0_116_309 vssd1 vssd1 vccd1 vccd1 sky130_fd_sc_hd__fill_2
XANTENNA__4051__B1 _4966_/B vssd1 vssd1 vccd1 vccd1 sky130_fd_sc_hd__diode_2
XFILLER_0_41_57 vssd1 vssd1 vccd1 vccd1 sky130_fd_sc_hd__decap_3
XFILLER_0_81_240 vssd1 vssd1 vccd1 vccd1 sky130_fd_sc_hd__fill_2
XFILLER_0_26_145 vssd1 vssd1 vccd1 vccd1 sky130_fd_sc_hd__fill_2
XFILLER_0_124_342 vssd1 vssd1 vccd1 vccd1 sky130_fd_sc_hd__fill_1
Xclkbuf_leaf_25_clk_i _6684_/CLK vssd1 vssd1 vccd1 vccd1 _6645_/CLK sky130_fd_sc_hd__clkbuf_16
XANTENNA__6343__A2 _6440_/B vssd1 vssd1 vccd1 vccd1 sky130_fd_sc_hd__diode_2
X_4400_ _4432_/A _4476_/D _4380_/X _4381_/X _4774_/B vssd1 vssd1 vccd1 vccd1 _4403_/A
+ sky130_fd_sc_hd__a32o_1
XFILLER_0_1_201 vssd1 vssd1 vccd1 vccd1 sky130_fd_sc_hd__fill_1
X_5380_ _5380_/A _5380_/B _5380_/C _5380_/D vssd1 vssd1 vccd1 vccd1 _5383_/A sky130_fd_sc_hd__and4_1
X_4331_ _4638_/A _4433_/D vssd1 vssd1 vccd1 vccd1 _4335_/A sky130_fd_sc_hd__nand2_1
X_4262_ _4322_/A _4322_/B vssd1 vssd1 vccd1 vccd1 _4264_/B sky130_fd_sc_hd__and2_1
XANTENNA__4106__A1 _5083_/A vssd1 vssd1 vccd1 vccd1 sky130_fd_sc_hd__diode_2
XANTENNA__4106__B2 _4736_/B vssd1 vssd1 vccd1 vccd1 sky130_fd_sc_hd__diode_2
XFILLER_0_66_21 vssd1 vssd1 vccd1 vccd1 sky130_fd_sc_hd__decap_4
XFILLER_0_5_57 vssd1 vssd1 vccd1 vccd1 sky130_ef_sc_hd__decap_12
X_6001_ _4966_/B _6000_/X _6037_/S vssd1 vssd1 vccd1 vccd1 _6669_/D sky130_fd_sc_hd__mux2_1
X_4193_ _5787_/A _5787_/B _4527_/B _4841_/C vssd1 vssd1 vccd1 vccd1 _4201_/A sky130_fd_sc_hd__and4_1
XANTENNA__5606__A1 _4942_/A vssd1 vssd1 vccd1 vccd1 sky130_fd_sc_hd__diode_2
XANTENNA__6317__S _6319_/S vssd1 vssd1 vccd1 vccd1 sky130_fd_sc_hd__diode_2
XANTENNA__5606__B2 _5687_/A vssd1 vssd1 vccd1 vccd1 sky130_fd_sc_hd__diode_2
X_6903_ vssd1 vssd1 vccd1 vccd1 _6903_/HI depth_mport_o[62] sky130_fd_sc_hd__conb_1
XFILLER_0_49_204 vssd1 vssd1 vccd1 vccd1 sky130_fd_sc_hd__fill_2
X_6834_ _6834_/CLK _6834_/D vssd1 vssd1 vccd1 vccd1 _6834_/Q sky130_fd_sc_hd__dfxtp_1
X_6765_ _6830_/CLK _6765_/D fanout153/X vssd1 vssd1 vccd1 vccd1 pix_mport_o[37] sky130_fd_sc_hd__dfrtp_4
XFILLER_0_119_169 vssd1 vssd1 vccd1 vccd1 sky130_fd_sc_hd__decap_3
X_3977_ _5049_/A _5049_/B _6678_/Q _6677_/Q vssd1 vssd1 vccd1 vccd1 _3979_/C sky130_fd_sc_hd__nand4_1
XFILLER_0_134_117 vssd1 vssd1 vccd1 vccd1 sky130_fd_sc_hd__decap_4
X_5716_ _5385_/B _5715_/Y _5784_/S vssd1 vssd1 vccd1 vccd1 _5716_/X sky130_fd_sc_hd__mux2_1
XFILLER_0_134_139 vssd1 vssd1 vccd1 vccd1 sky130_fd_sc_hd__fill_1
X_6696_ _6802_/CLK _6696_/D vssd1 vssd1 vccd1 vccd1 hold80/A sky130_fd_sc_hd__dfxtp_1
XFILLER_0_72_251 vssd1 vssd1 vccd1 vccd1 sky130_fd_sc_hd__fill_1
XFILLER_0_17_167 vssd1 vssd1 vccd1 vccd1 sky130_fd_sc_hd__fill_1
X_5647_ _5647_/A _5647_/B _6507_/Q vssd1 vssd1 vccd1 vccd1 _5649_/C sky130_fd_sc_hd__or3b_1
XFILLER_0_32_115 vssd1 vssd1 vccd1 vccd1 sky130_fd_sc_hd__fill_2
X_5578_ _5401_/B tex_mport_o[45] _5598_/S vssd1 vssd1 vccd1 vccd1 _6602_/D sky130_fd_sc_hd__mux2_1
Xhold241 _6783_/Q vssd1 vssd1 vccd1 vccd1 hold241/X sky130_fd_sc_hd__dlygate4sd3_1
X_4529_ _4520_/A _4519_/A _4519_/B vssd1 vssd1 vccd1 vccd1 _4532_/A sky130_fd_sc_hd__o21bai_1
XFILLER_0_40_170 vssd1 vssd1 vccd1 vccd1 sky130_fd_sc_hd__decap_3
XFILLER_0_40_181 vssd1 vssd1 vccd1 vccd1 sky130_fd_sc_hd__fill_2
Xhold230 _6747_/Q vssd1 vssd1 vccd1 vccd1 hold230/X sky130_fd_sc_hd__dlygate4sd3_1
Xhold252 _6741_/Q vssd1 vssd1 vccd1 vccd1 hold252/X sky130_fd_sc_hd__dlygate4sd3_1
XFILLER_0_130_389 vssd1 vssd1 vccd1 vccd1 sky130_ef_sc_hd__decap_12
Xhold285 _6629_/Q vssd1 vssd1 vccd1 vccd1 hold285/X sky130_fd_sc_hd__dlygate4sd3_1
Xhold296 _6624_/Q vssd1 vssd1 vccd1 vccd1 hold296/X sky130_fd_sc_hd__dlygate4sd3_1
Xhold274 _6636_/Q vssd1 vssd1 vccd1 vccd1 hold274/X sky130_fd_sc_hd__dlygate4sd3_1
Xhold263 _6107_/X vssd1 vssd1 vccd1 vccd1 _6745_/D sky130_fd_sc_hd__dlygate4sd3_1
XANTENNA_fanout67_A _4971_/D vssd1 vssd1 vccd1 vccd1 sky130_fd_sc_hd__diode_2
XTAP_590 vssd1 vccd1 sky130_fd_sc_hd__tapvpwrvgnd_1
XANTENNA__3871__A3 _5296_/A vssd1 vssd1 vccd1 vccd1 sky130_fd_sc_hd__diode_2
XANTENNA_114 sstream_i[9] vssd1 vssd1 vccd1 vccd1 sky130_fd_sc_hd__diode_2
XANTENNA_103 sstream_i[5] vssd1 vssd1 vccd1 vccd1 sky130_fd_sc_hd__diode_2
XANTENNA_125 tex_addr_i[12] vssd1 vssd1 vccd1 vccd1 sky130_fd_sc_hd__diode_2
XANTENNA__3828__A1_N _5093_/A vssd1 vssd1 vccd1 vccd1 sky130_fd_sc_hd__diode_2
XANTENNA_136 tex_addr_i[5] vssd1 vssd1 vccd1 vccd1 sky130_fd_sc_hd__diode_2
XANTENNA_158 tex_width_i[13] vssd1 vssd1 vccd1 vccd1 sky130_fd_sc_hd__diode_2
XANTENNA_147 tex_width_i[1] vssd1 vssd1 vccd1 vccd1 sky130_fd_sc_hd__diode_2
XFILLER_0_95_376 vssd1 vssd1 vccd1 vccd1 sky130_ef_sc_hd__decap_12
XANTENNA__4033__B1 _4841_/D vssd1 vssd1 vccd1 vccd1 sky130_fd_sc_hd__diode_2
XFILLER_0_102_18 vssd1 vssd1 vccd1 vccd1 sky130_fd_sc_hd__fill_2
XFILLER_0_63_251 vssd1 vssd1 vccd1 vccd1 sky130_fd_sc_hd__decap_4
XFILLER_0_11_27 vssd1 vssd1 vccd1 vccd1 sky130_ef_sc_hd__decap_12
XFILLER_0_121_301 vssd1 vssd1 vccd1 vccd1 sky130_fd_sc_hd__fill_2
XFILLER_0_23_126 vssd1 vssd1 vccd1 vccd1 sky130_fd_sc_hd__fill_2
XFILLER_0_133_183 vssd1 vssd1 vccd1 vccd1 sky130_fd_sc_hd__fill_1
XFILLER_0_121_334 vssd1 vssd1 vccd1 vccd1 sky130_fd_sc_hd__fill_2
XANTENNA__4639__A2 _4658_/D vssd1 vssd1 vccd1 vccd1 sky130_fd_sc_hd__diode_2
XFILLER_0_36_24 vssd1 vssd1 vccd1 vccd1 sky130_fd_sc_hd__fill_2
XFILLER_0_86_321 vssd1 vssd1 vccd1 vccd1 sky130_fd_sc_hd__fill_1
XANTENNA__4272__B1 _4736_/D vssd1 vssd1 vccd1 vccd1 sky130_fd_sc_hd__diode_2
XANTENNA__4811__A2 _4966_/A vssd1 vssd1 vccd1 vccd1 sky130_fd_sc_hd__diode_2
XFILLER_0_52_23 vssd1 vssd1 vccd1 vccd1 sky130_fd_sc_hd__fill_2
XFILLER_0_86_365 vssd1 vssd1 vccd1 vccd1 sky130_ef_sc_hd__decap_12
XFILLER_0_86_354 vssd1 vssd1 vccd1 vccd1 sky130_fd_sc_hd__fill_2
X_3900_ _3900_/A _4006_/A vssd1 vssd1 vccd1 vccd1 _3929_/A sky130_fd_sc_hd__nand2_1
X_4880_ _4880_/A _4880_/B _4880_/C vssd1 vssd1 vccd1 vccd1 _4880_/Y sky130_fd_sc_hd__nand3_2
X_3831_ _3831_/A _3831_/B vssd1 vssd1 vccd1 vccd1 _3875_/B sky130_fd_sc_hd__xor2_1
X_6550_ _6864_/CLK _6550_/D vssd1 vssd1 vccd1 vccd1 _6550_/Q sky130_fd_sc_hd__dfxtp_1
X_3762_ _3999_/A _5276_/B _3747_/X _3750_/B vssd1 vssd1 vccd1 vccd1 _3763_/B sky130_fd_sc_hd__a211o_1
XFILLER_0_116_139 vssd1 vssd1 vccd1 vccd1 sky130_fd_sc_hd__fill_1
X_5501_ hold15/X sstream_i[92] _5502_/S vssd1 vssd1 vccd1 vccd1 _6534_/D sky130_fd_sc_hd__mux2_1
XFILLER_0_6_359 vssd1 vssd1 vccd1 vccd1 sky130_fd_sc_hd__fill_2
XANTENNA__3509__B _5272_/B vssd1 vssd1 vccd1 vccd1 sky130_fd_sc_hd__diode_2
XFILLER_0_14_137 vssd1 vssd1 vccd1 vccd1 sky130_fd_sc_hd__decap_3
X_3693_ _3693_/A _3693_/B vssd1 vssd1 vccd1 vccd1 _3694_/C sky130_fd_sc_hd__xor2_1
X_6481_ hold164/X sstream_i[39] _6493_/S vssd1 vssd1 vccd1 vccd1 _6872_/D sky130_fd_sc_hd__mux2_1
XANTENNA__4327__A1 _5701_/A vssd1 vssd1 vccd1 vccd1 sky130_fd_sc_hd__diode_2
XFILLER_0_72_7 vssd1 vssd1 vccd1 vccd1 sky130_fd_sc_hd__fill_2
X_5432_ _5433_/A _5594_/B _5433_/B vssd1 vssd1 vccd1 vccd1 _5436_/B sky130_fd_sc_hd__o21ai_1
X_5363_ _5363_/A _5363_/B vssd1 vssd1 vccd1 vccd1 _5388_/B sky130_fd_sc_hd__xor2_2
X_4314_ _4958_/B _4814_/D _4688_/C _4658_/D vssd1 vssd1 vccd1 vccd1 _4314_/X sky130_fd_sc_hd__and4_1
XANTENNA__3550__A2 _5300_/A vssd1 vssd1 vccd1 vccd1 sky130_fd_sc_hd__diode_2
XFILLER_0_77_86 vssd1 vssd1 vccd1 vccd1 sky130_fd_sc_hd__decap_3
XFILLER_0_10_376 vssd1 vssd1 vccd1 vccd1 sky130_ef_sc_hd__decap_12
X_5294_ _5294_/A _5294_/B vssd1 vssd1 vccd1 vccd1 _5295_/B sky130_fd_sc_hd__xnor2_2
X_4245_ _4250_/A _4250_/B vssd1 vssd1 vccd1 vccd1 _4245_/Y sky130_fd_sc_hd__nor2_1
X_4176_ _4433_/D _4816_/B _4731_/A _4176_/D vssd1 vssd1 vccd1 vccd1 _4731_/B sky130_fd_sc_hd__nand4_2
XTAP_1019 vssd1 vccd1 sky130_fd_sc_hd__tapvpwrvgnd_1
XTAP_1008 vssd1 vccd1 sky130_fd_sc_hd__tapvpwrvgnd_1
XFILLER_0_26_90 vssd1 vssd1 vccd1 vccd1 sky130_fd_sc_hd__fill_2
X_6817_ _6827_/CLK _6817_/D fanout153/X vssd1 vssd1 vccd1 vccd1 depth_mport_o[39]
+ sky130_fd_sc_hd__dfrtp_4
XFILLER_0_9_131 vssd1 vssd1 vccd1 vccd1 sky130_fd_sc_hd__fill_1
XFILLER_0_37_218 vssd1 vssd1 vccd1 vccd1 sky130_fd_sc_hd__decap_6
XFILLER_0_37_229 vssd1 vssd1 vccd1 vccd1 sky130_ef_sc_hd__decap_12
XANTENNA__3369__A2 _5286_/B vssd1 vssd1 vccd1 vccd1 sky130_fd_sc_hd__diode_2
XANTENNA__5763__B1 _5762_/Y vssd1 vssd1 vccd1 vccd1 sky130_fd_sc_hd__diode_2
XFILLER_0_9_197 vssd1 vssd1 vccd1 vccd1 sky130_fd_sc_hd__fill_1
X_6748_ _6751_/CLK _6748_/D fanout139/X vssd1 vssd1 vccd1 vccd1 _6748_/Q sky130_fd_sc_hd__dfstp_1
X_6679_ _6683_/CLK _6679_/D vssd1 vssd1 vccd1 vccd1 _6679_/Q sky130_fd_sc_hd__dfxtp_1
XFILLER_0_60_210 vssd1 vssd1 vccd1 vccd1 sky130_fd_sc_hd__decap_4
XFILLER_0_103_312 vssd1 vssd1 vccd1 vccd1 sky130_fd_sc_hd__fill_1
XANTENNA__4318__A1 _4816_/B vssd1 vssd1 vccd1 vccd1 sky130_fd_sc_hd__diode_2
XFILLER_0_5_370 vssd1 vssd1 vccd1 vccd1 sky130_fd_sc_hd__fill_2
XFILLER_0_130_120 vssd1 vssd1 vccd1 vccd1 sky130_fd_sc_hd__fill_2
XANTENNA__4266__A _5701_/A vssd1 vssd1 vccd1 vccd1 sky130_fd_sc_hd__diode_2
XFILLER_0_138_231 vssd1 vssd1 vccd1 vccd1 sky130_fd_sc_hd__fill_1
XFILLER_0_113_28 vssd1 vssd1 vccd1 vccd1 sky130_fd_sc_hd__decap_4
XFILLER_0_22_15 vssd1 vssd1 vccd1 vccd1 sky130_ef_sc_hd__decap_12
XFILLER_0_28_218 vssd1 vssd1 vccd1 vccd1 sky130_fd_sc_hd__decap_6
XPHY_60 vssd1 vssd1 vccd1 vccd1 sky130_fd_sc_hd__decap_3
XPHY_71 vssd1 vssd1 vccd1 vccd1 sky130_fd_sc_hd__decap_3
XPHY_82 vssd1 vssd1 vccd1 vccd1 sky130_fd_sc_hd__decap_3
XFILLER_0_138_253 vssd1 vssd1 vccd1 vccd1 sky130_fd_sc_hd__decap_3
XANTENNA__6625__SET_B fanout145/X vssd1 vssd1 vccd1 vccd1 sky130_fd_sc_hd__diode_2
XFILLER_0_83_335 vssd1 vssd1 vccd1 vccd1 sky130_fd_sc_hd__fill_1
XPHY_93 vssd1 vssd1 vccd1 vccd1 sky130_fd_sc_hd__decap_3
XFILLER_0_106_150 vssd1 vssd1 vccd1 vccd1 sky130_fd_sc_hd__fill_2
XFILLER_0_51_232 vssd1 vssd1 vccd1 vccd1 sky130_fd_sc_hd__fill_1
XANTENNA__4151__D _5049_/D vssd1 vssd1 vccd1 vccd1 sky130_fd_sc_hd__diode_2
XFILLER_0_138_25 vssd1 vssd1 vccd1 vccd1 sky130_fd_sc_hd__decap_3
X_4030_ _4253_/A _4102_/B _4030_/C vssd1 vssd1 vccd1 vccd1 _4037_/A sky130_fd_sc_hd__nand3_1
XANTENNA__3999__B _6682_/Q vssd1 vssd1 vccd1 vccd1 sky130_fd_sc_hd__diode_2
XANTENNA__4176__A _4433_/D vssd1 vssd1 vccd1 vccd1 sky130_fd_sc_hd__diode_2
X_5981_ tex_height_i[3] _5982_/B vssd1 vssd1 vccd1 vccd1 _5983_/A sky130_fd_sc_hd__nand2_1
XFILLER_0_59_310 vssd1 vssd1 vccd1 vccd1 sky130_fd_sc_hd__fill_1
XFILLER_0_59_332 vssd1 vssd1 vccd1 vccd1 sky130_fd_sc_hd__fill_2
XANTENNA__3599__A2 _5787_/B vssd1 vssd1 vccd1 vccd1 sky130_fd_sc_hd__diode_2
XANTENNA__5993__A0 _4971_/D vssd1 vssd1 vccd1 vccd1 sky130_fd_sc_hd__diode_2
X_4932_ _4932_/A _4932_/B vssd1 vssd1 vccd1 vccd1 _4933_/B sky130_fd_sc_hd__or2_1
XFILLER_0_19_207 vssd1 vssd1 vccd1 vccd1 sky130_fd_sc_hd__decap_8
XANTENNA_14 sstream_i[11] vssd1 vssd1 vccd1 vccd1 sky130_fd_sc_hd__diode_2
X_6602_ _6734_/CLK _6602_/D fanout144/X vssd1 vssd1 vccd1 vccd1 tex_mport_o[45] sky130_fd_sc_hd__dfrtp_4
X_4863_ _4862_/B _4862_/C _4862_/A vssd1 vssd1 vccd1 vccd1 _4865_/B sky130_fd_sc_hd__a21bo_1
XANTENNA_36 sstream_i[14] vssd1 vssd1 vccd1 vccd1 sky130_fd_sc_hd__diode_2
XANTENNA_47 sstream_i[16] vssd1 vssd1 vccd1 vccd1 sky130_fd_sc_hd__diode_2
XANTENNA_25 sstream_i[12] vssd1 vssd1 vccd1 vccd1 sky130_fd_sc_hd__diode_2
X_3814_ _3835_/B _3814_/B vssd1 vssd1 vccd1 vccd1 _3815_/C sky130_fd_sc_hd__or2_1
X_4794_ _4942_/A _4794_/B _4942_/B _5083_/A vssd1 vssd1 vccd1 vccd1 _4796_/B sky130_fd_sc_hd__nand4_1
XANTENNA_69 sstream_i[23] vssd1 vssd1 vccd1 vccd1 sky130_fd_sc_hd__diode_2
XANTENNA_58 sstream_i[19] vssd1 vssd1 vccd1 vccd1 sky130_fd_sc_hd__diode_2
XFILLER_0_103_72 vssd1 vssd1 vccd1 vccd1 sky130_fd_sc_hd__fill_1
X_6533_ _6841_/CLK _6533_/D vssd1 vssd1 vccd1 vccd1 hold72/A sky130_fd_sc_hd__dfxtp_1
X_3745_ _5327_/A _6686_/Q _6687_/Q _5290_/A vssd1 vssd1 vccd1 vccd1 _3749_/D sky130_fd_sc_hd__a22o_1
XFILLER_0_27_295 vssd1 vssd1 vccd1 vccd1 sky130_fd_sc_hd__decap_6
XFILLER_0_42_221 vssd1 vssd1 vccd1 vccd1 sky130_fd_sc_hd__fill_1
XANTENNA__6330__S _6440_/B vssd1 vssd1 vccd1 vccd1 sky130_fd_sc_hd__diode_2
X_6464_ hold184/X sstream_i[22] _6464_/S vssd1 vssd1 vccd1 vccd1 _6855_/D sky130_fd_sc_hd__mux2_1
XFILLER_0_6_178 vssd1 vssd1 vccd1 vccd1 sky130_fd_sc_hd__fill_2
XFILLER_0_112_131 vssd1 vssd1 vccd1 vccd1 sky130_fd_sc_hd__fill_2
XFILLER_0_112_120 vssd1 vssd1 vccd1 vccd1 sky130_fd_sc_hd__fill_2
XANTENNA_fanout117_A _5801_/A vssd1 vssd1 vccd1 vccd1 sky130_fd_sc_hd__diode_2
X_3676_ _3664_/X _3672_/Y _3687_/A _3675_/X vssd1 vssd1 vccd1 vccd1 _3687_/B sky130_fd_sc_hd__o211ai_4
X_5415_ _5416_/B _5428_/B _5416_/A vssd1 vssd1 vccd1 vccd1 _5418_/B sky130_fd_sc_hd__a21o_1
X_6395_ _6378_/Y _6392_/B _6393_/A _6441_/B vssd1 vssd1 vccd1 vccd1 _6395_/Y sky130_fd_sc_hd__o31ai_1
XANTENNA__3255__A _4966_/A vssd1 vssd1 vccd1 vccd1 sky130_fd_sc_hd__diode_2
XFILLER_0_63_3 vssd1 vssd1 vccd1 vccd1 sky130_fd_sc_hd__decap_4
XFILLER_0_2_373 vssd1 vssd1 vccd1 vccd1 sky130_fd_sc_hd__fill_2
XFILLER_0_100_326 vssd1 vssd1 vccd1 vccd1 sky130_fd_sc_hd__fill_1
X_5346_ _5416_/A _5428_/B _5241_/X _5238_/A vssd1 vssd1 vccd1 vccd1 _5349_/C sky130_fd_sc_hd__o211ai_2
XANTENNA__4720__A1 _4432_/A vssd1 vssd1 vccd1 vccd1 sky130_fd_sc_hd__diode_2
XFILLER_0_10_195 vssd1 vssd1 vccd1 vccd1 sky130_fd_sc_hd__fill_1
X_5277_ _5277_/A _5277_/B vssd1 vssd1 vccd1 vccd1 _5278_/B sky130_fd_sc_hd__nand2_1
X_4228_ _4217_/Y _4218_/X _4223_/Y _4226_/X vssd1 vssd1 vccd1 vccd1 _4230_/C sky130_fd_sc_hd__o211a_1
XFILLER_0_97_405 vssd1 vssd1 vccd1 vccd1 sky130_fd_sc_hd__fill_2
X_4159_ _4158_/B _4158_/C _4158_/A vssd1 vssd1 vccd1 vccd1 _4161_/B sky130_fd_sc_hd__a21o_1
XFILLER_0_69_129 vssd1 vssd1 vccd1 vccd1 sky130_fd_sc_hd__fill_2
XANTENNA__3421__C _5320_/A vssd1 vssd1 vccd1 vccd1 sky130_fd_sc_hd__diode_2
XANTENNA__4814__A _5115_/D vssd1 vssd1 vccd1 vccd1 sky130_fd_sc_hd__diode_2
XFILLER_0_92_132 vssd1 vssd1 vccd1 vccd1 sky130_fd_sc_hd__fill_2
XFILLER_0_65_357 vssd1 vssd1 vccd1 vccd1 sky130_fd_sc_hd__fill_2
XFILLER_0_135_212 vssd1 vssd1 vccd1 vccd1 sky130_fd_sc_hd__decap_8
XFILLER_0_18_295 vssd1 vssd1 vccd1 vccd1 sky130_fd_sc_hd__fill_1
XANTENNA__3762__A2 _5276_/B vssd1 vssd1 vccd1 vccd1 sky130_fd_sc_hd__diode_2
XFILLER_0_103_120 vssd1 vssd1 vccd1 vccd1 sky130_fd_sc_hd__fill_1
XFILLER_0_21_405 vssd1 vssd1 vccd1 vccd1 sky130_fd_sc_hd__fill_2
XFILLER_0_33_265 vssd1 vssd1 vccd1 vccd1 sky130_fd_sc_hd__fill_1
XANTENNA__4475__B1 _4476_/D vssd1 vssd1 vccd1 vccd1 sky130_fd_sc_hd__diode_2
XFILLER_0_17_15 vssd1 vssd1 vccd1 vccd1 sky130_fd_sc_hd__decap_6
XANTENNA__5975__A0 _4841_/C vssd1 vssd1 vccd1 vccd1 sky130_fd_sc_hd__diode_2
XFILLER_0_33_47 vssd1 vssd1 vccd1 vccd1 sky130_fd_sc_hd__fill_2
XANTENNA_clkbuf_2_3__f_clk_i_A clkbuf_0_clk_i/X vssd1 vssd1 vccd1 vccd1 sky130_fd_sc_hd__diode_2
XFILLER_0_126_267 vssd1 vssd1 vccd1 vccd1 sky130_fd_sc_hd__fill_2
X_3530_ _3959_/B _5308_/B _5277_/B _3961_/A vssd1 vssd1 vccd1 vccd1 _3531_/B sky130_fd_sc_hd__a22o_1
XFILLER_0_12_405 vssd1 vssd1 vccd1 vccd1 sky130_fd_sc_hd__fill_2
XFILLER_0_3_137 vssd1 vssd1 vccd1 vccd1 sky130_fd_sc_hd__fill_2
X_3461_ _5286_/A _5300_/B _3461_/C _3461_/D vssd1 vssd1 vccd1 vccd1 _3554_/A sky130_fd_sc_hd__and4_1
X_6180_ _6168_/B _6170_/B _6168_/A vssd1 vssd1 vccd1 vccd1 _6182_/B sky130_fd_sc_hd__o21ba_1
X_3392_ _3673_/A _3673_/B _3384_/X vssd1 vssd1 vccd1 vccd1 _3611_/A sky130_fd_sc_hd__o21ai_1
X_5200_ _5192_/A _5193_/Y _5201_/A _5199_/X vssd1 vssd1 vccd1 vccd1 _5201_/B sky130_fd_sc_hd__a211oi_2
XANTENNA__6386__A hold53/A vssd1 vssd1 vccd1 vccd1 sky130_fd_sc_hd__diode_2
X_5131_ _5205_/B _5131_/B vssd1 vssd1 vccd1 vccd1 _5131_/X sky130_fd_sc_hd__and2_1
XANTENNA__5290__A _5290_/A vssd1 vssd1 vccd1 vccd1 sky130_fd_sc_hd__diode_2
X_5062_ _5061_/B _5061_/C _5061_/A vssd1 vssd1 vccd1 vccd1 _5076_/A sky130_fd_sc_hd__a21bo_1
X_4013_ _4013_/A _4013_/B _4013_/C vssd1 vssd1 vccd1 vccd1 _4013_/X sky130_fd_sc_hd__or3_1
XFILLER_0_79_405 vssd1 vssd1 vccd1 vccd1 sky130_fd_sc_hd__fill_2
X_5964_ _5964_/A _5964_/B _5964_/C _5964_/D vssd1 vssd1 vccd1 vccd1 _5964_/X sky130_fd_sc_hd__or4_2
XFILLER_0_59_151 vssd1 vssd1 vccd1 vccd1 sky130_fd_sc_hd__fill_1
XFILLER_0_59_162 vssd1 vssd1 vccd1 vccd1 sky130_fd_sc_hd__fill_1
XFILLER_0_114_60 vssd1 vssd1 vccd1 vccd1 sky130_fd_sc_hd__fill_2
X_5895_ tex_addr_i[28] _5913_/B vssd1 vssd1 vccd1 vccd1 _5897_/A sky130_fd_sc_hd__or2_1
X_4915_ _4915_/A _4915_/B vssd1 vssd1 vccd1 vccd1 _4917_/B sky130_fd_sc_hd__xor2_1
XFILLER_0_117_223 vssd1 vssd1 vccd1 vccd1 sky130_fd_sc_hd__fill_1
X_4846_ _4835_/A _4835_/C _4835_/B vssd1 vssd1 vccd1 vccd1 _4847_/C sky130_fd_sc_hd__a21o_1
XFILLER_0_117_289 vssd1 vssd1 vccd1 vccd1 sky130_fd_sc_hd__fill_2
XANTENNA__6060__S _6072_/S vssd1 vssd1 vccd1 vccd1 sky130_fd_sc_hd__diode_2
X_6516_ _6834_/CLK _6516_/D vssd1 vssd1 vccd1 vccd1 _6516_/Q sky130_fd_sc_hd__dfxtp_1
XFILLER_0_15_254 vssd1 vssd1 vccd1 vccd1 sky130_fd_sc_hd__decap_3
X_4777_ _4776_/A _4816_/B _4808_/A _4776_/D vssd1 vssd1 vccd1 vccd1 _4777_/X sky130_fd_sc_hd__a22o_1
XFILLER_0_130_70 vssd1 vssd1 vccd1 vccd1 sky130_fd_sc_hd__decap_4
XFILLER_0_70_360 vssd1 vssd1 vccd1 vccd1 sky130_fd_sc_hd__fill_2
X_3728_ _5320_/A _5300_/B _3645_/C _3645_/D vssd1 vssd1 vccd1 vccd1 _3729_/C sky130_fd_sc_hd__a22o_1
X_6447_ hold124/X sstream_i[5] _6473_/S vssd1 vssd1 vccd1 vccd1 _6838_/D sky130_fd_sc_hd__mux2_1
X_3659_ _5049_/A _5049_/B _5273_/B _5272_/B vssd1 vssd1 vccd1 vccd1 _3659_/X sky130_fd_sc_hd__and4_1
X_6378_ _6378_/A _6392_/A vssd1 vssd1 vccd1 vccd1 _6378_/Y sky130_fd_sc_hd__nand2_1
X_5329_ _5329_/A _5329_/B vssd1 vssd1 vccd1 vccd1 _5330_/B sky130_fd_sc_hd__xnor2_1
XANTENNA__4809__A _4971_/D vssd1 vssd1 vccd1 vccd1 sky130_fd_sc_hd__diode_2
XANTENNA_hold181_A _6550_/Q vssd1 vssd1 vccd1 vccd1 sky130_fd_sc_hd__diode_2
XFILLER_0_97_257 vssd1 vssd1 vccd1 vccd1 sky130_fd_sc_hd__decap_6
XFILLER_0_65_110 vssd1 vssd1 vccd1 vccd1 sky130_fd_sc_hd__fill_2
XFILLER_0_53_327 vssd1 vssd1 vccd1 vccd1 sky130_fd_sc_hd__decap_3
XFILLER_0_108_289 vssd1 vssd1 vccd1 vccd1 sky130_fd_sc_hd__fill_1
XFILLER_0_110_29 vssd1 vssd1 vccd1 vccd1 sky130_fd_sc_hd__fill_1
XFILLER_0_80_179 vssd1 vssd1 vccd1 vccd1 sky130_fd_sc_hd__fill_2
XFILLER_0_21_213 vssd1 vssd1 vccd1 vccd1 sky130_fd_sc_hd__fill_1
XFILLER_0_61_393 vssd1 vssd1 vccd1 vccd1 sky130_ef_sc_hd__decap_12
XFILLER_0_0_129 vssd1 vssd1 vccd1 vccd1 sky130_fd_sc_hd__fill_1
XFILLER_0_21_268 vssd1 vssd1 vccd1 vccd1 sky130_fd_sc_hd__fill_1
XTAP_408 vssd1 vccd1 sky130_fd_sc_hd__tapvpwrvgnd_1
XTAP_419 vssd1 vccd1 sky130_fd_sc_hd__tapvpwrvgnd_1
XFILLER_0_28_58 vssd1 vssd1 vccd1 vccd1 sky130_fd_sc_hd__fill_2
XFILLER_0_88_213 vssd1 vssd1 vccd1 vccd1 sky130_fd_sc_hd__fill_1
XANTENNA__5984__S _6038_/C vssd1 vssd1 vccd1 vccd1 sky130_fd_sc_hd__diode_2
XTAP_1191 vssd1 vccd1 sky130_fd_sc_hd__tapvpwrvgnd_1
XTAP_1180 vssd1 vccd1 sky130_fd_sc_hd__tapvpwrvgnd_1
X_4700_ _4575_/Y _4580_/A _4545_/B _4548_/X vssd1 vssd1 vccd1 vccd1 _4701_/B sky130_fd_sc_hd__a211o_1
X_5680_ tex_addr_i[4] _5680_/B vssd1 vssd1 vccd1 vccd1 _5681_/B sky130_fd_sc_hd__nor2_1
XFILLER_0_56_154 vssd1 vssd1 vccd1 vccd1 sky130_fd_sc_hd__fill_2
X_4631_ _4631_/A _4631_/B _4631_/C vssd1 vssd1 vccd1 vccd1 _4697_/A sky130_fd_sc_hd__and3_1
XFILLER_0_71_113 vssd1 vssd1 vccd1 vccd1 sky130_fd_sc_hd__fill_2
XFILLER_0_71_157 vssd1 vssd1 vccd1 vccd1 sky130_fd_sc_hd__decap_4
XFILLER_0_4_402 vssd1 vssd1 vccd1 vccd1 sky130_fd_sc_hd__decap_4
XANTENNA__6744__SET_B fanout140/X vssd1 vssd1 vccd1 vccd1 sky130_fd_sc_hd__diode_2
X_4562_ _5687_/A _6662_/Q _4841_/C _5687_/B vssd1 vssd1 vccd1 vccd1 _4563_/B sky130_fd_sc_hd__a22oi_1
XFILLER_0_12_202 vssd1 vssd1 vccd1 vccd1 sky130_fd_sc_hd__fill_2
XFILLER_0_52_360 vssd1 vssd1 vccd1 vccd1 sky130_fd_sc_hd__fill_2
X_6301_ _5556_/S _6300_/B _6300_/Y hold228/X vssd1 vssd1 vccd1 vccd1 _6784_/D sky130_fd_sc_hd__a22o_1
X_4493_ _4494_/A _4494_/B vssd1 vssd1 vccd1 vccd1 _4493_/X sky130_fd_sc_hd__or2_1
X_3513_ _3514_/A _3513_/B _3513_/C vssd1 vssd1 vccd1 vccd1 _5275_/S sky130_fd_sc_hd__or3_1
X_6232_ _6807_/Q _6231_/X _3264_/Y sstream_o vssd1 vssd1 vccd1 vccd1 _6232_/X sky130_fd_sc_hd__a2bb2o_1
XFILLER_0_122_270 vssd1 vssd1 vccd1 vccd1 sky130_fd_sc_hd__fill_1
X_3444_ _3444_/A _3444_/B vssd1 vssd1 vccd1 vccd1 _3445_/B sky130_fd_sc_hd__nand2_1
X_6163_ _6163_/A _6163_/B vssd1 vssd1 vccd1 vccd1 _6184_/A sky130_fd_sc_hd__or2_1
XTAP_953 vssd1 vccd1 sky130_fd_sc_hd__tapvpwrvgnd_1
XTAP_942 vssd1 vccd1 sky130_fd_sc_hd__tapvpwrvgnd_1
XTAP_931 vssd1 vccd1 sky130_fd_sc_hd__tapvpwrvgnd_1
XTAP_920 vssd1 vccd1 sky130_fd_sc_hd__tapvpwrvgnd_1
X_3375_ _3375_/A _3375_/B vssd1 vssd1 vccd1 vccd1 _3393_/C sky130_fd_sc_hd__xor2_1
XTAP_986 vssd1 vccd1 sky130_fd_sc_hd__tapvpwrvgnd_1
XTAP_975 vssd1 vccd1 sky130_fd_sc_hd__tapvpwrvgnd_1
XTAP_964 vssd1 vccd1 sky130_fd_sc_hd__tapvpwrvgnd_1
X_6094_ hold196/X _6732_/Q _6095_/S vssd1 vssd1 vccd1 vccd1 _6094_/X sky130_fd_sc_hd__mux2_1
XFILLER_0_85_64 vssd1 vssd1 vccd1 vccd1 sky130_fd_sc_hd__fill_2
XANTENNA__4348__B _4433_/D vssd1 vssd1 vccd1 vccd1 sky130_fd_sc_hd__diode_2
X_5114_ _5114_/A _5114_/B vssd1 vssd1 vccd1 vccd1 _5164_/A sky130_fd_sc_hd__xor2_2
XTAP_997 vssd1 vccd1 sky130_fd_sc_hd__tapvpwrvgnd_1
XFILLER_0_18_80 vssd1 vssd1 vccd1 vccd1 sky130_fd_sc_hd__fill_2
X_5045_ _5091_/B _5106_/B _6682_/Q _5091_/A vssd1 vssd1 vccd1 vccd1 _5045_/X sky130_fd_sc_hd__a22o_1
XANTENNA__4067__C _4736_/B vssd1 vssd1 vccd1 vccd1 sky130_fd_sc_hd__diode_2
XFILLER_0_26_3 vssd1 vssd1 vccd1 vccd1 sky130_ef_sc_hd__decap_12
XANTENNA__6055__S _6072_/S vssd1 vssd1 vccd1 vccd1 sky130_fd_sc_hd__diode_2
X_5947_ _5947_/A tex_height_i[13] vssd1 vssd1 vccd1 vccd1 _5963_/B sky130_fd_sc_hd__nor2_1
XANTENNA__5894__S _5923_/S vssd1 vssd1 vccd1 vccd1 sky130_fd_sc_hd__diode_2
XANTENNA__4514__D _4841_/C vssd1 vssd1 vccd1 vccd1 sky130_fd_sc_hd__diode_2
XANTENNA__3965__A2 _5083_/B vssd1 vssd1 vccd1 vccd1 sky130_fd_sc_hd__diode_2
XFILLER_0_47_143 vssd1 vssd1 vccd1 vccd1 sky130_fd_sc_hd__decap_3
XFILLER_0_47_165 vssd1 vssd1 vccd1 vccd1 sky130_fd_sc_hd__decap_3
XFILLER_0_7_240 vssd1 vssd1 vccd1 vccd1 sky130_fd_sc_hd__fill_2
X_5878_ _5878_/A _5878_/B vssd1 vssd1 vccd1 vccd1 _5878_/Y sky130_fd_sc_hd__xnor2_1
XFILLER_0_7_251 vssd1 vssd1 vccd1 vccd1 sky130_fd_sc_hd__fill_2
XANTENNA__3708__A _5801_/A vssd1 vssd1 vccd1 vccd1 sky130_fd_sc_hd__diode_2
X_4829_ _4842_/A tex_width_i[15] _4971_/B _5787_/A vssd1 vssd1 vccd1 vccd1 _4830_/C
+ sky130_fd_sc_hd__a22o_1
XFILLER_0_120_207 vssd1 vssd1 vccd1 vccd1 sky130_fd_sc_hd__fill_2
XFILLER_0_43_393 vssd1 vssd1 vccd1 vccd1 sky130_ef_sc_hd__decap_12
XANTENNA__5642__A2 _5559_/B vssd1 vssd1 vccd1 vccd1 sky130_fd_sc_hd__diode_2
XFILLER_0_14_27 vssd1 vssd1 vccd1 vccd1 sky130_fd_sc_hd__fill_1
XANTENNA__3405__A1 _3999_/A vssd1 vssd1 vccd1 vccd1 sky130_fd_sc_hd__diode_2
XPHY_252 vssd1 vssd1 vccd1 vccd1 sky130_fd_sc_hd__decap_3
XPHY_241 vssd1 vssd1 vccd1 vccd1 sky130_fd_sc_hd__decap_3
XPHY_230 vssd1 vssd1 vccd1 vccd1 sky130_fd_sc_hd__decap_3
XPHY_274 vssd1 vssd1 vccd1 vccd1 sky130_fd_sc_hd__decap_3
XPHY_263 vssd1 vssd1 vccd1 vccd1 sky130_fd_sc_hd__decap_3
XFILLER_0_93_271 vssd1 vssd1 vccd1 vccd1 sky130_fd_sc_hd__decap_3
XFILLER_0_93_260 vssd1 vssd1 vccd1 vccd1 sky130_fd_sc_hd__decap_4
XFILLER_0_38_187 vssd1 vssd1 vccd1 vccd1 sky130_fd_sc_hd__fill_2
XFILLER_0_53_102 vssd1 vssd1 vccd1 vccd1 sky130_fd_sc_hd__fill_1
XFILLER_0_19_390 vssd1 vssd1 vccd1 vccd1 sky130_fd_sc_hd__fill_2
XANTENNA__4721__B _5666_/A vssd1 vssd1 vccd1 vccd1 sky130_fd_sc_hd__diode_2
XFILLER_0_53_179 vssd1 vssd1 vccd1 vccd1 sky130_fd_sc_hd__fill_2
XFILLER_0_1_405 vssd1 vssd1 vccd1 vccd1 sky130_fd_sc_hd__fill_2
XFILLER_0_104_281 vssd1 vssd1 vccd1 vccd1 sky130_fd_sc_hd__fill_2
XFILLER_0_39_57 vssd1 vssd1 vccd1 vccd1 sky130_fd_sc_hd__fill_1
XANTENNA__3341__B1 _5273_/B vssd1 vssd1 vccd1 vccd1 sky130_fd_sc_hd__diode_2
Xhold1 hold1/A vssd1 vssd1 vccd1 vccd1 hold1/X sky130_fd_sc_hd__dlygate4sd3_1
XANTENNA__5979__S _6038_/C vssd1 vssd1 vccd1 vccd1 sky130_fd_sc_hd__diode_2
XFILLER_0_55_12 vssd1 vssd1 vccd1 vccd1 sky130_fd_sc_hd__fill_2
XANTENNA__3644__A1 _5051_/B vssd1 vssd1 vccd1 vccd1 sky130_fd_sc_hd__diode_2
XFILLER_0_55_89 vssd1 vssd1 vccd1 vccd1 sky130_fd_sc_hd__fill_1
X_6850_ _6862_/CLK _6850_/D vssd1 vssd1 vccd1 vccd1 _6850_/Q sky130_fd_sc_hd__dfxtp_1
XFILLER_0_76_205 vssd1 vssd1 vccd1 vccd1 sky130_fd_sc_hd__fill_2
X_6781_ _6812_/CLK _6781_/D fanout151/X vssd1 vssd1 vccd1 vccd1 depth_mport_o[64]
+ sky130_fd_sc_hd__dfrtp_4
XFILLER_0_29_121 vssd1 vssd1 vccd1 vccd1 sky130_fd_sc_hd__decap_3
X_5801_ _5801_/A _5802_/B _5802_/C vssd1 vssd1 vccd1 vccd1 _5882_/B sky130_fd_sc_hd__nor3_4
XFILLER_0_91_219 vssd1 vssd1 vccd1 vccd1 sky130_fd_sc_hd__fill_2
X_5732_ _5732_/A _5732_/B vssd1 vssd1 vccd1 vccd1 _5733_/B sky130_fd_sc_hd__nand2_1
XFILLER_0_29_143 vssd1 vssd1 vccd1 vccd1 sky130_fd_sc_hd__fill_1
X_3993_ _3981_/Y _3988_/X _4004_/A _3992_/X vssd1 vssd1 vccd1 vccd1 _4004_/B sky130_fd_sc_hd__o211ai_4
XFILLER_0_72_400 vssd1 vssd1 vccd1 vccd1 sky130_fd_sc_hd__decap_6
X_5663_ _5796_/A _5662_/Y _5563_/X vssd1 vssd1 vccd1 vccd1 _5663_/Y sky130_fd_sc_hd__o21bai_1
XFILLER_0_17_349 vssd1 vssd1 vccd1 vccd1 sky130_fd_sc_hd__fill_2
XFILLER_0_44_135 vssd1 vssd1 vccd1 vccd1 sky130_fd_sc_hd__fill_2
X_4614_ _5645_/A _5645_/B _4614_/C _4637_/D vssd1 vssd1 vccd1 vccd1 _4614_/X sky130_fd_sc_hd__and4_1
X_5594_ _5922_/S _5594_/B _5594_/C vssd1 vssd1 vccd1 vccd1 _5594_/Y sky130_fd_sc_hd__nor3_2
XFILLER_0_111_83 vssd1 vssd1 vccd1 vccd1 sky130_fd_sc_hd__fill_2
X_4545_ _4545_/A _4545_/B vssd1 vssd1 vccd1 vccd1 _4547_/B sky130_fd_sc_hd__nor2_2
XFILLER_0_25_393 vssd1 vssd1 vccd1 vccd1 sky130_ef_sc_hd__decap_12
XANTENNA__5743__A _5754_/B vssd1 vssd1 vccd1 vccd1 sky130_fd_sc_hd__diode_2
XFILLER_0_4_298 vssd1 vssd1 vccd1 vccd1 sky130_fd_sc_hd__fill_2
XFILLER_0_4_287 vssd1 vssd1 vccd1 vccd1 sky130_fd_sc_hd__fill_1
X_4476_ _4789_/B _4789_/C _4518_/D _4476_/D vssd1 vssd1 vccd1 vccd1 _4477_/B sky130_fd_sc_hd__and4_1
XFILLER_0_40_396 vssd1 vssd1 vccd1 vccd1 sky130_fd_sc_hd__decap_8
X_6215_ _6212_/B _6210_/X hold49/A vssd1 vssd1 vccd1 vccd1 _6215_/Y sky130_fd_sc_hd__o21ai_1
XFILLER_0_96_85 vssd1 vssd1 vccd1 vccd1 sky130_fd_sc_hd__decap_4
X_3427_ _3579_/A _3579_/B vssd1 vssd1 vccd1 vccd1 _3447_/B sky130_fd_sc_hd__and2_1
X_6146_ pix_mport_o[40] _6207_/B _6152_/B _6145_/Y vssd1 vssd1 vccd1 vccd1 _6768_/D
+ sky130_fd_sc_hd__a22o_1
XTAP_761 vssd1 vccd1 sky130_fd_sc_hd__tapvpwrvgnd_1
XTAP_750 vssd1 vccd1 sky130_fd_sc_hd__tapvpwrvgnd_1
X_3358_ _5299_/A _6688_/Q _3356_/Y _3397_/A vssd1 vssd1 vccd1 vccd1 _3360_/A sky130_fd_sc_hd__o2bb2a_1
XTAP_794 vssd1 vccd1 sky130_fd_sc_hd__tapvpwrvgnd_1
XTAP_783 vssd1 vccd1 sky130_fd_sc_hd__tapvpwrvgnd_1
XTAP_772 vssd1 vccd1 sky130_fd_sc_hd__tapvpwrvgnd_1
XANTENNA__3883__B2 _5091_/A vssd1 vssd1 vccd1 vccd1 sky130_fd_sc_hd__diode_2
XANTENNA__3883__A1 _5327_/A vssd1 vssd1 vccd1 vccd1 sky130_fd_sc_hd__diode_2
XANTENNA__5889__S _5923_/S vssd1 vssd1 vccd1 vccd1 sky130_fd_sc_hd__diode_2
X_6077_ hold64/X _6656_/Q _6315_/S vssd1 vssd1 vccd1 vccd1 hold65/A sky130_fd_sc_hd__mux2_1
X_3289_ tex_height_i[4] vssd1 vssd1 vccd1 vccd1 _3289_/Y sky130_fd_sc_hd__inv_2
X_5028_ _4230_/B _4229_/Y _5018_/Y _5027_/X vssd1 vssd1 vccd1 vccd1 _5028_/Y sky130_fd_sc_hd__o211ai_4
XANTENNA__3635__B2 _3961_/A vssd1 vssd1 vccd1 vccd1 sky130_fd_sc_hd__diode_2
XANTENNA__3710__B _5118_/B vssd1 vssd1 vccd1 vccd1 sky130_fd_sc_hd__diode_2
XFILLER_0_67_238 vssd1 vssd1 vccd1 vccd1 sky130_fd_sc_hd__fill_2
X_6979_ vssd1 vssd1 vccd1 vccd1 _6979_/HI tex_mport_o[65] sky130_fd_sc_hd__conb_1
XFILLER_0_118_340 vssd1 vssd1 vccd1 vccd1 sky130_fd_sc_hd__fill_2
XANTENNA__4822__A _5115_/C vssd1 vssd1 vccd1 vccd1 sky130_fd_sc_hd__diode_2
XANTENNA_fanout12_A _5468_/X vssd1 vssd1 vccd1 vccd1 sky130_fd_sc_hd__diode_2
XFILLER_0_90_241 vssd1 vssd1 vccd1 vccd1 sky130_fd_sc_hd__fill_2
XFILLER_0_90_230 vssd1 vssd1 vccd1 vccd1 sky130_fd_sc_hd__fill_2
Xclkbuf_leaf_6_clk_i clkbuf_leaf_9_clk_i/A vssd1 vssd1 vccd1 vccd1 _6864_/CLK sky130_fd_sc_hd__clkbuf_16
XFILLER_0_90_296 vssd1 vssd1 vccd1 vccd1 sky130_fd_sc_hd__fill_1
XFILLER_0_16_371 vssd1 vssd1 vccd1 vccd1 sky130_fd_sc_hd__fill_1
XFILLER_0_50_127 vssd1 vssd1 vccd1 vccd1 sky130_fd_sc_hd__fill_2
XANTENNA__5091__C _6682_/Q vssd1 vssd1 vccd1 vccd1 sky130_fd_sc_hd__diode_2
XFILLER_0_25_15 vssd1 vssd1 vccd1 vccd1 sky130_ef_sc_hd__decap_12
XANTENNA__4823__B1 _4966_/B vssd1 vssd1 vccd1 vccd1 sky130_fd_sc_hd__diode_2
XANTENNA__4716__B _5051_/B vssd1 vssd1 vccd1 vccd1 sky130_fd_sc_hd__diode_2
XFILLER_0_98_385 vssd1 vssd1 vccd1 vccd1 sky130_ef_sc_hd__decap_12
XANTENNA__6040__A2 _6038_/B vssd1 vssd1 vccd1 vccd1 sky130_fd_sc_hd__diode_2
XANTENNA__4051__A1 _5701_/A vssd1 vssd1 vccd1 vccd1 sky130_fd_sc_hd__diode_2
XANTENNA__4051__B2 _5687_/A vssd1 vssd1 vccd1 vccd1 sky130_fd_sc_hd__diode_2
XFILLER_0_81_230 vssd1 vssd1 vccd1 vccd1 sky130_fd_sc_hd__decap_3
XFILLER_0_124_332 vssd1 vssd1 vccd1 vccd1 sky130_fd_sc_hd__fill_1
XANTENNA__5563__A _5796_/A vssd1 vssd1 vccd1 vccd1 sky130_fd_sc_hd__diode_2
X_4330_ _4330_/A _4330_/B _4330_/C vssd1 vssd1 vccd1 vccd1 _4338_/A sky130_fd_sc_hd__nand3_1
XFILLER_0_1_235 vssd1 vssd1 vccd1 vccd1 sky130_fd_sc_hd__fill_1
X_4261_ _4261_/A _4261_/B vssd1 vssd1 vccd1 vccd1 _4322_/B sky130_fd_sc_hd__xor2_1
XANTENNA__4106__A2 _4736_/D vssd1 vssd1 vccd1 vccd1 sky130_fd_sc_hd__diode_2
XFILLER_0_5_69 vssd1 vssd1 vccd1 vccd1 sky130_ef_sc_hd__decap_12
X_6000_ _5999_/Y hold164/X _6000_/S vssd1 vssd1 vccd1 vccd1 _6000_/X sky130_fd_sc_hd__mux2_1
X_4192_ _4191_/B _4191_/C _4191_/A vssd1 vssd1 vccd1 vccd1 _4194_/B sky130_fd_sc_hd__a21o_1
XANTENNA__3865__A1 _5051_/B vssd1 vssd1 vccd1 vccd1 sky130_fd_sc_hd__diode_2
XANTENNA__4907__A _5083_/A vssd1 vssd1 vccd1 vccd1 sky130_fd_sc_hd__diode_2
X_6902_ vssd1 vssd1 vccd1 vccd1 _6902_/HI depth_mport_o[61] sky130_fd_sc_hd__conb_1
XFILLER_0_82_65 vssd1 vssd1 vccd1 vccd1 sky130_fd_sc_hd__decap_3
X_6833_ _6834_/CLK _6833_/D vssd1 vssd1 vccd1 vccd1 _6833_/Q sky130_fd_sc_hd__dfxtp_1
X_6764_ _6827_/CLK _6764_/D fanout151/X vssd1 vssd1 vccd1 vccd1 pix_mport_o[36] sky130_fd_sc_hd__dfrtp_4
XANTENNA_fanout147_A fanout149/X vssd1 vssd1 vccd1 vccd1 sky130_fd_sc_hd__diode_2
XANTENNA__4642__A _5666_/A vssd1 vssd1 vccd1 vccd1 sky130_fd_sc_hd__diode_2
XFILLER_0_9_335 vssd1 vssd1 vccd1 vccd1 sky130_fd_sc_hd__fill_1
X_3976_ _5049_/A _5049_/B _6678_/Q _4944_/B vssd1 vssd1 vccd1 vccd1 _3976_/X sky130_fd_sc_hd__and4_1
X_6695_ _6802_/CLK _6695_/D vssd1 vssd1 vccd1 vccd1 _6695_/Q sky130_fd_sc_hd__dfxtp_1
X_5715_ _5715_/A _5715_/B vssd1 vssd1 vccd1 vccd1 _5715_/Y sky130_fd_sc_hd__xnor2_1
XFILLER_0_122_82 vssd1 vssd1 vccd1 vccd1 sky130_fd_sc_hd__fill_2
X_5646_ _5800_/B _5800_/C _5656_/B _5645_/Y vssd1 vssd1 vccd1 vccd1 _5649_/B sky130_fd_sc_hd__a22o_1
XFILLER_0_17_157 vssd1 vssd1 vccd1 vccd1 sky130_fd_sc_hd__fill_2
XFILLER_0_72_296 vssd1 vssd1 vccd1 vccd1 sky130_fd_sc_hd__fill_2
XFILLER_0_130_302 vssd1 vssd1 vccd1 vccd1 sky130_fd_sc_hd__fill_2
Xhold220 _6783_/Q vssd1 vssd1 vccd1 vccd1 hold220/X sky130_fd_sc_hd__dlygate4sd3_1
X_5577_ _5393_/B tex_mport_o[44] _5598_/S vssd1 vssd1 vccd1 vccd1 _6601_/D sky130_fd_sc_hd__mux2_1
XFILLER_0_25_190 vssd1 vssd1 vccd1 vccd1 sky130_fd_sc_hd__fill_2
XFILLER_0_130_357 vssd1 vssd1 vccd1 vccd1 sky130_fd_sc_hd__decap_6
XFILLER_0_130_346 vssd1 vssd1 vccd1 vccd1 sky130_fd_sc_hd__decap_4
X_4528_ _4528_/A _4528_/B _4528_/C vssd1 vssd1 vccd1 vccd1 _4541_/A sky130_fd_sc_hd__or3_2
Xhold231 _6109_/X vssd1 vssd1 vccd1 vccd1 _6747_/D sky130_fd_sc_hd__dlygate4sd3_1
Xhold242 _6743_/Q vssd1 vssd1 vccd1 vccd1 hold242/X sky130_fd_sc_hd__dlygate4sd3_1
Xhold253 _6103_/X vssd1 vssd1 vccd1 vccd1 _6741_/D sky130_fd_sc_hd__dlygate4sd3_1
Xhold264 _6725_/Q vssd1 vssd1 vccd1 vccd1 hold264/X sky130_fd_sc_hd__dlygate4sd3_1
Xhold275 _6729_/Q vssd1 vssd1 vccd1 vccd1 hold275/X sky130_fd_sc_hd__dlygate4sd3_1
X_4459_ _4414_/Y _4420_/X _4457_/A _4457_/Y vssd1 vssd1 vccd1 vccd1 _4459_/X sky130_fd_sc_hd__o211a_1
Xhold286 _6649_/Q vssd1 vssd1 vccd1 vccd1 hold286/X sky130_fd_sc_hd__dlygate4sd3_1
Xhold297 _6784_/Q vssd1 vssd1 vccd1 vccd1 _6225_/A sky130_fd_sc_hd__dlygate4sd3_1
X_6129_ pix_mport_o[37] hold73/X _6224_/B vssd1 vssd1 vccd1 vccd1 _6765_/D sky130_fd_sc_hd__mux2_1
XFILLER_0_99_127 vssd1 vssd1 vccd1 vccd1 sky130_fd_sc_hd__fill_1
XFILLER_0_99_116 vssd1 vssd1 vccd1 vccd1 sky130_fd_sc_hd__decap_4
XTAP_580 vssd1 vccd1 sky130_fd_sc_hd__tapvpwrvgnd_1
XTAP_591 vssd1 vccd1 sky130_fd_sc_hd__tapvpwrvgnd_1
XFILLER_0_99_149 vssd1 vssd1 vccd1 vccd1 sky130_fd_sc_hd__decap_8
XANTENNA__3871__A4 _5081_/D vssd1 vssd1 vccd1 vccd1 sky130_fd_sc_hd__diode_2
XANTENNA_104 sstream_i[5] vssd1 vssd1 vccd1 vccd1 sky130_fd_sc_hd__diode_2
XANTENNA_115 sstream_i[9] vssd1 vssd1 vccd1 vccd1 sky130_fd_sc_hd__diode_2
XANTENNA__4255__C _4658_/D vssd1 vssd1 vccd1 vccd1 sky130_fd_sc_hd__diode_2
XANTENNA_137 tex_addr_i[7] vssd1 vssd1 vccd1 vccd1 sky130_fd_sc_hd__diode_2
XANTENNA_126 tex_addr_i[13] vssd1 vssd1 vccd1 vccd1 sky130_fd_sc_hd__diode_2
XANTENNA_148 tex_width_i[2] vssd1 vssd1 vccd1 vccd1 sky130_fd_sc_hd__diode_2
XANTENNA_159 hold168/X vssd1 vssd1 vccd1 vccd1 sky130_fd_sc_hd__diode_2
XFILLER_0_95_388 vssd1 vssd1 vccd1 vccd1 sky130_fd_sc_hd__decap_4
XANTENNA__4552__A _5656_/A vssd1 vssd1 vccd1 vccd1 sky130_fd_sc_hd__diode_2
XANTENNA__4033__A1 _4842_/A vssd1 vssd1 vccd1 vccd1 sky130_fd_sc_hd__diode_2
XANTENNA__4584__A2 _4614_/C vssd1 vssd1 vccd1 vccd1 sky130_fd_sc_hd__diode_2
XFILLER_0_125_129 vssd1 vssd1 vccd1 vccd1 sky130_fd_sc_hd__fill_2
XFILLER_0_106_332 vssd1 vssd1 vccd1 vccd1 sky130_fd_sc_hd__fill_2
XFILLER_0_63_274 vssd1 vssd1 vccd1 vccd1 sky130_fd_sc_hd__decap_6
XFILLER_0_63_263 vssd1 vssd1 vccd1 vccd1 sky130_fd_sc_hd__decap_4
XFILLER_0_11_39 vssd1 vssd1 vccd1 vccd1 sky130_ef_sc_hd__decap_12
XFILLER_0_133_151 vssd1 vssd1 vccd1 vccd1 sky130_fd_sc_hd__fill_1
XFILLER_0_106_365 vssd1 vssd1 vccd1 vccd1 sky130_ef_sc_hd__decap_12
XANTENNA__5533__A1 hold152/X vssd1 vssd1 vccd1 vccd1 sky130_fd_sc_hd__diode_2
XFILLER_0_121_313 vssd1 vssd1 vccd1 vccd1 sky130_fd_sc_hd__fill_2
XFILLER_0_121_346 vssd1 vssd1 vccd1 vccd1 sky130_fd_sc_hd__fill_1
XFILLER_0_31_160 vssd1 vssd1 vccd1 vccd1 sky130_fd_sc_hd__fill_2
XANTENNA__6648__SET_B _5937_/A vssd1 vssd1 vccd1 vccd1 sky130_fd_sc_hd__diode_2
XANTENNA__3631__A _5081_/A vssd1 vssd1 vccd1 vccd1 sky130_fd_sc_hd__diode_2
XFILLER_0_36_47 vssd1 vssd1 vccd1 vccd1 sky130_fd_sc_hd__decap_3
XFILLER_0_98_171 vssd1 vssd1 vccd1 vccd1 sky130_fd_sc_hd__decap_8
XANTENNA__4272__A1 _4816_/A vssd1 vssd1 vccd1 vccd1 sky130_fd_sc_hd__diode_2
XANTENNA__4272__B2 _4776_/A vssd1 vssd1 vccd1 vccd1 sky130_fd_sc_hd__diode_2
XFILLER_0_86_344 vssd1 vssd1 vccd1 vccd1 sky130_fd_sc_hd__fill_1
XFILLER_0_86_377 vssd1 vssd1 vccd1 vccd1 sky130_ef_sc_hd__decap_12
X_3830_ _3830_/A _3830_/B vssd1 vssd1 vccd1 vccd1 _3875_/A sky130_fd_sc_hd__or2_1
XANTENNA__5277__B _5277_/B vssd1 vssd1 vccd1 vccd1 sky130_fd_sc_hd__diode_2
X_3761_ _3747_/X _3750_/B _3999_/A _5276_/B vssd1 vssd1 vccd1 vccd1 _3765_/A sky130_fd_sc_hd__o211ai_1
X_5500_ hold72/X sstream_i[91] _5502_/S vssd1 vssd1 vccd1 vccd1 _6533_/D sky130_fd_sc_hd__mux2_1
X_3692_ _3693_/B _3693_/A vssd1 vssd1 vccd1 vccd1 _3692_/Y sky130_fd_sc_hd__nand2b_1
X_6480_ hold116/X sstream_i[38] _6493_/S vssd1 vssd1 vccd1 vccd1 _6871_/D sky130_fd_sc_hd__mux2_1
XFILLER_0_124_162 vssd1 vssd1 vccd1 vccd1 sky130_fd_sc_hd__decap_4
XANTENNA__4327__A2 _4614_/C vssd1 vssd1 vccd1 vccd1 sky130_fd_sc_hd__diode_2
X_5431_ _5431_/A _5431_/B _5431_/C vssd1 vssd1 vccd1 vccd1 _5456_/A sky130_fd_sc_hd__and3_1
X_5362_ _5364_/A _5364_/B _4608_/Y vssd1 vssd1 vccd1 vccd1 _5363_/B sky130_fd_sc_hd__a21bo_1
X_4313_ _4313_/A _4313_/B vssd1 vssd1 vccd1 vccd1 _4320_/A sky130_fd_sc_hd__xnor2_1
XFILLER_0_77_54 vssd1 vssd1 vccd1 vccd1 sky130_fd_sc_hd__fill_2
XFILLER_0_65_7 vssd1 vssd1 vccd1 vccd1 sky130_fd_sc_hd__fill_1
XFILLER_0_10_355 vssd1 vssd1 vccd1 vccd1 sky130_fd_sc_hd__fill_2
X_5293_ _5293_/A _5293_/B vssd1 vssd1 vccd1 vccd1 _5294_/B sky130_fd_sc_hd__xnor2_1
X_4244_ _4244_/A _4244_/B vssd1 vssd1 vccd1 vccd1 _4250_/B sky130_fd_sc_hd__xnor2_4
XFILLER_0_10_388 vssd1 vssd1 vccd1 vccd1 sky130_ef_sc_hd__decap_12
X_4175_ _4518_/D _5732_/A _4814_/D _4476_/D vssd1 vssd1 vccd1 vccd1 _4176_/D sky130_fd_sc_hd__a22o_1
XFILLER_0_117_82 vssd1 vssd1 vccd1 vccd1 sky130_fd_sc_hd__fill_2
XTAP_1009 vssd1 vccd1 sky130_fd_sc_hd__tapvpwrvgnd_1
X_6816_ _6827_/CLK _6816_/D fanout153/X vssd1 vssd1 vccd1 vccd1 depth_mport_o[38]
+ sky130_fd_sc_hd__dfrtp_4
XANTENNA__6063__S _6072_/S vssd1 vssd1 vccd1 vccd1 sky130_fd_sc_hd__diode_2
XFILLER_0_135_405 vssd1 vssd1 vccd1 vccd1 sky130_fd_sc_hd__fill_2
XANTENNA__5763__A1 _5784_/S vssd1 vssd1 vccd1 vccd1 sky130_fd_sc_hd__diode_2
X_6747_ _6747_/CLK _6747_/D fanout140/X vssd1 vssd1 vccd1 vccd1 _6747_/Q sky130_fd_sc_hd__dfstp_1
X_3959_ _5081_/B _3959_/B _5081_/C _5081_/D vssd1 vssd1 vccd1 vccd1 _3962_/A sky130_fd_sc_hd__nand4_2
XFILLER_0_45_241 vssd1 vssd1 vccd1 vccd1 sky130_fd_sc_hd__decap_8
X_6678_ _6683_/CLK _6678_/D vssd1 vssd1 vccd1 vccd1 _6678_/Q sky130_fd_sc_hd__dfxtp_2
XANTENNA__4318__A2 _4841_/D vssd1 vssd1 vccd1 vccd1 sky130_fd_sc_hd__diode_2
X_5629_ _5621_/X _5627_/Y _5628_/Y _5615_/X vssd1 vssd1 vccd1 vccd1 _5629_/X sky130_fd_sc_hd__o22a_1
XFILLER_0_60_233 vssd1 vssd1 vccd1 vccd1 sky130_fd_sc_hd__fill_2
XFILLER_0_5_393 vssd1 vssd1 vccd1 vccd1 sky130_ef_sc_hd__decap_12
XFILLER_0_60_288 vssd1 vssd1 vccd1 vccd1 sky130_ef_sc_hd__decap_12
XFILLER_0_130_165 vssd1 vssd1 vccd1 vccd1 sky130_fd_sc_hd__fill_2
XFILLER_0_130_187 vssd1 vssd1 vccd1 vccd1 sky130_fd_sc_hd__decap_3
XANTENNA__3451__A _3999_/A vssd1 vssd1 vccd1 vccd1 sky130_fd_sc_hd__diode_2
XANTENNA__4266__B _5687_/A vssd1 vssd1 vccd1 vccd1 sky130_fd_sc_hd__diode_2
XPHY_50 vssd1 vssd1 vccd1 vccd1 sky130_fd_sc_hd__decap_3
XPHY_61 vssd1 vssd1 vccd1 vccd1 sky130_fd_sc_hd__decap_3
XPHY_72 vssd1 vssd1 vccd1 vccd1 sky130_fd_sc_hd__decap_3
XPHY_83 vssd1 vssd1 vccd1 vccd1 sky130_fd_sc_hd__decap_3
XFILLER_0_22_27 vssd1 vssd1 vccd1 vccd1 sky130_fd_sc_hd__fill_1
XFILLER_0_22_49 vssd1 vssd1 vccd1 vccd1 sky130_fd_sc_hd__fill_2
XPHY_94 vssd1 vssd1 vccd1 vccd1 sky130_fd_sc_hd__decap_3
XFILLER_0_36_241 vssd1 vssd1 vccd1 vccd1 sky130_fd_sc_hd__decap_3
XFILLER_0_91_391 vssd1 vssd1 vccd1 vccd1 sky130_fd_sc_hd__fill_1
XFILLER_0_36_296 vssd1 vssd1 vccd1 vccd1 sky130_fd_sc_hd__fill_2
XFILLER_0_51_222 vssd1 vssd1 vccd1 vccd1 sky130_fd_sc_hd__fill_2
XFILLER_0_3_319 vssd1 vssd1 vccd1 vccd1 sky130_fd_sc_hd__decap_4
XFILLER_0_121_110 vssd1 vssd1 vccd1 vccd1 sky130_fd_sc_hd__fill_2
XANTENNA__4190__B1 _4841_/C vssd1 vssd1 vccd1 vccd1 sky130_fd_sc_hd__diode_2
XFILLER_0_2_15 vssd1 vssd1 vccd1 vccd1 sky130_ef_sc_hd__decap_12
XANTENNA__4176__B _4816_/B vssd1 vssd1 vccd1 vccd1 sky130_fd_sc_hd__diode_2
XANTENNA__3511__D _5273_/B vssd1 vssd1 vccd1 vccd1 sky130_fd_sc_hd__diode_2
X_5980_ _4841_/D _5979_/X _6037_/S vssd1 vssd1 vccd1 vccd1 _6664_/D sky130_fd_sc_hd__mux2_1
XFILLER_0_59_322 vssd1 vssd1 vccd1 vccd1 sky130_fd_sc_hd__fill_1
X_4931_ _6640_/Q _4931_/B vssd1 vssd1 vccd1 vccd1 _4932_/B sky130_fd_sc_hd__nor2_1
XFILLER_0_86_152 vssd1 vssd1 vccd1 vccd1 sky130_fd_sc_hd__fill_2
X_4862_ _4862_/A _4862_/B _4862_/C vssd1 vssd1 vccd1 vccd1 _4876_/A sky130_fd_sc_hd__nand3_2
XFILLER_0_117_405 vssd1 vssd1 vccd1 vccd1 sky130_fd_sc_hd__fill_2
X_6601_ _6732_/CLK _6601_/D fanout143/X vssd1 vssd1 vccd1 vccd1 tex_mport_o[44] sky130_fd_sc_hd__dfrtp_4
X_3813_ _3813_/A _3813_/B _3813_/C vssd1 vssd1 vccd1 vccd1 _3814_/B sky130_fd_sc_hd__nor3_1
XANTENNA_37 sstream_i[15] vssd1 vssd1 vccd1 vccd1 sky130_fd_sc_hd__diode_2
XANTENNA_26 sstream_i[13] vssd1 vssd1 vccd1 vccd1 sky130_fd_sc_hd__diode_2
XANTENNA_48 sstream_i[16] vssd1 vssd1 vccd1 vccd1 sky130_fd_sc_hd__diode_2
XANTENNA_15 sstream_i[11] vssd1 vssd1 vccd1 vccd1 sky130_fd_sc_hd__diode_2
X_4793_ _5687_/B _5049_/D vssd1 vssd1 vccd1 vccd1 _4796_/A sky130_fd_sc_hd__and2_1
XANTENNA_59 sstream_i[19] vssd1 vssd1 vccd1 vccd1 sky130_fd_sc_hd__diode_2
X_6532_ _6841_/CLK _6532_/D vssd1 vssd1 vccd1 vccd1 hold59/A sky130_fd_sc_hd__dfxtp_1
XFILLER_0_6_157 vssd1 vssd1 vccd1 vccd1 sky130_fd_sc_hd__decap_3
X_3744_ _3751_/A _3751_/B vssd1 vssd1 vccd1 vccd1 _3744_/Y sky130_fd_sc_hd__nand2b_1
X_6463_ hold182/X sstream_i[21] _6472_/S vssd1 vssd1 vccd1 vccd1 _6854_/D sky130_fd_sc_hd__mux2_1
XFILLER_0_88_20 vssd1 vssd1 vccd1 vccd1 sky130_fd_sc_hd__fill_2
XFILLER_0_12_93 vssd1 vssd1 vccd1 vccd1 sky130_fd_sc_hd__fill_2
X_3675_ _3675_/A _3675_/B _3675_/C vssd1 vssd1 vccd1 vccd1 _3675_/X sky130_fd_sc_hd__or3_2
XFILLER_0_88_53 vssd1 vssd1 vccd1 vccd1 sky130_fd_sc_hd__fill_2
XFILLER_0_30_406 vssd1 vssd1 vccd1 vccd1 sky130_fd_sc_hd__fill_1
X_5414_ _3258_/Y _5355_/Y _5358_/Y _5409_/X _5413_/X vssd1 vssd1 vccd1 vccd1 _5431_/B
+ sky130_fd_sc_hd__o2111a_1
X_6394_ _6378_/Y _6392_/B _6393_/Y vssd1 vssd1 vccd1 vccd1 _6404_/A sky130_fd_sc_hd__o21a_1
XFILLER_0_112_165 vssd1 vssd1 vccd1 vccd1 sky130_fd_sc_hd__fill_2
XFILLER_0_112_154 vssd1 vssd1 vccd1 vccd1 sky130_fd_sc_hd__decap_3
XFILLER_0_2_363 vssd1 vssd1 vccd1 vccd1 sky130_fd_sc_hd__fill_1
XFILLER_0_10_141 vssd1 vssd1 vccd1 vccd1 sky130_fd_sc_hd__decap_4
X_5345_ _5232_/B _5416_/B _5428_/B _5230_/X _5238_/A vssd1 vssd1 vccd1 vccd1 _5445_/C
+ sky130_fd_sc_hd__a311o_1
XFILLER_0_56_3 vssd1 vssd1 vccd1 vccd1 sky130_fd_sc_hd__fill_2
XANTENNA__4720__A2 _5049_/D vssd1 vssd1 vccd1 vccd1 sky130_fd_sc_hd__diode_2
XFILLER_0_10_163 vssd1 vssd1 vccd1 vccd1 sky130_fd_sc_hd__fill_1
X_5276_ _5276_/A _5276_/B vssd1 vssd1 vccd1 vccd1 _5278_/A sky130_fd_sc_hd__nand2_1
XANTENNA__6058__S _6061_/S vssd1 vssd1 vccd1 vccd1 sky130_fd_sc_hd__diode_2
X_4227_ _4223_/Y _4226_/X _4217_/Y _4218_/X vssd1 vssd1 vccd1 vccd1 _4230_/B sky130_fd_sc_hd__a211oi_4
X_4158_ _4158_/A _4158_/B _4158_/C vssd1 vssd1 vccd1 vccd1 _4161_/A sky130_fd_sc_hd__nand3_1
X_4089_ _4089_/A _4089_/B vssd1 vssd1 vccd1 vccd1 _4243_/B sky130_fd_sc_hd__xnor2_2
XANTENNA__4814__B _4958_/B vssd1 vssd1 vccd1 vccd1 sky130_fd_sc_hd__diode_2
XFILLER_0_135_202 vssd1 vssd1 vccd1 vccd1 sky130_fd_sc_hd__decap_6
XFILLER_0_92_144 vssd1 vssd1 vccd1 vccd1 sky130_fd_sc_hd__fill_2
XFILLER_0_73_380 vssd1 vssd1 vccd1 vccd1 sky130_fd_sc_hd__fill_2
XFILLER_0_33_222 vssd1 vssd1 vccd1 vccd1 sky130_fd_sc_hd__fill_2
XFILLER_0_103_198 vssd1 vssd1 vccd1 vccd1 sky130_fd_sc_hd__decap_3
XANTENNA__4172__B1 _4841_/D vssd1 vssd1 vccd1 vccd1 sky130_fd_sc_hd__diode_2
XFILLER_0_108_29 vssd1 vssd1 vccd1 vccd1 sky130_fd_sc_hd__fill_2
XANTENNA__4475__B2 _4789_/B vssd1 vssd1 vccd1 vccd1 sky130_fd_sc_hd__diode_2
XANTENNA__4475__A1 _4736_/D vssd1 vssd1 vccd1 vccd1 sky130_fd_sc_hd__diode_2
XFILLER_0_68_141 vssd1 vssd1 vccd1 vccd1 sky130_fd_sc_hd__fill_2
XFILLER_0_83_133 vssd1 vssd1 vccd1 vccd1 sky130_fd_sc_hd__decap_4
XFILLER_0_83_111 vssd1 vssd1 vccd1 vccd1 sky130_fd_sc_hd__fill_1
XFILLER_0_83_188 vssd1 vssd1 vccd1 vccd1 sky130_fd_sc_hd__fill_1
XANTENNA__4740__A _5083_/A vssd1 vssd1 vccd1 vccd1 sky130_fd_sc_hd__diode_2
XFILLER_0_3_105 vssd1 vssd1 vccd1 vccd1 sky130_fd_sc_hd__decap_6
XFILLER_0_3_149 vssd1 vssd1 vccd1 vccd1 sky130_fd_sc_hd__fill_2
XFILLER_0_24_288 vssd1 vssd1 vccd1 vccd1 sky130_fd_sc_hd__fill_2
X_3460_ _5308_/A _5273_/A _5272_/A _5277_/A vssd1 vssd1 vccd1 vccd1 _3461_/D sky130_fd_sc_hd__a22o_1
X_3391_ _3391_/A _3391_/B vssd1 vssd1 vccd1 vccd1 _3673_/B sky130_fd_sc_hd__xor2_2
X_5130_ _5127_/X _5128_/Y _5098_/B _5100_/B vssd1 vssd1 vccd1 vccd1 _5131_/B sky130_fd_sc_hd__o211ai_1
XANTENNA__6386__B hold7/A vssd1 vssd1 vccd1 vccd1 sky130_fd_sc_hd__diode_2
XANTENNA__3803__B _5049_/D vssd1 vssd1 vccd1 vccd1 sky130_fd_sc_hd__diode_2
X_5061_ _5061_/A _5061_/B _5061_/C vssd1 vssd1 vccd1 vccd1 _5173_/A sky130_fd_sc_hd__and3_1
XFILLER_0_74_22 vssd1 vssd1 vccd1 vccd1 sky130_fd_sc_hd__decap_4
X_4012_ _4013_/A _4013_/B _4013_/C vssd1 vssd1 vccd1 vccd1 _4012_/Y sky130_fd_sc_hd__nor3_1
XFILLER_0_35_8 vssd1 vssd1 vccd1 vccd1 sky130_fd_sc_hd__fill_2
XFILLER_0_74_44 vssd1 vssd1 vccd1 vccd1 sky130_fd_sc_hd__decap_3
X_5963_ _5963_/A _5963_/B _5963_/C _5948_/X vssd1 vssd1 vccd1 vccd1 _5964_/D sky130_fd_sc_hd__or4b_1
XFILLER_0_90_43 vssd1 vssd1 vccd1 vccd1 sky130_fd_sc_hd__fill_2
X_4914_ _4914_/A _4914_/B vssd1 vssd1 vccd1 vccd1 _4915_/B sky130_fd_sc_hd__nand2_1
XFILLER_0_90_76 vssd1 vssd1 vccd1 vccd1 sky130_fd_sc_hd__fill_2
XFILLER_0_90_65 vssd1 vssd1 vccd1 vccd1 sky130_fd_sc_hd__decap_3
X_5894_ hold284/X _5893_/X _5923_/S vssd1 vssd1 vccd1 vccd1 _6648_/D sky130_fd_sc_hd__mux2_1
X_4845_ _4844_/B _4844_/C _4844_/A vssd1 vssd1 vccd1 vccd1 _4847_/B sky130_fd_sc_hd__a21bo_1
X_4776_ _4776_/A _4816_/B _4808_/A _4776_/D vssd1 vssd1 vccd1 vccd1 _4808_/B sky130_fd_sc_hd__nand4_1
XFILLER_0_132_205 vssd1 vssd1 vccd1 vccd1 sky130_fd_sc_hd__decap_4
XFILLER_0_99_41 vssd1 vssd1 vccd1 vccd1 sky130_fd_sc_hd__fill_2
X_6515_ _6834_/CLK _6515_/D vssd1 vssd1 vccd1 vccd1 _6515_/Q sky130_fd_sc_hd__dfxtp_1
X_3727_ _5320_/A _5300_/B _3645_/C _3645_/D vssd1 vssd1 vccd1 vccd1 _3727_/Y sky130_fd_sc_hd__a22oi_1
XFILLER_0_132_249 vssd1 vssd1 vccd1 vccd1 sky130_fd_sc_hd__fill_1
XFILLER_0_125_290 vssd1 vssd1 vccd1 vccd1 sky130_fd_sc_hd__decap_3
XFILLER_0_15_288 vssd1 vssd1 vccd1 vccd1 sky130_fd_sc_hd__fill_1
X_6446_ hold130/X sstream_i[4] _6464_/S vssd1 vssd1 vccd1 vccd1 _6837_/D sky130_fd_sc_hd__mux2_1
X_3658_ _3658_/A _3658_/B vssd1 vssd1 vccd1 vccd1 _3671_/A sky130_fd_sc_hd__xnor2_1
XFILLER_0_30_247 vssd1 vssd1 vccd1 vccd1 sky130_fd_sc_hd__fill_2
X_6377_ _6377_/A _6383_/B vssd1 vssd1 vccd1 vccd1 _6392_/A sky130_fd_sc_hd__xnor2_1
X_3589_ _3589_/A _3589_/B vssd1 vssd1 vccd1 vccd1 _3620_/A sky130_fd_sc_hd__xnor2_1
XFILLER_0_2_160 vssd1 vssd1 vccd1 vccd1 sky130_fd_sc_hd__fill_1
X_5328_ _5328_/A _5328_/B vssd1 vssd1 vccd1 vccd1 _5329_/B sky130_fd_sc_hd__xor2_1
XANTENNA__4809__B _4970_/B vssd1 vssd1 vccd1 vccd1 sky130_fd_sc_hd__diode_2
X_5259_ _5410_/D _5340_/B vssd1 vssd1 vccd1 vccd1 _5259_/X sky130_fd_sc_hd__or2_1
XANTENNA__3432__C _5299_/A vssd1 vssd1 vccd1 vccd1 sky130_fd_sc_hd__diode_2
XFILLER_0_97_225 vssd1 vssd1 vccd1 vccd1 sky130_fd_sc_hd__decap_6
XFILLER_0_97_203 vssd1 vssd1 vccd1 vccd1 sky130_fd_sc_hd__decap_8
XFILLER_0_65_155 vssd1 vssd1 vccd1 vccd1 sky130_fd_sc_hd__fill_2
XANTENNA__5656__A _5656_/A vssd1 vssd1 vccd1 vccd1 sky130_fd_sc_hd__diode_2
XFILLER_0_80_158 vssd1 vssd1 vccd1 vccd1 sky130_fd_sc_hd__decap_4
XFILLER_0_21_225 vssd1 vssd1 vccd1 vccd1 sky130_ef_sc_hd__decap_12
XTAP_409 vssd1 vccd1 sky130_fd_sc_hd__tapvpwrvgnd_1
XANTENNA__5893__A0 _5434_/X vssd1 vssd1 vccd1 vccd1 sky130_fd_sc_hd__diode_2
XANTENNA__4448__A1 _4488_/A vssd1 vssd1 vccd1 vccd1 sky130_fd_sc_hd__diode_2
XFILLER_0_88_236 vssd1 vssd1 vccd1 vccd1 sky130_fd_sc_hd__fill_2
XANTENNA__4173__C _4971_/B vssd1 vssd1 vccd1 vccd1 sky130_fd_sc_hd__diode_2
XTAP_1192 vssd1 vccd1 sky130_fd_sc_hd__tapvpwrvgnd_1
XTAP_1181 vssd1 vccd1 sky130_fd_sc_hd__tapvpwrvgnd_1
XTAP_1170 vssd1 vccd1 sky130_fd_sc_hd__tapvpwrvgnd_1
XFILLER_0_56_133 vssd1 vssd1 vccd1 vccd1 sky130_fd_sc_hd__fill_2
X_4630_ _4626_/A _4633_/A _4633_/B vssd1 vssd1 vccd1 vccd1 _4631_/C sky130_fd_sc_hd__o21ba_1
XFILLER_0_44_317 vssd1 vssd1 vccd1 vccd1 sky130_fd_sc_hd__fill_2
XFILLER_0_114_3 vssd1 vssd1 vccd1 vccd1 sky130_fd_sc_hd__decap_3
X_6300_ _3335_/B _6300_/B vssd1 vssd1 vccd1 vccd1 _6300_/Y sky130_fd_sc_hd__nand2b_1
X_4561_ _4568_/A _4568_/B vssd1 vssd1 vccd1 vccd1 _4581_/A sky130_fd_sc_hd__or2_1
XFILLER_0_71_169 vssd1 vssd1 vccd1 vccd1 sky130_fd_sc_hd__fill_2
XFILLER_0_69_22 vssd1 vssd1 vccd1 vccd1 sky130_fd_sc_hd__decap_3
X_4492_ _4492_/A _4492_/B vssd1 vssd1 vccd1 vccd1 _4494_/B sky130_fd_sc_hd__or2_1
XFILLER_0_69_55 vssd1 vssd1 vccd1 vccd1 sky130_fd_sc_hd__fill_1
XFILLER_0_12_225 vssd1 vssd1 vccd1 vccd1 sky130_fd_sc_hd__decap_4
X_3512_ _3513_/B _3513_/C vssd1 vssd1 vccd1 vccd1 _3514_/B sky130_fd_sc_hd__nor2_1
X_6231_ _6231_/A _6231_/B vssd1 vssd1 vccd1 vccd1 _6231_/X sky130_fd_sc_hd__or2_1
XFILLER_0_69_88 vssd1 vssd1 vccd1 vccd1 sky130_fd_sc_hd__fill_2
XFILLER_0_12_269 vssd1 vssd1 vccd1 vccd1 sky130_fd_sc_hd__fill_2
X_3443_ _3444_/A _3444_/B vssd1 vssd1 vccd1 vccd1 _3445_/A sky130_fd_sc_hd__or2_1
X_6162_ _6162_/A _6162_/B vssd1 vssd1 vccd1 vccd1 _6163_/B sky130_fd_sc_hd__nand2_1
XFILLER_0_100_85 vssd1 vssd1 vccd1 vccd1 sky130_fd_sc_hd__decap_3
XTAP_910 vssd1 vccd1 sky130_fd_sc_hd__tapvpwrvgnd_1
XANTENNA__5884__B1 _5882_/B vssd1 vssd1 vccd1 vccd1 sky130_fd_sc_hd__diode_2
XTAP_943 vssd1 vccd1 sky130_fd_sc_hd__tapvpwrvgnd_1
XTAP_932 vssd1 vccd1 sky130_fd_sc_hd__tapvpwrvgnd_1
XTAP_921 vssd1 vccd1 sky130_fd_sc_hd__tapvpwrvgnd_1
X_3374_ _3375_/A _3375_/B vssd1 vssd1 vccd1 vccd1 _3374_/X sky130_fd_sc_hd__or2_1
X_5113_ _5114_/B _5114_/A vssd1 vssd1 vccd1 vccd1 _5113_/Y sky130_fd_sc_hd__nand2b_1
X_6093_ hold268/X _6731_/Q _6098_/S vssd1 vssd1 vccd1 vccd1 _6093_/X sky130_fd_sc_hd__mux2_1
XTAP_987 vssd1 vccd1 sky130_fd_sc_hd__tapvpwrvgnd_1
XTAP_976 vssd1 vccd1 sky130_fd_sc_hd__tapvpwrvgnd_1
XTAP_965 vssd1 vccd1 sky130_fd_sc_hd__tapvpwrvgnd_1
XTAP_954 vssd1 vccd1 sky130_fd_sc_hd__tapvpwrvgnd_1
XTAP_998 vssd1 vccd1 sky130_fd_sc_hd__tapvpwrvgnd_1
XFILLER_0_85_87 vssd1 vssd1 vccd1 vccd1 sky130_fd_sc_hd__decap_3
X_5044_ _4963_/A _5086_/B _4962_/B _4964_/B _4964_/A vssd1 vssd1 vccd1 vccd1 _5058_/A
+ sky130_fd_sc_hd__a32o_1
XFILLER_0_79_225 vssd1 vssd1 vccd1 vccd1 sky130_fd_sc_hd__decap_4
XFILLER_0_79_203 vssd1 vssd1 vccd1 vccd1 sky130_fd_sc_hd__fill_2
XANTENNA__4067__D _4736_/D vssd1 vssd1 vccd1 vccd1 sky130_fd_sc_hd__diode_2
XFILLER_0_19_3 vssd1 vssd1 vccd1 vccd1 sky130_ef_sc_hd__decap_12
XANTENNA__3414__A2 _5273_/A vssd1 vssd1 vccd1 vccd1 sky130_fd_sc_hd__diode_2
X_5946_ _5946_/A _5964_/A _5962_/C vssd1 vssd1 vccd1 vccd1 _5946_/Y sky130_fd_sc_hd__nor3_1
X_5877_ tex_addr_i[24] _5882_/B _5867_/Y vssd1 vssd1 vccd1 vccd1 _5878_/B sky130_fd_sc_hd__a21o_1
XANTENNA__6071__S _6072_/S vssd1 vssd1 vccd1 vccd1 sky130_fd_sc_hd__diode_2
XFILLER_0_90_401 vssd1 vssd1 vccd1 vccd1 sky130_fd_sc_hd__decap_6
XFILLER_0_47_188 vssd1 vssd1 vccd1 vccd1 sky130_fd_sc_hd__fill_2
X_4828_ _4842_/A tex_width_i[15] _4971_/B _5787_/A vssd1 vssd1 vccd1 vccd1 _4830_/B
+ sky130_fd_sc_hd__nand4_2
XANTENNA__3708__B _5277_/B vssd1 vssd1 vccd1 vccd1 sky130_fd_sc_hd__diode_2
X_4759_ _4757_/A _4757_/C _4757_/B vssd1 vssd1 vccd1 vccd1 _4760_/C sky130_fd_sc_hd__a21o_1
X_6429_ _6427_/X _6428_/Y _6441_/B vssd1 vssd1 vccd1 vccd1 _6429_/X sky130_fd_sc_hd__o21a_1
XANTENNA__6750__SET_B fanout140/X vssd1 vssd1 vccd1 vccd1 sky130_fd_sc_hd__diode_2
XFILLER_0_85_239 vssd1 vssd1 vccd1 vccd1 sky130_fd_sc_hd__fill_1
XFILLER_0_38_100 vssd1 vssd1 vccd1 vccd1 sky130_fd_sc_hd__fill_2
XPHY_242 vssd1 vssd1 vccd1 vccd1 sky130_fd_sc_hd__decap_3
XPHY_231 vssd1 vssd1 vccd1 vccd1 sky130_fd_sc_hd__decap_3
XPHY_220 vssd1 vssd1 vccd1 vccd1 sky130_fd_sc_hd__decap_3
XPHY_275 vssd1 vssd1 vccd1 vccd1 sky130_fd_sc_hd__decap_3
XPHY_264 vssd1 vssd1 vccd1 vccd1 sky130_fd_sc_hd__decap_3
XPHY_253 vssd1 vssd1 vccd1 vccd1 sky130_fd_sc_hd__decap_3
XANTENNA__4290__A _5666_/A vssd1 vssd1 vccd1 vccd1 sky130_fd_sc_hd__diode_2
XFILLER_0_38_166 vssd1 vssd1 vccd1 vccd1 sky130_fd_sc_hd__fill_1
XFILLER_0_136_363 vssd1 vssd1 vccd1 vccd1 sky130_fd_sc_hd__fill_1
XFILLER_0_26_339 vssd1 vssd1 vccd1 vccd1 sky130_fd_sc_hd__fill_1
XFILLER_0_30_16 vssd1 vssd1 vccd1 vccd1 sky130_fd_sc_hd__fill_2
XFILLER_0_41_309 vssd1 vssd1 vccd1 vccd1 sky130_fd_sc_hd__fill_1
XFILLER_0_111_219 vssd1 vssd1 vccd1 vccd1 sky130_fd_sc_hd__fill_2
XFILLER_0_61_191 vssd1 vssd1 vccd1 vccd1 sky130_fd_sc_hd__decap_3
XANTENNA__3341__A1 _5296_/A vssd1 vssd1 vccd1 vccd1 sky130_fd_sc_hd__diode_2
XANTENNA__3341__B2 _5081_/D vssd1 vssd1 vccd1 vccd1 sky130_fd_sc_hd__diode_2
Xhold2 hold2/A vssd1 vssd1 vccd1 vccd1 hold2/X sky130_fd_sc_hd__dlygate4sd3_1
XANTENNA__3644__A2 _5296_/A vssd1 vssd1 vccd1 vccd1 sky130_fd_sc_hd__diode_2
X_6780_ _6832_/CLK _6780_/D fanout152/X vssd1 vssd1 vccd1 vccd1 depth_mport_o[68]
+ sky130_fd_sc_hd__dfrtp_4
X_5800_ _6521_/Q _5800_/B _5800_/C vssd1 vssd1 vccd1 vccd1 _5803_/C sky130_fd_sc_hd__and3_1
XFILLER_0_29_100 vssd1 vssd1 vccd1 vccd1 sky130_fd_sc_hd__decap_4
XFILLER_0_29_111 vssd1 vssd1 vccd1 vccd1 sky130_fd_sc_hd__fill_1
X_3992_ _3992_/A _3992_/B _3992_/C vssd1 vssd1 vccd1 vccd1 _3992_/X sky130_fd_sc_hd__or3_2
X_5731_ _5732_/A _5732_/B vssd1 vssd1 vccd1 vccd1 _5754_/C sky130_fd_sc_hd__or2_1
XFILLER_0_84_261 vssd1 vssd1 vccd1 vccd1 sky130_fd_sc_hd__decap_4
XFILLER_0_84_250 vssd1 vssd1 vccd1 vccd1 sky130_fd_sc_hd__fill_2
XANTENNA__5296__A _5296_/A vssd1 vssd1 vccd1 vccd1 sky130_fd_sc_hd__diode_2
XFILLER_0_29_166 vssd1 vssd1 vccd1 vccd1 sky130_fd_sc_hd__fill_2
XFILLER_0_29_177 vssd1 vssd1 vccd1 vccd1 sky130_fd_sc_hd__fill_1
X_5662_ _5662_/A _5662_/B vssd1 vssd1 vccd1 vccd1 _5662_/Y sky130_fd_sc_hd__xnor2_1
XFILLER_0_44_147 vssd1 vssd1 vccd1 vccd1 sky130_fd_sc_hd__fill_1
X_4613_ _6626_/Q _4613_/B vssd1 vssd1 vccd1 vccd1 _4625_/A sky130_fd_sc_hd__xnor2_1
X_5593_ _5342_/Y tex_mport_o[57] _5601_/S vssd1 vssd1 vccd1 vccd1 _6614_/D sky130_fd_sc_hd__mux2_1
X_4544_ _4535_/X _4537_/Y _4545_/A _4543_/X vssd1 vssd1 vccd1 vccd1 _4545_/B sky130_fd_sc_hd__a211oi_2
XFILLER_0_4_266 vssd1 vssd1 vccd1 vccd1 sky130_fd_sc_hd__fill_2
XFILLER_0_4_244 vssd1 vssd1 vccd1 vccd1 sky130_fd_sc_hd__fill_1
XFILLER_0_40_320 vssd1 vssd1 vccd1 vccd1 sky130_fd_sc_hd__fill_1
X_6214_ _6224_/B _6218_/A _6213_/Y _6207_/X vssd1 vssd1 vccd1 vccd1 _6775_/D sky130_fd_sc_hd__a31o_1
X_4475_ _4736_/D _4518_/D _4476_/D _4789_/B vssd1 vssd1 vccd1 vccd1 _4477_/A sky130_fd_sc_hd__a22oi_1
XFILLER_0_96_75 vssd1 vssd1 vccd1 vccd1 sky130_fd_sc_hd__decap_3
X_3426_ _3426_/A _3426_/B vssd1 vssd1 vccd1 vccd1 _3579_/B sky130_fd_sc_hd__xnor2_1
X_6145_ _6136_/D _6136_/Y _6143_/Y _6207_/B vssd1 vssd1 vccd1 vccd1 _6145_/Y sky130_fd_sc_hd__a31oi_1
XTAP_751 vssd1 vccd1 sky130_fd_sc_hd__tapvpwrvgnd_1
XTAP_740 vssd1 vccd1 sky130_fd_sc_hd__tapvpwrvgnd_1
X_3357_ _5290_/A _5327_/A _6689_/Q _6690_/Q vssd1 vssd1 vccd1 vccd1 _3397_/A sky130_fd_sc_hd__and4_1
X_6076_ hold3/X hold54/A _6315_/S vssd1 vssd1 vccd1 vccd1 hold4/A sky130_fd_sc_hd__mux2_1
XTAP_795 vssd1 vccd1 sky130_fd_sc_hd__tapvpwrvgnd_1
XTAP_784 vssd1 vccd1 sky130_fd_sc_hd__tapvpwrvgnd_1
XTAP_773 vssd1 vccd1 sky130_fd_sc_hd__tapvpwrvgnd_1
XTAP_762 vssd1 vccd1 sky130_fd_sc_hd__tapvpwrvgnd_1
XANTENNA__6066__S _6072_/S vssd1 vssd1 vccd1 vccd1 sky130_fd_sc_hd__diode_2
X_5027_ _5018_/A _5018_/C _5018_/B vssd1 vssd1 vccd1 vccd1 _5027_/X sky130_fd_sc_hd__a21o_1
X_3288_ tex_height_i[5] vssd1 vssd1 vccd1 vccd1 _3288_/Y sky130_fd_sc_hd__inv_2
XANTENNA__3635__A2 _5273_/A vssd1 vssd1 vccd1 vccd1 sky130_fd_sc_hd__diode_2
XANTENNA__6034__A0 _3961_/A vssd1 vssd1 vccd1 vccd1 sky130_fd_sc_hd__diode_2
X_6978_ vssd1 vssd1 vccd1 vccd1 _6978_/HI tex_mport_o[31] sky130_fd_sc_hd__conb_1
X_5929_ hold66/X tex_mport_i[4] _5932_/S vssd1 vssd1 vccd1 vccd1 _6657_/D sky130_fd_sc_hd__mux2_1
XFILLER_0_0_81 vssd1 vssd1 vccd1 vccd1 sky130_fd_sc_hd__decap_3
XANTENNA__4822__B _4822_/B vssd1 vssd1 vccd1 vccd1 sky130_fd_sc_hd__diode_2
XFILLER_0_118_363 vssd1 vssd1 vccd1 vccd1 sky130_fd_sc_hd__fill_1
XFILLER_0_90_220 vssd1 vssd1 vccd1 vccd1 sky130_fd_sc_hd__decap_3
XFILLER_0_35_147 vssd1 vssd1 vccd1 vccd1 sky130_fd_sc_hd__decap_3
XFILLER_0_90_253 vssd1 vssd1 vccd1 vccd1 sky130_fd_sc_hd__fill_2
XFILLER_0_35_169 vssd1 vssd1 vccd1 vccd1 sky130_fd_sc_hd__decap_3
XFILLER_0_133_366 vssd1 vssd1 vccd1 vccd1 sky130_ef_sc_hd__decap_12
XFILLER_0_8_3 vssd1 vssd1 vccd1 vccd1 sky130_ef_sc_hd__decap_12
XANTENNA__5091__D _6683_/Q vssd1 vssd1 vccd1 vccd1 sky130_fd_sc_hd__diode_2
XFILLER_0_116_29 vssd1 vssd1 vccd1 vccd1 sky130_fd_sc_hd__decap_4
XFILLER_0_25_27 vssd1 vssd1 vccd1 vccd1 sky130_fd_sc_hd__decap_3
XANTENNA__4823__A1 _4970_/B vssd1 vssd1 vccd1 vccd1 sky130_fd_sc_hd__diode_2
XANTENNA__4716__C _4736_/D vssd1 vssd1 vccd1 vccd1 sky130_fd_sc_hd__diode_2
XANTENNA__4823__B2 _4966_/C vssd1 vssd1 vccd1 vccd1 sky130_fd_sc_hd__diode_2
XFILLER_0_98_397 vssd1 vssd1 vccd1 vccd1 sky130_fd_sc_hd__decap_8
XFILLER_0_109_330 vssd1 vssd1 vccd1 vccd1 sky130_fd_sc_hd__fill_2
XANTENNA__4051__A2 _4518_/D vssd1 vssd1 vccd1 vccd1 sky130_fd_sc_hd__diode_2
XFILLER_0_14_309 vssd1 vssd1 vccd1 vccd1 sky130_fd_sc_hd__fill_1
XANTENNA__3348__B _5296_/A vssd1 vssd1 vccd1 vccd1 sky130_fd_sc_hd__diode_2
XFILLER_0_124_355 vssd1 vssd1 vccd1 vccd1 sky130_fd_sc_hd__fill_1
XFILLER_0_1_225 vssd1 vssd1 vccd1 vccd1 sky130_fd_sc_hd__decap_3
XANTENNA__5839__B1 _5882_/B vssd1 vssd1 vccd1 vccd1 sky130_fd_sc_hd__diode_2
X_4260_ _4261_/A _4261_/B vssd1 vssd1 vccd1 vccd1 _4281_/B sky130_fd_sc_hd__and2_1
XFILLER_0_5_15 vssd1 vssd1 vccd1 vccd1 sky130_ef_sc_hd__decap_12
X_4191_ _4191_/A _4191_/B _4191_/C vssd1 vssd1 vccd1 vccd1 _4194_/A sky130_fd_sc_hd__nand3_1
XFILLER_0_66_56 vssd1 vssd1 vccd1 vccd1 sky130_fd_sc_hd__fill_1
XANTENNA__3865__A2 _5083_/B vssd1 vssd1 vccd1 vccd1 sky130_fd_sc_hd__diode_2
XANTENNA__4907__B _5666_/A vssd1 vssd1 vccd1 vccd1 sky130_fd_sc_hd__diode_2
X_6901_ vssd1 vssd1 vccd1 vccd1 _6901_/HI depth_mport_o[60] sky130_fd_sc_hd__conb_1
XFILLER_0_89_342 vssd1 vssd1 vccd1 vccd1 sky130_ef_sc_hd__decap_12
X_6832_ _6832_/CLK _6832_/D fanout152/X vssd1 vssd1 vccd1 vccd1 depth_mport_o[66]
+ sky130_fd_sc_hd__dfrtp_4
XFILLER_0_82_99 vssd1 vssd1 vccd1 vccd1 sky130_fd_sc_hd__fill_1
XFILLER_0_119_127 vssd1 vssd1 vccd1 vccd1 sky130_fd_sc_hd__fill_2
X_6763_ _6827_/CLK _6763_/D fanout151/X vssd1 vssd1 vccd1 vccd1 pix_mport_o[35] sky130_fd_sc_hd__dfrtp_4
XFILLER_0_64_209 vssd1 vssd1 vccd1 vccd1 sky130_fd_sc_hd__fill_2
X_3975_ _5051_/A _5064_/B _3881_/A _3880_/D vssd1 vssd1 vccd1 vccd1 _3975_/X sky130_fd_sc_hd__a22o_1
XFILLER_0_57_272 vssd1 vssd1 vccd1 vccd1 sky130_fd_sc_hd__decap_6
X_6694_ _6802_/CLK _6694_/D vssd1 vssd1 vccd1 vccd1 hold55/A sky130_fd_sc_hd__dfxtp_1
X_5714_ _5692_/A _5699_/X _5704_/X _5704_/B tex_addr_i[6] vssd1 vssd1 vccd1 vccd1
+ _5715_/B sky130_fd_sc_hd__a32oi_4
XFILLER_0_122_72 vssd1 vssd1 vccd1 vccd1 sky130_fd_sc_hd__fill_1
XFILLER_0_115_311 vssd1 vssd1 vccd1 vccd1 sky130_fd_sc_hd__fill_1
X_5645_ _5645_/A _5645_/B vssd1 vssd1 vccd1 vccd1 _5645_/Y sky130_fd_sc_hd__nand2_1
XFILLER_0_72_253 vssd1 vssd1 vccd1 vccd1 sky130_fd_sc_hd__decap_3
XFILLER_0_17_169 vssd1 vssd1 vccd1 vccd1 sky130_fd_sc_hd__fill_1
XFILLER_0_86_3 vssd1 vssd1 vccd1 vccd1 sky130_fd_sc_hd__fill_2
XANTENNA__5754__A _5754_/A vssd1 vssd1 vccd1 vccd1 sky130_fd_sc_hd__diode_2
XFILLER_0_32_106 vssd1 vssd1 vccd1 vccd1 sky130_fd_sc_hd__decap_3
X_5576_ _5360_/X tex_mport_o[43] _5576_/S vssd1 vssd1 vccd1 vccd1 _6600_/D sky130_fd_sc_hd__mux2_1
Xhold210 _6625_/Q vssd1 vssd1 vccd1 vccd1 hold210/X sky130_fd_sc_hd__dlygate4sd3_1
XANTENNA__3553__A1 _5286_/A vssd1 vssd1 vccd1 vccd1 sky130_fd_sc_hd__diode_2
XFILLER_0_25_180 vssd1 vssd1 vccd1 vccd1 sky130_fd_sc_hd__decap_8
Xhold232 _6721_/Q vssd1 vssd1 vccd1 vccd1 hold232/X sky130_fd_sc_hd__dlygate4sd3_1
X_4527_ _5718_/B _4527_/B _4536_/A _4527_/D vssd1 vssd1 vccd1 vccd1 _4528_/C sky130_fd_sc_hd__nand4_1
XFILLER_0_40_150 vssd1 vssd1 vccd1 vccd1 sky130_fd_sc_hd__fill_2
Xhold243 _6105_/X vssd1 vssd1 vccd1 vccd1 _6743_/D sky130_fd_sc_hd__dlygate4sd3_1
Xhold221 _6638_/Q vssd1 vssd1 vccd1 vccd1 hold221/X sky130_fd_sc_hd__dlygate4sd3_1
Xhold265 _6087_/X vssd1 vssd1 vccd1 vccd1 _6725_/D sky130_fd_sc_hd__dlygate4sd3_1
Xhold276 _6091_/X vssd1 vssd1 vccd1 vccd1 _6729_/D sky130_fd_sc_hd__dlygate4sd3_1
X_4458_ _4457_/A _4457_/Y _4414_/Y _4420_/X vssd1 vssd1 vccd1 vccd1 _4458_/Y sky130_fd_sc_hd__a211oi_4
Xhold287 _6644_/Q vssd1 vssd1 vccd1 vccd1 hold287/X sky130_fd_sc_hd__dlygate4sd3_1
Xhold254 _6740_/Q vssd1 vssd1 vccd1 vccd1 hold254/X sky130_fd_sc_hd__dlygate4sd3_1
X_3409_ _3409_/A _3409_/B vssd1 vssd1 vccd1 vccd1 _3615_/B sky130_fd_sc_hd__xor2_1
Xhold298 _6669_/Q vssd1 vssd1 vccd1 vccd1 hold298/X sky130_fd_sc_hd__dlygate4sd3_1
X_6128_ pix_mport_o[36] hold86/X _6224_/B vssd1 vssd1 vccd1 vccd1 _6764_/D sky130_fd_sc_hd__mux2_1
X_4389_ _4422_/B vssd1 vssd1 vccd1 vccd1 _4484_/A sky130_fd_sc_hd__inv_2
XTAP_570 vssd1 vccd1 sky130_fd_sc_hd__tapvpwrvgnd_1
XTAP_581 vssd1 vccd1 sky130_fd_sc_hd__tapvpwrvgnd_1
XTAP_592 vssd1 vccd1 sky130_fd_sc_hd__tapvpwrvgnd_1
X_6059_ hold45/X hold53/X _6072_/S vssd1 vssd1 vccd1 vccd1 _6698_/D sky130_fd_sc_hd__mux2_1
XANTENNA_116 sstream_i[9] vssd1 vssd1 vccd1 vccd1 sky130_fd_sc_hd__diode_2
XANTENNA_105 sstream_i[6] vssd1 vssd1 vccd1 vccd1 sky130_fd_sc_hd__diode_2
XANTENNA_138 tex_addr_i[7] vssd1 vssd1 vccd1 vccd1 sky130_fd_sc_hd__diode_2
XANTENNA_127 tex_addr_i[13] vssd1 vssd1 vccd1 vccd1 sky130_fd_sc_hd__diode_2
XANTENNA_149 tex_width_i[7] vssd1 vssd1 vccd1 vccd1 sky130_fd_sc_hd__diode_2
XANTENNA__4833__A _4971_/B vssd1 vssd1 vccd1 vccd1 sky130_fd_sc_hd__diode_2
XANTENNA__4552__B _4614_/C vssd1 vssd1 vccd1 vccd1 sky130_fd_sc_hd__diode_2
XFILLER_0_48_272 vssd1 vssd1 vccd1 vccd1 sky130_fd_sc_hd__decap_4
XFILLER_0_48_283 vssd1 vssd1 vccd1 vccd1 sky130_fd_sc_hd__decap_4
XFILLER_0_48_294 vssd1 vssd1 vccd1 vccd1 sky130_fd_sc_hd__fill_1
XFILLER_0_133_141 vssd1 vssd1 vccd1 vccd1 sky130_fd_sc_hd__fill_2
XFILLER_0_106_377 vssd1 vssd1 vccd1 vccd1 sky130_ef_sc_hd__decap_12
XFILLER_0_31_183 vssd1 vssd1 vccd1 vccd1 sky130_fd_sc_hd__decap_3
XANTENNA__5297__A1 _5276_/A vssd1 vssd1 vccd1 vccd1 sky130_fd_sc_hd__diode_2
XANTENNA__3631__B _5300_/A vssd1 vssd1 vccd1 vccd1 sky130_fd_sc_hd__diode_2
XANTENNA__4272__A2 _4736_/B vssd1 vssd1 vccd1 vccd1 sky130_fd_sc_hd__diode_2
XFILLER_0_86_389 vssd1 vssd1 vccd1 vccd1 sky130_ef_sc_hd__decap_12
X_3760_ _3678_/Y _3704_/X _3758_/A _3758_/Y vssd1 vssd1 vccd1 vccd1 _3771_/B sky130_fd_sc_hd__a211oi_1
XFILLER_0_39_272 vssd1 vssd1 vccd1 vccd1 sky130_fd_sc_hd__fill_2
XFILLER_0_54_253 vssd1 vssd1 vccd1 vccd1 sky130_ef_sc_hd__decap_12
XANTENNA__5574__A _5599_/A vssd1 vssd1 vccd1 vccd1 sky130_fd_sc_hd__diode_2
X_3691_ _3691_/A _3691_/B vssd1 vssd1 vccd1 vccd1 _3693_/B sky130_fd_sc_hd__xor2_1
X_5430_ _3260_/Y _5342_/Y _5418_/X _5419_/Y _5429_/X vssd1 vssd1 vccd1 vccd1 _5431_/C
+ sky130_fd_sc_hd__a2111oi_1
X_5361_ _5361_/A _5361_/B vssd1 vssd1 vccd1 vccd1 _5762_/B sky130_fd_sc_hd__xnor2_1
X_4312_ _5754_/B _4527_/B vssd1 vssd1 vccd1 vccd1 _4396_/A sky130_fd_sc_hd__nand2_1
X_5292_ _5292_/A _6688_/Q vssd1 vssd1 vccd1 vccd1 _5293_/B sky130_fd_sc_hd__nand2_1
XFILLER_0_22_172 vssd1 vssd1 vccd1 vccd1 sky130_fd_sc_hd__fill_2
XFILLER_0_22_194 vssd1 vssd1 vccd1 vccd1 sky130_fd_sc_hd__fill_2
X_4243_ _4243_/A _4243_/B vssd1 vssd1 vccd1 vccd1 _4250_/A sky130_fd_sc_hd__xor2_4
XFILLER_0_10_345 vssd1 vssd1 vccd1 vccd1 sky130_fd_sc_hd__fill_2
XANTENNA__3822__A _5051_/A vssd1 vssd1 vccd1 vccd1 sky130_fd_sc_hd__diode_2
X_4174_ _4518_/D _4476_/D _5732_/A _4814_/D vssd1 vssd1 vccd1 vccd1 _4731_/A sky130_fd_sc_hd__nand4_2
Xclkbuf_leaf_5_clk_i clkbuf_leaf_9_clk_i/A vssd1 vssd1 vccd1 vccd1 _6855_/CLK sky130_fd_sc_hd__clkbuf_16
XFILLER_0_93_76 vssd1 vssd1 vccd1 vccd1 sky130_fd_sc_hd__fill_1
X_6815_ _6827_/CLK _6815_/D fanout151/X vssd1 vssd1 vccd1 vccd1 depth_mport_o[37]
+ sky130_fd_sc_hd__dfrtp_4
XFILLER_0_9_111 vssd1 vssd1 vccd1 vccd1 sky130_fd_sc_hd__fill_1
XFILLER_0_37_209 vssd1 vssd1 vccd1 vccd1 sky130_fd_sc_hd__fill_2
XFILLER_0_133_71 vssd1 vssd1 vccd1 vccd1 sky130_fd_sc_hd__decap_3
XFILLER_0_92_337 vssd1 vssd1 vccd1 vccd1 sky130_ef_sc_hd__decap_12
XFILLER_0_9_144 vssd1 vssd1 vccd1 vccd1 sky130_fd_sc_hd__fill_1
X_6746_ _6747_/CLK _6746_/D fanout139/X vssd1 vssd1 vccd1 vccd1 _6746_/Q sky130_fd_sc_hd__dfstp_1
X_3958_ _3958_/A _3958_/B _3958_/C vssd1 vssd1 vccd1 vccd1 _3973_/A sky130_fd_sc_hd__and3_2
XFILLER_0_115_130 vssd1 vssd1 vccd1 vccd1 sky130_fd_sc_hd__fill_2
X_6677_ _6677_/CLK _6677_/D vssd1 vssd1 vccd1 vccd1 _6677_/Q sky130_fd_sc_hd__dfxtp_2
X_3889_ _3889_/A _3889_/B vssd1 vssd1 vccd1 vccd1 _3990_/B sky130_fd_sc_hd__xor2_2
XFILLER_0_45_275 vssd1 vssd1 vccd1 vccd1 sky130_fd_sc_hd__decap_4
XFILLER_0_60_223 vssd1 vssd1 vccd1 vccd1 sky130_fd_sc_hd__fill_2
X_5628_ _5617_/X _5621_/D _5621_/C vssd1 vssd1 vccd1 vccd1 _5628_/Y sky130_fd_sc_hd__a21oi_1
XFILLER_0_130_111 vssd1 vssd1 vccd1 vccd1 sky130_fd_sc_hd__decap_3
X_5559_ _5599_/A _5559_/B _5588_/C vssd1 vssd1 vccd1 vccd1 _5559_/X sky130_fd_sc_hd__and3_1
XANTENNA__4828__A _4842_/A vssd1 vssd1 vccd1 vccd1 sky130_fd_sc_hd__diode_2
XANTENNA__4266__C _4971_/B vssd1 vssd1 vccd1 vccd1 sky130_fd_sc_hd__diode_2
XFILLER_0_68_334 vssd1 vssd1 vccd1 vccd1 sky130_fd_sc_hd__decap_3
XPHY_40 vssd1 vssd1 vccd1 vccd1 sky130_fd_sc_hd__decap_3
XFILLER_0_95_175 vssd1 vssd1 vccd1 vccd1 sky130_fd_sc_hd__fill_1
XFILLER_0_83_315 vssd1 vssd1 vccd1 vccd1 sky130_fd_sc_hd__decap_4
XPHY_51 vssd1 vssd1 vccd1 vccd1 sky130_fd_sc_hd__decap_3
XPHY_62 vssd1 vssd1 vccd1 vccd1 sky130_fd_sc_hd__decap_3
XPHY_73 vssd1 vssd1 vccd1 vccd1 sky130_fd_sc_hd__decap_3
XFILLER_0_126_406 vssd1 vssd1 vccd1 vccd1 sky130_fd_sc_hd__fill_1
XPHY_84 vssd1 vssd1 vccd1 vccd1 sky130_fd_sc_hd__decap_3
XPHY_95 vssd1 vssd1 vccd1 vccd1 sky130_fd_sc_hd__decap_3
XFILLER_0_36_231 vssd1 vssd1 vccd1 vccd1 sky130_fd_sc_hd__decap_4
XFILLER_0_121_133 vssd1 vssd1 vccd1 vccd1 sky130_fd_sc_hd__fill_2
XFILLER_0_106_185 vssd1 vssd1 vccd1 vccd1 sky130_fd_sc_hd__fill_2
XANTENNA__4190__A1 _5801_/A vssd1 vssd1 vccd1 vccd1 sky130_fd_sc_hd__diode_2
XANTENNA__4190__B2 _5787_/A vssd1 vssd1 vccd1 vccd1 sky130_fd_sc_hd__diode_2
XFILLER_0_47_14 vssd1 vssd1 vccd1 vccd1 sky130_fd_sc_hd__decap_3
XANTENNA__4738__A _4944_/B vssd1 vssd1 vccd1 vccd1 sky130_fd_sc_hd__diode_2
XANTENNA__6219__B1 _6224_/B vssd1 vssd1 vccd1 vccd1 sky130_fd_sc_hd__diode_2
XFILLER_0_2_27 vssd1 vssd1 vccd1 vccd1 sky130_fd_sc_hd__fill_1
XFILLER_0_63_57 vssd1 vssd1 vccd1 vccd1 sky130_fd_sc_hd__fill_1
X_4930_ _6640_/Q _4931_/B vssd1 vssd1 vccd1 vccd1 _4932_/A sky130_fd_sc_hd__and2_1
XFILLER_0_74_315 vssd1 vssd1 vccd1 vccd1 sky130_fd_sc_hd__fill_1
X_4861_ _4859_/A _4859_/B _4859_/C vssd1 vssd1 vccd1 vccd1 _4862_/C sky130_fd_sc_hd__a21o_1
XFILLER_0_59_389 vssd1 vssd1 vccd1 vccd1 sky130_fd_sc_hd__decap_3
XFILLER_0_129_277 vssd1 vssd1 vccd1 vccd1 sky130_fd_sc_hd__decap_3
X_6600_ _6802_/CLK _6600_/D fanout143/X vssd1 vssd1 vccd1 vccd1 tex_mport_o[43] sky130_fd_sc_hd__dfrtp_4
X_3812_ _3813_/A _3813_/B _3813_/C vssd1 vssd1 vccd1 vccd1 _3835_/B sky130_fd_sc_hd__o21a_1
XANTENNA_38 sstream_i[15] vssd1 vssd1 vccd1 vccd1 sky130_fd_sc_hd__diode_2
XANTENNA_27 sstream_i[13] vssd1 vssd1 vccd1 vccd1 sky130_fd_sc_hd__diode_2
XANTENNA_16 sstream_i[11] vssd1 vssd1 vccd1 vccd1 sky130_fd_sc_hd__diode_2
XFILLER_0_103_52 vssd1 vssd1 vccd1 vccd1 sky130_fd_sc_hd__fill_2
XFILLER_0_27_253 vssd1 vssd1 vccd1 vccd1 sky130_fd_sc_hd__fill_2
X_4792_ _4792_/A _4792_/B vssd1 vssd1 vccd1 vccd1 _4802_/A sky130_fd_sc_hd__xnor2_1
XANTENNA_49 sstream_i[17] vssd1 vssd1 vccd1 vccd1 sky130_fd_sc_hd__diode_2
X_6531_ _6841_/CLK _6531_/D vssd1 vssd1 vccd1 vccd1 hold21/A sky130_fd_sc_hd__dfxtp_1
X_3743_ _5051_/A _5272_/B _3741_/B _3739_/X vssd1 vssd1 vccd1 vccd1 _3751_/B sky130_fd_sc_hd__a31o_1
XFILLER_0_42_201 vssd1 vssd1 vccd1 vccd1 sky130_fd_sc_hd__fill_2
X_6462_ hold219/X sstream_i[20] _6472_/S vssd1 vssd1 vccd1 vccd1 _6853_/D sky130_fd_sc_hd__mux2_1
XFILLER_0_103_96 vssd1 vssd1 vccd1 vccd1 sky130_fd_sc_hd__fill_2
XANTENNA__6727__SET_B fanout145/X vssd1 vssd1 vccd1 vccd1 sky130_fd_sc_hd__diode_2
XFILLER_0_12_83 vssd1 vssd1 vccd1 vccd1 sky130_fd_sc_hd__fill_1
XFILLER_0_6_169 vssd1 vssd1 vccd1 vccd1 sky130_fd_sc_hd__decap_3
X_3674_ _3675_/A _3675_/B _3675_/C vssd1 vssd1 vccd1 vccd1 _3687_/A sky130_fd_sc_hd__o21ai_4
X_6393_ _6393_/A _6393_/B vssd1 vssd1 vccd1 vccd1 _6393_/Y sky130_fd_sc_hd__xnor2_1
X_5413_ _6739_/Q _5355_/A _5355_/B _5411_/Y _5412_/X vssd1 vssd1 vccd1 vccd1 _5413_/X
+ sky130_fd_sc_hd__o32a_1
XFILLER_0_88_76 vssd1 vssd1 vccd1 vccd1 sky130_fd_sc_hd__fill_1
X_5344_ _5425_/A _5425_/B _5425_/C vssd1 vssd1 vccd1 vccd1 _5428_/B sky130_fd_sc_hd__a21o_2
X_5275_ _5273_/X _5274_/X _5275_/S vssd1 vssd1 vccd1 vccd1 _5279_/A sky130_fd_sc_hd__mux2_1
X_4226_ _4232_/A _4232_/B vssd1 vssd1 vccd1 vccd1 _4226_/X sky130_fd_sc_hd__or2_1
XFILLER_0_10_197 vssd1 vssd1 vccd1 vccd1 sky130_fd_sc_hd__fill_2
XFILLER_0_49_3 vssd1 vssd1 vccd1 vccd1 sky130_fd_sc_hd__decap_3
X_4157_ _4942_/A _4774_/B _4776_/A _4942_/B vssd1 vssd1 vccd1 vccd1 _4158_/C sky130_fd_sc_hd__a22o_1
X_4088_ _4088_/A _4297_/A vssd1 vssd1 vccd1 vccd1 _4243_/A sky130_fd_sc_hd__nand2_2
XFILLER_0_69_109 vssd1 vssd1 vccd1 vccd1 sky130_fd_sc_hd__decap_3
XANTENNA__6074__S _6315_/S vssd1 vssd1 vccd1 vccd1 sky130_fd_sc_hd__diode_2
XFILLER_0_77_120 vssd1 vssd1 vccd1 vccd1 sky130_fd_sc_hd__fill_2
XFILLER_0_77_142 vssd1 vssd1 vccd1 vccd1 sky130_fd_sc_hd__decap_4
XFILLER_0_65_315 vssd1 vssd1 vccd1 vccd1 sky130_fd_sc_hd__fill_2
XANTENNA__4814__C _5118_/B vssd1 vssd1 vccd1 vccd1 sky130_fd_sc_hd__diode_2
XFILLER_0_92_167 vssd1 vssd1 vccd1 vccd1 sky130_fd_sc_hd__fill_2
XFILLER_0_135_269 vssd1 vssd1 vccd1 vccd1 sky130_fd_sc_hd__fill_2
X_6729_ _6802_/CLK _6729_/D fanout142/X vssd1 vssd1 vccd1 vccd1 _6729_/Q sky130_fd_sc_hd__dfstp_1
XFILLER_0_92_189 vssd1 vssd1 vccd1 vccd1 sky130_fd_sc_hd__fill_2
XFILLER_0_103_111 vssd1 vssd1 vccd1 vccd1 sky130_fd_sc_hd__fill_1
XFILLER_0_5_191 vssd1 vssd1 vccd1 vccd1 sky130_fd_sc_hd__fill_1
XFILLER_0_5_180 vssd1 vssd1 vccd1 vccd1 sky130_fd_sc_hd__fill_2
XANTENNA__4172__A1 _4842_/A vssd1 vssd1 vccd1 vccd1 sky130_fd_sc_hd__diode_2
XANTENNA__4172__B2 _4966_/A vssd1 vssd1 vccd1 vccd1 sky130_fd_sc_hd__diode_2
XANTENNA__4475__A2 _4518_/D vssd1 vssd1 vccd1 vccd1 sky130_fd_sc_hd__diode_2
XFILLER_0_33_16 vssd1 vssd1 vccd1 vccd1 sky130_fd_sc_hd__fill_2
XFILLER_0_56_304 vssd1 vssd1 vccd1 vccd1 sky130_fd_sc_hd__fill_2
XFILLER_0_68_197 vssd1 vssd1 vccd1 vccd1 sky130_fd_sc_hd__fill_2
XFILLER_0_56_348 vssd1 vssd1 vccd1 vccd1 sky130_fd_sc_hd__fill_1
XFILLER_0_83_156 vssd1 vssd1 vccd1 vccd1 sky130_fd_sc_hd__decap_3
XFILLER_0_56_359 vssd1 vssd1 vccd1 vccd1 sky130_fd_sc_hd__decap_4
XANTENNA__5836__B _5919_/B vssd1 vssd1 vccd1 vccd1 sky130_fd_sc_hd__diode_2
XANTENNA__4740__B _5687_/B vssd1 vssd1 vccd1 vccd1 sky130_fd_sc_hd__diode_2
XFILLER_0_116_7 vssd1 vssd1 vccd1 vccd1 sky130_fd_sc_hd__fill_2
X_3390_ _3390_/A _3390_/B vssd1 vssd1 vccd1 vccd1 _3673_/A sky130_fd_sc_hd__or2_1
XANTENNA__4468__A _4942_/A vssd1 vssd1 vccd1 vccd1 sky130_fd_sc_hd__diode_2
X_5060_ _5101_/B _5058_/C _5058_/A vssd1 vssd1 vccd1 vccd1 _5061_/C sky130_fd_sc_hd__a21o_1
XANTENNA__5663__A1 _5796_/A vssd1 vssd1 vccd1 vccd1 sky130_fd_sc_hd__diode_2
XANTENNA__5998__S _6037_/S vssd1 vssd1 vccd1 vccd1 sky130_fd_sc_hd__diode_2
X_4011_ _3927_/Y _3940_/X _3996_/A _3996_/Y vssd1 vssd1 vccd1 vccd1 _4013_/C sky130_fd_sc_hd__o211a_1
XANTENNA__5299__A _5299_/A vssd1 vssd1 vccd1 vccd1 sky130_fd_sc_hd__diode_2
X_5962_ _5962_/A _5962_/B _5962_/C _5942_/X vssd1 vssd1 vccd1 vccd1 _5964_/C sky130_fd_sc_hd__or4b_1
XFILLER_0_90_33 vssd1 vssd1 vccd1 vccd1 sky130_fd_sc_hd__fill_1
X_4913_ _6638_/Q _4913_/B vssd1 vssd1 vccd1 vccd1 _4914_/B sky130_fd_sc_hd__or2_1
XFILLER_0_74_112 vssd1 vssd1 vccd1 vccd1 sky130_fd_sc_hd__decap_3
X_5893_ _5434_/X _5892_/Y _5922_/S vssd1 vssd1 vccd1 vccd1 _5893_/X sky130_fd_sc_hd__mux2_1
X_4844_ _4844_/A _4844_/B _4844_/C vssd1 vssd1 vccd1 vccd1 _4859_/A sky130_fd_sc_hd__nand3_1
XFILLER_0_74_189 vssd1 vssd1 vccd1 vccd1 sky130_fd_sc_hd__decap_4
XFILLER_0_74_167 vssd1 vssd1 vccd1 vccd1 sky130_fd_sc_hd__decap_3
X_4775_ _5115_/C _4958_/B _4814_/D _4774_/B vssd1 vssd1 vccd1 vccd1 _4776_/D sky130_fd_sc_hd__a22o_1
XFILLER_0_132_217 vssd1 vssd1 vccd1 vccd1 sky130_fd_sc_hd__fill_1
XFILLER_0_99_53 vssd1 vssd1 vccd1 vccd1 sky130_fd_sc_hd__decap_3
X_6514_ _6834_/CLK _6514_/D vssd1 vssd1 vccd1 vccd1 _6514_/Q sky130_fd_sc_hd__dfxtp_1
XFILLER_0_15_223 vssd1 vssd1 vccd1 vccd1 sky130_fd_sc_hd__fill_1
XFILLER_0_15_212 vssd1 vssd1 vccd1 vccd1 sky130_fd_sc_hd__decap_8
XANTENNA_fanout122_A _5787_/B vssd1 vssd1 vccd1 vccd1 sky130_fd_sc_hd__diode_2
X_3726_ _3716_/A _3718_/B _3716_/B vssd1 vssd1 vccd1 vccd1 _3729_/B sky130_fd_sc_hd__a21bo_1
Xclkbuf_leaf_23_clk_i _6684_/CLK vssd1 vssd1 vccd1 vccd1 _6693_/CLK sky130_fd_sc_hd__clkbuf_16
XANTENNA__3748__A2_N _5276_/B vssd1 vssd1 vccd1 vccd1 sky130_fd_sc_hd__diode_2
XFILLER_0_130_94 vssd1 vssd1 vccd1 vccd1 sky130_fd_sc_hd__fill_2
X_6445_ hold118/X sstream_i[3] _6464_/S vssd1 vssd1 vccd1 vccd1 _6836_/D sky130_fd_sc_hd__mux2_1
XANTENNA__5762__A _5784_/S vssd1 vssd1 vccd1 vccd1 sky130_fd_sc_hd__diode_2
X_3657_ _3608_/X _3625_/Y _3655_/A _3654_/Y vssd1 vssd1 vccd1 vccd1 _3678_/B sky130_fd_sc_hd__a211o_1
XFILLER_0_30_226 vssd1 vssd1 vccd1 vccd1 sky130_fd_sc_hd__decap_3
X_6376_ _6376_/A _6376_/B vssd1 vssd1 vccd1 vccd1 _6383_/B sky130_fd_sc_hd__xnor2_1
XFILLER_0_100_125 vssd1 vssd1 vccd1 vccd1 sky130_fd_sc_hd__decap_3
X_3588_ _3588_/A _3588_/B vssd1 vssd1 vccd1 vccd1 _3589_/B sky130_fd_sc_hd__nor2_1
XANTENNA__6069__S _6072_/S vssd1 vssd1 vccd1 vccd1 sky130_fd_sc_hd__diode_2
X_5327_ _5327_/A _6692_/Q vssd1 vssd1 vccd1 vccd1 _5328_/B sky130_fd_sc_hd__nand2_1
XANTENNA__3282__A _6876_/Q vssd1 vssd1 vccd1 vccd1 sky130_fd_sc_hd__diode_2
XANTENNA__4809__C _4966_/A vssd1 vssd1 vccd1 vccd1 sky130_fd_sc_hd__diode_2
XANTENNA__4097__B _4551_/D vssd1 vssd1 vccd1 vccd1 sky130_fd_sc_hd__diode_2
X_5258_ _5256_/X _5258_/B vssd1 vssd1 vccd1 vccd1 _5340_/B sky130_fd_sc_hd__nand2b_1
X_4209_ _4209_/A _4209_/B vssd1 vssd1 vccd1 vccd1 _4221_/B sky130_fd_sc_hd__xnor2_1
X_5189_ _5189_/A _5189_/B vssd1 vssd1 vccd1 vccd1 _5191_/C sky130_fd_sc_hd__nand2_1
XFILLER_0_3_81 vssd1 vssd1 vccd1 vccd1 sky130_ef_sc_hd__decap_12
XFILLER_0_65_123 vssd1 vssd1 vccd1 vccd1 sky130_fd_sc_hd__fill_2
XANTENNA__5937__A _5937_/A vssd1 vssd1 vccd1 vccd1 sky130_fd_sc_hd__diode_2
XANTENNA__4841__A _5801_/A vssd1 vssd1 vccd1 vccd1 sky130_fd_sc_hd__diode_2
XANTENNA_fanout1_A _5601_/S vssd1 vssd1 vccd1 vccd1 sky130_fd_sc_hd__diode_2
XFILLER_0_80_104 vssd1 vssd1 vccd1 vccd1 sky130_fd_sc_hd__fill_2
XFILLER_0_65_167 vssd1 vssd1 vccd1 vccd1 sky130_fd_sc_hd__fill_1
XANTENNA__5590__A0 _5447_/X vssd1 vssd1 vccd1 vccd1 sky130_fd_sc_hd__diode_2
XFILLER_0_61_362 vssd1 vssd1 vccd1 vccd1 sky130_fd_sc_hd__fill_2
XFILLER_0_0_109 vssd1 vssd1 vccd1 vccd1 sky130_fd_sc_hd__decap_3
XFILLER_0_21_237 vssd1 vssd1 vccd1 vccd1 sky130_fd_sc_hd__fill_1
XFILLER_0_21_248 vssd1 vssd1 vccd1 vccd1 sky130_fd_sc_hd__fill_1
XFILLER_0_28_16 vssd1 vssd1 vccd1 vccd1 sky130_fd_sc_hd__decap_8
XFILLER_0_28_38 vssd1 vssd1 vccd1 vccd1 sky130_fd_sc_hd__fill_2
XANTENNA__4448__A2 _4518_/D vssd1 vssd1 vccd1 vccd1 sky130_fd_sc_hd__diode_2
XFILLER_0_135_28 vssd1 vssd1 vccd1 vccd1 sky130_fd_sc_hd__fill_2
XFILLER_0_88_204 vssd1 vssd1 vccd1 vccd1 sky130_fd_sc_hd__fill_2
XFILLER_0_88_226 vssd1 vssd1 vccd1 vccd1 sky130_fd_sc_hd__fill_1
XFILLER_0_44_37 vssd1 vssd1 vccd1 vccd1 sky130_fd_sc_hd__fill_2
XFILLER_0_44_48 vssd1 vssd1 vccd1 vccd1 sky130_fd_sc_hd__fill_1
XANTENNA__4173__D _4822_/B vssd1 vssd1 vccd1 vccd1 sky130_fd_sc_hd__diode_2
XFILLER_0_56_112 vssd1 vssd1 vccd1 vccd1 sky130_fd_sc_hd__fill_2
XTAP_1182 vssd1 vccd1 sky130_fd_sc_hd__tapvpwrvgnd_1
XTAP_1171 vssd1 vccd1 sky130_fd_sc_hd__tapvpwrvgnd_1
XTAP_1160 vssd1 vccd1 sky130_fd_sc_hd__tapvpwrvgnd_1
XFILLER_0_29_359 vssd1 vssd1 vccd1 vccd1 sky130_fd_sc_hd__fill_1
XTAP_1193 vssd1 vccd1 sky130_fd_sc_hd__tapvpwrvgnd_1
XFILLER_0_44_307 vssd1 vssd1 vccd1 vccd1 sky130_fd_sc_hd__fill_1
XFILLER_0_56_189 vssd1 vssd1 vccd1 vccd1 sky130_fd_sc_hd__fill_1
XFILLER_0_114_217 vssd1 vssd1 vccd1 vccd1 sky130_fd_sc_hd__fill_2
X_4560_ _4522_/A _4522_/C _4522_/B vssd1 vssd1 vccd1 vccd1 _4568_/B sky130_fd_sc_hd__a21oi_1
XFILLER_0_8_15 vssd1 vssd1 vccd1 vccd1 sky130_ef_sc_hd__decap_12
X_4491_ _6630_/Q _4491_/B vssd1 vssd1 vccd1 vccd1 _4492_/B sky130_fd_sc_hd__nor2_1
XFILLER_0_69_34 vssd1 vssd1 vccd1 vccd1 sky130_fd_sc_hd__decap_3
XANTENNA__3517__D _5277_/B vssd1 vssd1 vccd1 vccd1 sky130_fd_sc_hd__diode_2
X_3511_ _5273_/A _5272_/A _5300_/B _5273_/B vssd1 vssd1 vccd1 vccd1 _3513_/C sky130_fd_sc_hd__and4_1
X_6230_ depth_mport_o[64] _6441_/B _6229_/X depth_mport_i[32] vssd1 vssd1 vccd1 vccd1
+ _6781_/D sky130_fd_sc_hd__o22a_1
XFILLER_0_122_283 vssd1 vssd1 vccd1 vccd1 sky130_fd_sc_hd__fill_1
XFILLER_0_69_78 vssd1 vssd1 vccd1 vccd1 sky130_fd_sc_hd__decap_4
X_3442_ _3442_/A _3442_/B vssd1 vssd1 vccd1 vccd1 _3444_/B sky130_fd_sc_hd__xor2_1
X_6161_ fb_i _6161_/B vssd1 vssd1 vccd1 vccd1 _6162_/B sky130_fd_sc_hd__or2_1
XTAP_900 vssd1 vccd1 sky130_fd_sc_hd__tapvpwrvgnd_1
X_3373_ _3373_/A _3373_/B vssd1 vssd1 vccd1 vccd1 _3375_/B sky130_fd_sc_hd__xor2_1
XTAP_944 vssd1 vccd1 sky130_fd_sc_hd__tapvpwrvgnd_1
XTAP_933 vssd1 vccd1 sky130_fd_sc_hd__tapvpwrvgnd_1
XTAP_922 vssd1 vccd1 sky130_fd_sc_hd__tapvpwrvgnd_1
XTAP_911 vssd1 vccd1 sky130_fd_sc_hd__tapvpwrvgnd_1
X_5112_ _5112_/A _5112_/B vssd1 vssd1 vccd1 vccd1 _5114_/B sky130_fd_sc_hd__xnor2_2
X_6092_ hold192/X _6730_/Q _6098_/S vssd1 vssd1 vccd1 vccd1 _6092_/X sky130_fd_sc_hd__mux2_1
XTAP_977 vssd1 vccd1 sky130_fd_sc_hd__tapvpwrvgnd_1
XTAP_966 vssd1 vccd1 sky130_fd_sc_hd__tapvpwrvgnd_1
XTAP_955 vssd1 vccd1 sky130_fd_sc_hd__tapvpwrvgnd_1
XFILLER_0_40_7 vssd1 vssd1 vccd1 vccd1 sky130_fd_sc_hd__fill_2
XTAP_999 vssd1 vccd1 sky130_fd_sc_hd__tapvpwrvgnd_1
XTAP_988 vssd1 vccd1 sky130_fd_sc_hd__tapvpwrvgnd_1
XFILLER_0_18_71 vssd1 vssd1 vccd1 vccd1 sky130_fd_sc_hd__decap_3
X_5043_ _5354_/A _5039_/B _5041_/X _5042_/Y _5000_/Y vssd1 vssd1 vccd1 vccd1 _5425_/B
+ sky130_fd_sc_hd__o311a_1
XFILLER_0_87_281 vssd1 vssd1 vccd1 vccd1 sky130_fd_sc_hd__decap_4
X_5945_ tex_height_i[12] _5945_/B vssd1 vssd1 vccd1 vccd1 _5962_/C sky130_fd_sc_hd__nor2_1
X_5876_ _5876_/A _5876_/B vssd1 vssd1 vccd1 vccd1 _5878_/A sky130_fd_sc_hd__nand2_1
X_4827_ _4971_/D _5787_/B vssd1 vssd1 vccd1 vccd1 _4830_/A sky130_fd_sc_hd__and2_1
XFILLER_0_62_104 vssd1 vssd1 vccd1 vccd1 sky130_fd_sc_hd__fill_2
XANTENNA__4375__A1 _5687_/A vssd1 vssd1 vccd1 vccd1 sky130_fd_sc_hd__diode_2
XFILLER_0_7_275 vssd1 vssd1 vccd1 vccd1 sky130_fd_sc_hd__fill_2
XANTENNA__4375__B2 _5701_/A vssd1 vssd1 vccd1 vccd1 sky130_fd_sc_hd__diode_2
XFILLER_0_7_286 vssd1 vssd1 vccd1 vccd1 sky130_fd_sc_hd__fill_2
XANTENNA__3708__C _5115_/C vssd1 vssd1 vccd1 vccd1 sky130_fd_sc_hd__diode_2
X_4758_ _4758_/A _4758_/B vssd1 vssd1 vccd1 vccd1 _4760_/B sky130_fd_sc_hd__xnor2_1
X_4689_ _4689_/A _4689_/B _5370_/A vssd1 vssd1 vccd1 vccd1 _5375_/B sky130_fd_sc_hd__or3b_1
X_3709_ _5801_/A _5115_/C _5115_/D _4832_/C vssd1 vssd1 vccd1 vccd1 _3710_/D sky130_fd_sc_hd__a22o_1
XFILLER_0_43_384 vssd1 vssd1 vccd1 vccd1 sky130_fd_sc_hd__decap_8
X_6428_ _6427_/A _6427_/B _6427_/C vssd1 vssd1 vccd1 vccd1 _6428_/Y sky130_fd_sc_hd__a21oi_1
XFILLER_0_70_192 vssd1 vssd1 vccd1 vccd1 sky130_fd_sc_hd__fill_2
XANTENNA__5324__B1 _3999_/A vssd1 vssd1 vccd1 vccd1 sky130_fd_sc_hd__diode_2
X_6359_ _6368_/S _6356_/X _6348_/A _6349_/Y vssd1 vssd1 vccd1 vccd1 _6369_/A sky130_fd_sc_hd__a211o_1
XPHY_210 vssd1 vssd1 vccd1 vccd1 sky130_fd_sc_hd__decap_3
XFILLER_0_85_229 vssd1 vssd1 vccd1 vccd1 sky130_fd_sc_hd__fill_1
XFILLER_0_14_29 vssd1 vssd1 vccd1 vccd1 sky130_ef_sc_hd__decap_12
XPHY_243 vssd1 vssd1 vccd1 vccd1 sky130_fd_sc_hd__decap_3
XPHY_232 vssd1 vssd1 vccd1 vccd1 sky130_fd_sc_hd__decap_3
XPHY_221 vssd1 vssd1 vccd1 vccd1 sky130_fd_sc_hd__decap_3
XPHY_276 vssd1 vssd1 vccd1 vccd1 sky130_fd_sc_hd__decap_3
XANTENNA_clkbuf_leaf_6_clk_i_A clkbuf_leaf_9_clk_i/A vssd1 vssd1 vccd1 vccd1 sky130_fd_sc_hd__diode_2
XPHY_265 vssd1 vssd1 vccd1 vccd1 sky130_fd_sc_hd__decap_3
XPHY_254 vssd1 vssd1 vccd1 vccd1 sky130_fd_sc_hd__decap_3
XFILLER_0_38_156 vssd1 vssd1 vccd1 vccd1 sky130_fd_sc_hd__fill_2
XFILLER_0_136_353 vssd1 vssd1 vccd1 vccd1 sky130_fd_sc_hd__fill_2
XANTENNA__4290__B _5115_/D vssd1 vssd1 vccd1 vccd1 sky130_fd_sc_hd__diode_2
XFILLER_0_53_126 vssd1 vssd1 vccd1 vccd1 sky130_fd_sc_hd__decap_3
XFILLER_0_53_137 vssd1 vssd1 vccd1 vccd1 sky130_fd_sc_hd__fill_2
XFILLER_0_34_362 vssd1 vssd1 vccd1 vccd1 sky130_fd_sc_hd__fill_2
XFILLER_0_61_181 vssd1 vssd1 vccd1 vccd1 sky130_fd_sc_hd__fill_2
XFILLER_0_39_48 vssd1 vssd1 vccd1 vccd1 sky130_fd_sc_hd__fill_2
XANTENNA__5618__A1 _5787_/A vssd1 vssd1 vccd1 vccd1 sky130_fd_sc_hd__diode_2
XANTENNA__3341__A2 _5064_/B vssd1 vssd1 vccd1 vccd1 sky130_fd_sc_hd__diode_2
Xhold3 hold3/A vssd1 vssd1 vccd1 vccd1 hold3/X sky130_fd_sc_hd__dlygate4sd3_1
XANTENNA__5618__B2 _5787_/B vssd1 vssd1 vccd1 vccd1 sky130_fd_sc_hd__diode_2
XANTENNA__3629__B1 _5118_/B vssd1 vssd1 vccd1 vccd1 sky130_fd_sc_hd__diode_2
XANTENNA__4746__A _4794_/B vssd1 vssd1 vccd1 vccd1 sky130_fd_sc_hd__diode_2
XANTENNA__6043__A1 _5272_/B vssd1 vssd1 vccd1 vccd1 sky130_fd_sc_hd__diode_2
XFILLER_0_69_281 vssd1 vssd1 vccd1 vccd1 sky130_fd_sc_hd__fill_2
XFILLER_0_69_270 vssd1 vssd1 vccd1 vccd1 sky130_fd_sc_hd__fill_2
X_3991_ _3992_/A _3992_/B _3992_/C vssd1 vssd1 vccd1 vccd1 _4004_/A sky130_fd_sc_hd__o21ai_4
X_5730_ hold285/X _5729_/Y _5844_/S vssd1 vssd1 vccd1 vccd1 _6629_/D sky130_fd_sc_hd__mux2_1
XFILLER_0_71_68 vssd1 vssd1 vccd1 vccd1 sky130_fd_sc_hd__fill_1
XFILLER_0_29_134 vssd1 vssd1 vccd1 vccd1 sky130_fd_sc_hd__fill_2
XANTENNA__5296__B _5296_/B vssd1 vssd1 vccd1 vccd1 sky130_fd_sc_hd__diode_2
X_5661_ tex_addr_i[0] _5640_/B _5650_/B _5648_/Y vssd1 vssd1 vccd1 vccd1 _5662_/B
+ sky130_fd_sc_hd__a31oi_2
X_5592_ tex_mport_o[56] _5576_/S _5591_/X _5588_/C vssd1 vssd1 vccd1 vccd1 _6613_/D
+ sky130_fd_sc_hd__a22o_1
X_4612_ _4612_/A _4612_/B vssd1 vssd1 vccd1 vccd1 _4635_/A sky130_fd_sc_hd__nand2_1
XFILLER_0_4_223 vssd1 vssd1 vccd1 vccd1 sky130_fd_sc_hd__fill_1
XFILLER_0_44_159 vssd1 vssd1 vccd1 vccd1 sky130_fd_sc_hd__fill_2
XANTENNA_hold60_A hold60/A vssd1 vssd1 vccd1 vccd1 sky130_fd_sc_hd__diode_2
X_4543_ _4498_/Y _4510_/X _4541_/A _4541_/Y vssd1 vssd1 vccd1 vccd1 _4543_/X sky130_fd_sc_hd__o211a_1
XFILLER_0_25_384 vssd1 vssd1 vccd1 vccd1 sky130_fd_sc_hd__decap_8
XFILLER_0_20_72 vssd1 vssd1 vccd1 vccd1 sky130_fd_sc_hd__decap_3
X_6213_ _6212_/B _6212_/C _6212_/A vssd1 vssd1 vccd1 vccd1 _6213_/Y sky130_fd_sc_hd__o21ai_1
X_4474_ _5656_/A _4551_/D vssd1 vssd1 vccd1 vccd1 _4478_/A sky130_fd_sc_hd__nand2_1
XFILLER_0_110_253 vssd1 vssd1 vccd1 vccd1 sky130_fd_sc_hd__fill_1
X_3425_ _3425_/A _3425_/B vssd1 vssd1 vccd1 vccd1 _3579_/A sky130_fd_sc_hd__or2_1
X_6144_ _6136_/D _6136_/Y _6143_/Y vssd1 vssd1 vccd1 vccd1 _6152_/B sky130_fd_sc_hd__a21o_1
XTAP_752 vssd1 vccd1 sky130_fd_sc_hd__tapvpwrvgnd_1
XTAP_741 vssd1 vccd1 sky130_fd_sc_hd__tapvpwrvgnd_1
XTAP_730 vssd1 vccd1 sky130_fd_sc_hd__tapvpwrvgnd_1
X_3356_ _3359_/D vssd1 vssd1 vccd1 vccd1 _3356_/Y sky130_fd_sc_hd__inv_2
X_6075_ hold91/X _6654_/Q _6315_/S vssd1 vssd1 vccd1 vccd1 hold92/A sky130_fd_sc_hd__mux2_1
XTAP_785 vssd1 vccd1 sky130_fd_sc_hd__tapvpwrvgnd_1
XTAP_774 vssd1 vccd1 sky130_fd_sc_hd__tapvpwrvgnd_1
XTAP_763 vssd1 vccd1 sky130_fd_sc_hd__tapvpwrvgnd_1
X_3287_ tex_height_i[6] vssd1 vssd1 vccd1 vccd1 _5951_/B sky130_fd_sc_hd__inv_2
XTAP_796 vssd1 vccd1 sky130_fd_sc_hd__tapvpwrvgnd_1
X_5026_ _5020_/A _5021_/X _5012_/Y _5014_/X vssd1 vssd1 vccd1 vccd1 _5026_/Y sky130_fd_sc_hd__a211oi_1
XFILLER_0_31_3 vssd1 vssd1 vccd1 vccd1 sky130_fd_sc_hd__decap_3
X_6977_ vssd1 vssd1 vccd1 vccd1 _6977_/HI tex_mport_o[30] sky130_fd_sc_hd__conb_1
XFILLER_0_67_229 vssd1 vssd1 vccd1 vccd1 sky130_fd_sc_hd__fill_2
X_5928_ hold100/X tex_mport_i[3] _5932_/S vssd1 vssd1 vccd1 vccd1 _6656_/D sky130_fd_sc_hd__mux2_1
XANTENNA__6082__S _6098_/S vssd1 vssd1 vccd1 vccd1 sky130_fd_sc_hd__diode_2
XANTENNA__6337__A2 _6440_/B vssd1 vssd1 vccd1 vccd1 sky130_fd_sc_hd__diode_2
XFILLER_0_118_353 vssd1 vssd1 vccd1 vccd1 sky130_fd_sc_hd__fill_2
XFILLER_0_35_126 vssd1 vssd1 vccd1 vccd1 sky130_fd_sc_hd__fill_2
X_5859_ _5863_/D _5859_/B vssd1 vssd1 vccd1 vccd1 _5859_/Y sky130_fd_sc_hd__xnor2_1
XFILLER_0_133_334 vssd1 vssd1 vccd1 vccd1 sky130_fd_sc_hd__fill_2
XFILLER_0_16_340 vssd1 vssd1 vccd1 vccd1 sky130_fd_sc_hd__fill_2
XFILLER_0_133_378 vssd1 vssd1 vccd1 vccd1 sky130_ef_sc_hd__decap_12
XANTENNA__3571__A2 _5300_/A vssd1 vssd1 vccd1 vccd1 sky130_fd_sc_hd__diode_2
XFILLER_0_31_321 vssd1 vssd1 vccd1 vccd1 sky130_fd_sc_hd__decap_4
XFILLER_0_31_354 vssd1 vssd1 vccd1 vccd1 sky130_fd_sc_hd__fill_2
XANTENNA__4823__A2 _4966_/A vssd1 vssd1 vccd1 vccd1 sky130_fd_sc_hd__diode_2
XFILLER_0_98_365 vssd1 vssd1 vccd1 vccd1 sky130_fd_sc_hd__fill_2
XANTENNA__4716__D _4944_/B vssd1 vssd1 vccd1 vccd1 sky130_fd_sc_hd__diode_2
XFILLER_0_66_251 vssd1 vssd1 vccd1 vccd1 sky130_fd_sc_hd__fill_1
XFILLER_0_136_183 vssd1 vssd1 vccd1 vccd1 sky130_fd_sc_hd__decap_3
XANTENNA__3348__C _5276_/A vssd1 vssd1 vccd1 vccd1 sky130_fd_sc_hd__diode_2
XFILLER_0_41_118 vssd1 vssd1 vccd1 vccd1 sky130_fd_sc_hd__fill_2
XANTENNA__3645__A _5320_/A vssd1 vssd1 vccd1 vccd1 sky130_fd_sc_hd__diode_2
XFILLER_0_22_332 vssd1 vssd1 vccd1 vccd1 sky130_fd_sc_hd__fill_1
XFILLER_0_34_192 vssd1 vssd1 vccd1 vccd1 sky130_fd_sc_hd__fill_1
XFILLER_0_5_27 vssd1 vssd1 vccd1 vccd1 sky130_ef_sc_hd__decap_12
X_4190_ _5801_/A _4527_/B _4841_/C _5787_/A vssd1 vssd1 vccd1 vccd1 _4191_/C sky130_fd_sc_hd__a22o_1
XANTENNA__4476__A _4789_/B vssd1 vssd1 vccd1 vccd1 sky130_fd_sc_hd__diode_2
X_6900_ vssd1 vssd1 vccd1 vccd1 _6900_/HI depth_mport_o[59] sky130_fd_sc_hd__conb_1
XFILLER_0_89_354 vssd1 vssd1 vccd1 vccd1 sky130_ef_sc_hd__decap_12
X_6831_ _6832_/CLK _6831_/D fanout153/X vssd1 vssd1 vccd1 vccd1 depth_mport_o[53]
+ sky130_fd_sc_hd__dfrtp_4
XANTENNA__4027__B1 _4814_/D vssd1 vssd1 vccd1 vccd1 sky130_fd_sc_hd__diode_2
XFILLER_0_106_85 vssd1 vssd1 vccd1 vccd1 sky130_fd_sc_hd__decap_3
X_6762_ _6818_/CLK _6762_/D fanout151/X vssd1 vssd1 vccd1 vccd1 pix_mport_o[34] sky130_fd_sc_hd__dfrtp_4
XFILLER_0_9_359 vssd1 vssd1 vccd1 vccd1 sky130_fd_sc_hd__fill_2
X_3974_ _3973_/A _3972_/Y _3923_/X _3941_/Y vssd1 vssd1 vccd1 vccd1 _3996_/A sky130_fd_sc_hd__o211ai_4
X_5713_ _5711_/Y _5713_/B vssd1 vssd1 vccd1 vccd1 _5715_/A sky130_fd_sc_hd__and2b_1
XFILLER_0_72_221 vssd1 vssd1 vccd1 vccd1 sky130_fd_sc_hd__fill_2
X_6693_ _6693_/CLK _6693_/D vssd1 vssd1 vccd1 vccd1 hold13/A sky130_fd_sc_hd__dfxtp_1
XFILLER_0_17_137 vssd1 vssd1 vccd1 vccd1 sky130_fd_sc_hd__fill_2
X_5644_ _5645_/A _5645_/B vssd1 vssd1 vccd1 vccd1 _5656_/B sky130_fd_sc_hd__or2_1
XFILLER_0_17_148 vssd1 vssd1 vccd1 vccd1 sky130_fd_sc_hd__fill_2
XFILLER_0_60_405 vssd1 vssd1 vccd1 vccd1 sky130_fd_sc_hd__fill_2
XFILLER_0_115_356 vssd1 vssd1 vccd1 vccd1 sky130_fd_sc_hd__fill_1
XFILLER_0_72_287 vssd1 vssd1 vccd1 vccd1 sky130_fd_sc_hd__fill_2
XFILLER_0_72_276 vssd1 vssd1 vccd1 vccd1 sky130_fd_sc_hd__fill_2
XANTENNA__5754__B _5754_/B vssd1 vssd1 vccd1 vccd1 sky130_fd_sc_hd__diode_2
Xhold200 _6552_/Q vssd1 vssd1 vccd1 vccd1 hold200/X sky130_fd_sc_hd__dlygate4sd3_1
X_5575_ tex_mport_o[42] _5598_/S _5574_/X vssd1 vssd1 vccd1 vccd1 _6599_/D sky130_fd_sc_hd__a21o_1
Xhold211 _6086_/X vssd1 vssd1 vccd1 vccd1 _6724_/D sky130_fd_sc_hd__dlygate4sd3_1
XFILLER_0_79_3 vssd1 vssd1 vccd1 vccd1 sky130_fd_sc_hd__decap_8
Xhold233 _6083_/X vssd1 vssd1 vccd1 vccd1 _6721_/D sky130_fd_sc_hd__dlygate4sd3_1
X_4526_ _5718_/B _4527_/B _4536_/A _4527_/D vssd1 vssd1 vccd1 vccd1 _4573_/A sky130_fd_sc_hd__and4_1
Xhold244 _6735_/Q vssd1 vssd1 vccd1 vccd1 hold244/X sky130_fd_sc_hd__dlygate4sd3_1
XFILLER_0_13_376 vssd1 vssd1 vccd1 vccd1 sky130_fd_sc_hd__decap_3
XFILLER_0_13_365 vssd1 vssd1 vccd1 vccd1 sky130_fd_sc_hd__fill_2
Xhold222 _6099_/X vssd1 vssd1 vccd1 vccd1 _6737_/D sky130_fd_sc_hd__dlygate4sd3_1
Xhold266 _6723_/Q vssd1 vssd1 vccd1 vccd1 hold266/X sky130_fd_sc_hd__dlygate4sd3_1
X_4457_ _4457_/A _4457_/B _4457_/C vssd1 vssd1 vccd1 vccd1 _4457_/Y sky130_fd_sc_hd__nand3_2
XFILLER_0_40_195 vssd1 vssd1 vccd1 vccd1 sky130_fd_sc_hd__fill_1
Xhold277 _6642_/Q vssd1 vssd1 vccd1 vccd1 hold277/X sky130_fd_sc_hd__dlygate4sd3_1
Xhold255 _6102_/X vssd1 vssd1 vccd1 vccd1 _6740_/D sky130_fd_sc_hd__dlygate4sd3_1
XFILLER_0_0_281 vssd1 vssd1 vccd1 vccd1 sky130_fd_sc_hd__fill_2
Xhold299 _6681_/Q vssd1 vssd1 vccd1 vccd1 hold299/X sky130_fd_sc_hd__dlygate4sd3_1
X_3408_ _3408_/A _3689_/A vssd1 vssd1 vccd1 vccd1 _3615_/A sky130_fd_sc_hd__nand2_1
Xhold288 _6739_/Q vssd1 vssd1 vccd1 vccd1 hold288/X sky130_fd_sc_hd__dlygate4sd3_1
X_6127_ pix_mport_o[35] hold88/X _6224_/B vssd1 vssd1 vccd1 vccd1 _6763_/D sky130_fd_sc_hd__mux2_1
XANTENNA__6077__S _6315_/S vssd1 vssd1 vccd1 vccd1 sky130_fd_sc_hd__diode_2
X_4388_ _5718_/A _4816_/B _4688_/C _4658_/D vssd1 vssd1 vccd1 vccd1 _4422_/B sky130_fd_sc_hd__and4_1
XTAP_560 vssd1 vccd1 sky130_fd_sc_hd__tapvpwrvgnd_1
X_3339_ _5308_/A _5286_/A vssd1 vssd1 vccd1 vccd1 _3602_/B sky130_fd_sc_hd__nand2_1
XTAP_571 vssd1 vccd1 sky130_fd_sc_hd__tapvpwrvgnd_1
XTAP_582 vssd1 vccd1 sky130_fd_sc_hd__tapvpwrvgnd_1
XTAP_593 vssd1 vccd1 sky130_fd_sc_hd__tapvpwrvgnd_1
X_6058_ hold42/X hold60/X _6061_/S vssd1 vssd1 vccd1 vccd1 _6697_/D sky130_fd_sc_hd__mux2_1
XANTENNA__5463__C1 _6098_/S vssd1 vssd1 vccd1 vccd1 sky130_fd_sc_hd__diode_2
XANTENNA_106 sstream_i[7] vssd1 vssd1 vccd1 vccd1 sky130_fd_sc_hd__diode_2
X_5009_ _6637_/Q _5009_/B vssd1 vssd1 vccd1 vccd1 _5010_/B sky130_fd_sc_hd__or2_1
XANTENNA_117 sstream_i[9] vssd1 vssd1 vccd1 vccd1 sky130_fd_sc_hd__diode_2
XFILLER_0_95_324 vssd1 vssd1 vccd1 vccd1 sky130_fd_sc_hd__decap_3
XANTENNA_139 tex_addr_i[8] vssd1 vssd1 vccd1 vccd1 sky130_fd_sc_hd__diode_2
XANTENNA_128 tex_addr_i[14] vssd1 vssd1 vccd1 vccd1 sky130_fd_sc_hd__diode_2
XANTENNA__4833__B _5787_/B vssd1 vssd1 vccd1 vccd1 sky130_fd_sc_hd__diode_2
XFILLER_0_63_221 vssd1 vssd1 vccd1 vccd1 sky130_fd_sc_hd__decap_3
XANTENNA__5518__A0 hold185/X vssd1 vssd1 vccd1 vccd1 sky130_fd_sc_hd__diode_2
XFILLER_0_118_161 vssd1 vssd1 vccd1 vccd1 sky130_fd_sc_hd__fill_1
XFILLER_0_63_232 vssd1 vssd1 vccd1 vccd1 sky130_fd_sc_hd__fill_2
XFILLER_0_51_405 vssd1 vssd1 vccd1 vccd1 sky130_fd_sc_hd__fill_2
XFILLER_0_133_175 vssd1 vssd1 vccd1 vccd1 sky130_fd_sc_hd__fill_1
XFILLER_0_106_389 vssd1 vssd1 vccd1 vccd1 sky130_ef_sc_hd__decap_12
XFILLER_0_16_192 vssd1 vssd1 vccd1 vccd1 sky130_fd_sc_hd__fill_2
XFILLER_0_121_326 vssd1 vssd1 vccd1 vccd1 sky130_fd_sc_hd__decap_3
XANTENNA__5297__A2 _5286_/B vssd1 vssd1 vccd1 vccd1 sky130_fd_sc_hd__diode_2
XFILLER_0_52_15 vssd1 vssd1 vccd1 vccd1 sky130_fd_sc_hd__fill_2
XFILLER_0_109_172 vssd1 vssd1 vccd1 vccd1 sky130_fd_sc_hd__fill_2
XFILLER_0_54_243 vssd1 vssd1 vccd1 vccd1 sky130_fd_sc_hd__fill_1
XFILLER_0_109_194 vssd1 vssd1 vccd1 vccd1 sky130_fd_sc_hd__fill_2
XANTENNA__5574__B _5574_/B vssd1 vssd1 vccd1 vccd1 sky130_fd_sc_hd__diode_2
X_3690_ _3687_/A _3687_/B _3691_/B vssd1 vssd1 vccd1 vccd1 _3690_/X sky130_fd_sc_hd__a21o_1
XFILLER_0_54_265 vssd1 vssd1 vccd1 vccd1 sky130_fd_sc_hd__fill_1
XFILLER_0_112_304 vssd1 vssd1 vccd1 vccd1 sky130_fd_sc_hd__fill_2
XFILLER_0_112_326 vssd1 vssd1 vccd1 vccd1 sky130_fd_sc_hd__fill_1
X_5360_ _5361_/A _5361_/B vssd1 vssd1 vccd1 vccd1 _5360_/X sky130_fd_sc_hd__xor2_1
X_4311_ _4287_/B _4287_/C _4285_/Y _4264_/X vssd1 vssd1 vccd1 vccd1 _4311_/X sky130_fd_sc_hd__o2bb2a_1
XFILLER_0_77_34 vssd1 vssd1 vccd1 vccd1 sky130_fd_sc_hd__decap_4
X_5291_ _5291_/A _5291_/B vssd1 vssd1 vccd1 vccd1 _5293_/A sky130_fd_sc_hd__xnor2_1
X_4242_ _4244_/A _4244_/B vssd1 vssd1 vccd1 vccd1 _4242_/Y sky130_fd_sc_hd__nor2_1
XANTENNA__4637__C _4658_/D vssd1 vssd1 vccd1 vccd1 sky130_fd_sc_hd__diode_2
X_4173_ _4171_/X _4172_/Y _4971_/B _4822_/B vssd1 vssd1 vccd1 vccd1 _4199_/A sky130_fd_sc_hd__and4bb_1
XFILLER_0_93_55 vssd1 vssd1 vccd1 vccd1 sky130_fd_sc_hd__fill_1
XFILLER_0_26_82 vssd1 vssd1 vccd1 vccd1 sky130_fd_sc_hd__fill_2
XFILLER_0_77_346 vssd1 vssd1 vccd1 vccd1 sky130_fd_sc_hd__fill_2
XFILLER_0_77_335 vssd1 vssd1 vccd1 vccd1 sky130_fd_sc_hd__fill_1
XANTENNA_fanout152_A fanout153/X vssd1 vssd1 vccd1 vccd1 sky130_fd_sc_hd__diode_2
X_6814_ _6818_/CLK _6814_/D fanout151/X vssd1 vssd1 vccd1 vccd1 depth_mport_o[36]
+ sky130_fd_sc_hd__dfrtp_4
XFILLER_0_92_349 vssd1 vssd1 vccd1 vccd1 sky130_ef_sc_hd__decap_12
XFILLER_0_85_390 vssd1 vssd1 vccd1 vccd1 sky130_fd_sc_hd__fill_2
XFILLER_0_9_167 vssd1 vssd1 vccd1 vccd1 sky130_fd_sc_hd__fill_1
X_3957_ _3956_/B _3956_/C _3956_/A vssd1 vssd1 vccd1 vccd1 _3958_/C sky130_fd_sc_hd__a21bo_1
X_6745_ _6745_/CLK _6745_/D fanout139/X vssd1 vssd1 vccd1 vccd1 _6745_/Q sky130_fd_sc_hd__dfstp_1
XANTENNA__5765__A _5766_/A vssd1 vssd1 vccd1 vccd1 sky130_fd_sc_hd__diode_2
XFILLER_0_9_189 vssd1 vssd1 vccd1 vccd1 sky130_fd_sc_hd__decap_8
XFILLER_0_45_254 vssd1 vssd1 vccd1 vccd1 sky130_fd_sc_hd__decap_4
X_6676_ _6677_/CLK _6676_/D vssd1 vssd1 vccd1 vccd1 _6676_/Q sky130_fd_sc_hd__dfxtp_1
X_3888_ _3888_/A _3888_/B vssd1 vssd1 vccd1 vccd1 _3990_/A sky130_fd_sc_hd__or2_2
XFILLER_0_33_405 vssd1 vssd1 vccd1 vccd1 sky130_fd_sc_hd__fill_2
XFILLER_0_103_304 vssd1 vssd1 vccd1 vccd1 sky130_fd_sc_hd__decap_8
X_5627_ _5626_/A _5625_/X _5626_/C vssd1 vssd1 vccd1 vccd1 _5627_/Y sky130_fd_sc_hd__a21oi_1
X_5558_ hold71/X _5598_/S _5557_/X tex_mport_o[64] vssd1 vssd1 vccd1 vccd1 _6588_/D
+ sky130_fd_sc_hd__a2bb2o_1
XFILLER_0_103_337 vssd1 vssd1 vccd1 vccd1 sky130_fd_sc_hd__decap_4
X_4509_ _4509_/A _4509_/B vssd1 vssd1 vccd1 vccd1 _4547_/A sky130_fd_sc_hd__nand2_2
XFILLER_0_111_381 vssd1 vssd1 vccd1 vccd1 sky130_fd_sc_hd__decap_8
X_5489_ hold101/X sstream_i[80] _6450_/S vssd1 vssd1 vccd1 vccd1 _6522_/D sky130_fd_sc_hd__mux2_1
XTAP_390 vssd1 vccd1 sky130_fd_sc_hd__tapvpwrvgnd_1
XANTENNA_fanout65_A _4970_/B vssd1 vssd1 vccd1 vccd1 sky130_fd_sc_hd__diode_2
XANTENNA__4266__D _4551_/D vssd1 vssd1 vccd1 vccd1 sky130_fd_sc_hd__diode_2
XFILLER_0_138_201 vssd1 vssd1 vccd1 vccd1 sky130_fd_sc_hd__fill_1
XPHY_30 vssd1 vssd1 vccd1 vccd1 sky130_fd_sc_hd__decap_3
XFILLER_0_138_212 vssd1 vssd1 vccd1 vccd1 sky130_fd_sc_hd__fill_1
XFILLER_0_95_165 vssd1 vssd1 vccd1 vccd1 sky130_fd_sc_hd__decap_3
XFILLER_0_95_154 vssd1 vssd1 vccd1 vccd1 sky130_fd_sc_hd__decap_6
XFILLER_0_83_305 vssd1 vssd1 vccd1 vccd1 sky130_fd_sc_hd__fill_2
XPHY_41 vssd1 vssd1 vccd1 vccd1 sky130_fd_sc_hd__decap_3
XPHY_52 vssd1 vssd1 vccd1 vccd1 sky130_fd_sc_hd__decap_3
XPHY_63 vssd1 vssd1 vccd1 vccd1 sky130_fd_sc_hd__decap_3
XPHY_74 vssd1 vssd1 vccd1 vccd1 sky130_fd_sc_hd__decap_3
XFILLER_0_83_327 vssd1 vssd1 vccd1 vccd1 sky130_fd_sc_hd__decap_8
XFILLER_0_22_29 vssd1 vssd1 vccd1 vccd1 sky130_ef_sc_hd__decap_12
XPHY_85 vssd1 vssd1 vccd1 vccd1 sky130_fd_sc_hd__decap_3
XPHY_96 vssd1 vssd1 vccd1 vccd1 sky130_fd_sc_hd__decap_3
XFILLER_0_138_289 vssd1 vssd1 vccd1 vccd1 sky130_fd_sc_hd__fill_2
XFILLER_0_76_390 vssd1 vssd1 vccd1 vccd1 sky130_ef_sc_hd__decap_12
XFILLER_0_51_213 vssd1 vssd1 vccd1 vccd1 sky130_fd_sc_hd__fill_2
XFILLER_0_106_164 vssd1 vssd1 vccd1 vccd1 sky130_fd_sc_hd__fill_2
XFILLER_0_91_393 vssd1 vssd1 vccd1 vccd1 sky130_ef_sc_hd__decap_12
XFILLER_0_106_197 vssd1 vssd1 vccd1 vccd1 sky130_fd_sc_hd__fill_2
XANTENNA__4190__A2 _4527_/B vssd1 vssd1 vccd1 vccd1 sky130_fd_sc_hd__diode_2
XANTENNA__4738__B _5656_/A vssd1 vssd1 vccd1 vccd1 sky130_fd_sc_hd__diode_2
XFILLER_0_63_25 vssd1 vssd1 vccd1 vccd1 sky130_fd_sc_hd__decap_3
XFILLER_0_86_132 vssd1 vssd1 vccd1 vccd1 sky130_fd_sc_hd__fill_2
XFILLER_0_63_69 vssd1 vssd1 vccd1 vccd1 sky130_fd_sc_hd__fill_2
XFILLER_0_129_223 vssd1 vssd1 vccd1 vccd1 sky130_fd_sc_hd__fill_1
XFILLER_0_74_305 vssd1 vssd1 vccd1 vccd1 sky130_fd_sc_hd__decap_3
X_4860_ _4860_/A _4860_/B vssd1 vssd1 vccd1 vccd1 _4862_/B sky130_fd_sc_hd__xnor2_2
XFILLER_0_137_3 vssd1 vssd1 vccd1 vccd1 sky130_fd_sc_hd__decap_3
XFILLER_0_86_176 vssd1 vssd1 vccd1 vccd1 sky130_fd_sc_hd__fill_2
X_3811_ _3835_/A _3811_/B vssd1 vssd1 vccd1 vccd1 _3813_/C sky130_fd_sc_hd__nor2_1
XANTENNA_39 sstream_i[15] vssd1 vssd1 vccd1 vccd1 sky130_fd_sc_hd__diode_2
XANTENNA_28 sstream_i[13] vssd1 vssd1 vccd1 vccd1 sky130_fd_sc_hd__diode_2
XANTENNA_17 sstream_i[11] vssd1 vssd1 vccd1 vccd1 sky130_fd_sc_hd__diode_2
X_6530_ _6841_/CLK _6530_/D vssd1 vssd1 vccd1 vccd1 hold37/A sky130_fd_sc_hd__dfxtp_1
XFILLER_0_27_221 vssd1 vssd1 vccd1 vccd1 sky130_fd_sc_hd__decap_3
XFILLER_0_27_243 vssd1 vssd1 vccd1 vccd1 sky130_fd_sc_hd__decap_8
X_4791_ _5051_/B _5656_/A vssd1 vssd1 vccd1 vccd1 _4792_/B sky130_fd_sc_hd__nand2_1
XFILLER_0_15_405 vssd1 vssd1 vccd1 vccd1 sky130_fd_sc_hd__fill_2
X_3742_ _5051_/A _5272_/B vssd1 vssd1 vccd1 vccd1 _3818_/B sky130_fd_sc_hd__nand2_1
X_6461_ hold229/X sstream_i[19] _6465_/S vssd1 vssd1 vccd1 vccd1 _6852_/D sky130_fd_sc_hd__mux2_1
X_3673_ _3673_/A _3673_/B vssd1 vssd1 vccd1 vccd1 _3675_/C sky130_fd_sc_hd__xor2_2
X_6392_ _6392_/A _6392_/B vssd1 vssd1 vccd1 vccd1 _6393_/B sky130_fd_sc_hd__nand2_1
XFILLER_0_112_112 vssd1 vssd1 vccd1 vccd1 sky130_fd_sc_hd__fill_2
X_5412_ _6744_/Q _5591_/B _5591_/C vssd1 vssd1 vccd1 vccd1 _5412_/X sky130_fd_sc_hd__and3_1
XFILLER_0_2_365 vssd1 vssd1 vccd1 vccd1 sky130_fd_sc_hd__fill_2
X_5343_ _5342_/A _5342_/B _6745_/Q vssd1 vssd1 vccd1 vccd1 _5343_/Y sky130_fd_sc_hd__o21ai_1
XFILLER_0_10_132 vssd1 vssd1 vccd1 vccd1 sky130_fd_sc_hd__fill_2
XFILLER_0_10_121 vssd1 vssd1 vccd1 vccd1 sky130_fd_sc_hd__decap_4
X_5274_ _5272_/A _5300_/B _5273_/X vssd1 vssd1 vccd1 vccd1 _5274_/X sky130_fd_sc_hd__a21bo_1
X_4225_ _4225_/A _4237_/A vssd1 vssd1 vccd1 vccd1 _4232_/B sky130_fd_sc_hd__xnor2_4
X_4156_ _4942_/A _4942_/B _4774_/B _4776_/A vssd1 vssd1 vccd1 vccd1 _4158_/B sky130_fd_sc_hd__nand4_1
X_4087_ _6634_/Q _4296_/B vssd1 vssd1 vccd1 vccd1 _4297_/A sky130_fd_sc_hd__nand2_1
XANTENNA__4814__D _4814_/D vssd1 vssd1 vccd1 vccd1 sky130_fd_sc_hd__diode_2
XANTENNA__6090__S _6098_/S vssd1 vssd1 vccd1 vccd1 sky130_fd_sc_hd__diode_2
XFILLER_0_92_157 vssd1 vssd1 vccd1 vccd1 sky130_fd_sc_hd__decap_4
X_4989_ _4988_/B _4988_/C _4988_/A vssd1 vssd1 vccd1 vccd1 _4989_/X sky130_fd_sc_hd__o21a_1
X_6728_ _6802_/CLK _6728_/D fanout142/X vssd1 vssd1 vccd1 vccd1 _6728_/Q sky130_fd_sc_hd__dfstp_1
XFILLER_0_80_319 vssd1 vssd1 vccd1 vccd1 sky130_fd_sc_hd__decap_8
XFILLER_0_18_276 vssd1 vssd1 vccd1 vccd1 sky130_fd_sc_hd__fill_2
X_6659_ _6853_/CLK _6659_/D vssd1 vssd1 vccd1 vccd1 _6659_/Q sky130_fd_sc_hd__dfxtp_1
XFILLER_0_73_393 vssd1 vssd1 vccd1 vccd1 sky130_ef_sc_hd__decap_12
XFILLER_0_33_279 vssd1 vssd1 vccd1 vccd1 sky130_fd_sc_hd__fill_1
XANTENNA__4172__A2 _4966_/C vssd1 vssd1 vccd1 vccd1 sky130_fd_sc_hd__diode_2
XANTENNA__3380__B1 _5286_/B vssd1 vssd1 vccd1 vccd1 sky130_fd_sc_hd__diode_2
XANTENNA__3683__A1 _3999_/A vssd1 vssd1 vccd1 vccd1 sky130_fd_sc_hd__diode_2
XFILLER_0_68_110 vssd1 vssd1 vccd1 vccd1 sky130_fd_sc_hd__decap_3
XANTENNA__6733__SET_B fanout144/X vssd1 vssd1 vccd1 vccd1 sky130_fd_sc_hd__diode_2
XFILLER_0_33_28 vssd1 vssd1 vccd1 vccd1 sky130_fd_sc_hd__decap_4
XFILLER_0_33_39 vssd1 vssd1 vccd1 vccd1 sky130_fd_sc_hd__fill_2
XFILLER_0_83_102 vssd1 vssd1 vccd1 vccd1 sky130_fd_sc_hd__fill_2
XFILLER_0_126_226 vssd1 vssd1 vccd1 vccd1 sky130_fd_sc_hd__fill_2
Xclkbuf_leaf_4_clk_i clkbuf_leaf_9_clk_i/A vssd1 vssd1 vccd1 vccd1 _6841_/CLK sky130_fd_sc_hd__clkbuf_16
XFILLER_0_24_246 vssd1 vssd1 vccd1 vccd1 sky130_fd_sc_hd__decap_6
XFILLER_0_24_268 vssd1 vssd1 vccd1 vccd1 sky130_fd_sc_hd__decap_3
XFILLER_0_24_279 vssd1 vssd1 vccd1 vccd1 sky130_fd_sc_hd__fill_2
XFILLER_0_58_25 vssd1 vssd1 vccd1 vccd1 sky130_fd_sc_hd__decap_3
XANTENNA__4468__B _4942_/B vssd1 vssd1 vccd1 vccd1 sky130_fd_sc_hd__diode_2
XANTENNA__3803__D _5081_/D vssd1 vssd1 vccd1 vccd1 sky130_fd_sc_hd__diode_2
X_4010_ _4010_/A _4010_/B vssd1 vssd1 vccd1 vccd1 _4013_/B sky130_fd_sc_hd__xor2_2
XFILLER_0_74_68 vssd1 vssd1 vccd1 vccd1 sky130_fd_sc_hd__decap_3
X_5961_ _6880_/Q _3278_/Y _3285_/Y _6873_/Q _5938_/X vssd1 vssd1 vccd1 vccd1 _5963_/C
+ sky130_fd_sc_hd__a221o_1
X_4912_ _4912_/A _4912_/B vssd1 vssd1 vccd1 vccd1 _4915_/A sky130_fd_sc_hd__nand2_1
XFILLER_0_59_143 vssd1 vssd1 vccd1 vccd1 sky130_fd_sc_hd__fill_1
XFILLER_0_114_52 vssd1 vssd1 vccd1 vccd1 sky130_fd_sc_hd__fill_2
XFILLER_0_114_41 vssd1 vssd1 vccd1 vccd1 sky130_fd_sc_hd__fill_2
X_5892_ _5892_/A _5892_/B vssd1 vssd1 vccd1 vccd1 _5892_/Y sky130_fd_sc_hd__xnor2_1
XFILLER_0_114_85 vssd1 vssd1 vccd1 vccd1 sky130_fd_sc_hd__fill_2
X_4843_ _5801_/A _4841_/C _4841_/D _5787_/A vssd1 vssd1 vccd1 vccd1 _4844_/C sky130_fd_sc_hd__a22o_1
XFILLER_0_23_83 vssd1 vssd1 vccd1 vccd1 sky130_fd_sc_hd__fill_2
XFILLER_0_23_94 vssd1 vssd1 vccd1 vccd1 sky130_fd_sc_hd__decap_4
X_4774_ _5115_/C _4774_/B _4958_/B _4814_/D vssd1 vssd1 vccd1 vccd1 _4808_/A sky130_fd_sc_hd__nand4_2
X_6513_ _6834_/CLK _6513_/D vssd1 vssd1 vccd1 vccd1 _6513_/Q sky130_fd_sc_hd__dfxtp_1
XFILLER_0_15_235 vssd1 vssd1 vccd1 vccd1 sky130_fd_sc_hd__fill_2
X_3725_ _5277_/A _5320_/A _3725_/C _3725_/D vssd1 vssd1 vccd1 vccd1 _3733_/B sky130_fd_sc_hd__and4_1
XFILLER_0_55_393 vssd1 vssd1 vccd1 vccd1 sky130_ef_sc_hd__decap_12
X_6444_ hold139/X sstream_i[2] _6464_/S vssd1 vssd1 vccd1 vccd1 _6835_/D sky130_fd_sc_hd__mux2_1
XFILLER_0_15_268 vssd1 vssd1 vccd1 vccd1 sky130_fd_sc_hd__fill_1
XFILLER_0_15_279 vssd1 vssd1 vccd1 vccd1 sky130_fd_sc_hd__fill_1
X_3656_ _3655_/A _3654_/Y _3608_/X _3625_/Y vssd1 vssd1 vccd1 vccd1 _3678_/A sky130_fd_sc_hd__o211ai_4
XANTENNA_fanout115_A _4789_/C vssd1 vssd1 vccd1 vccd1 sky130_fd_sc_hd__diode_2
X_6375_ _6375_/A _6375_/B vssd1 vssd1 vccd1 vccd1 _6376_/B sky130_fd_sc_hd__nand2_1
X_3587_ _3587_/A _3587_/B _3587_/C vssd1 vssd1 vccd1 vccd1 _3588_/B sky130_fd_sc_hd__and3_1
XFILLER_0_61_3 vssd1 vssd1 vccd1 vccd1 sky130_fd_sc_hd__fill_1
X_5326_ _3543_/A _3543_/B _3561_/B _3562_/Y vssd1 vssd1 vccd1 vccd1 _5328_/A sky130_fd_sc_hd__o31a_1
X_5257_ _5247_/Y _5250_/X _5255_/X _4017_/B vssd1 vssd1 vccd1 vccd1 _5258_/B sky130_fd_sc_hd__a211o_1
XANTENNA__4809__D _4966_/C vssd1 vssd1 vccd1 vccd1 sky130_fd_sc_hd__diode_2
X_4208_ _5787_/B _4527_/B vssd1 vssd1 vccd1 vccd1 _4221_/A sky130_fd_sc_hd__nand2_1
XANTENNA__3665__B2 _5290_/A vssd1 vssd1 vccd1 vccd1 sky130_fd_sc_hd__diode_2
XANTENNA__3665__A1 _5327_/A vssd1 vssd1 vccd1 vccd1 sky130_fd_sc_hd__diode_2
X_5188_ _6641_/Q _5188_/B vssd1 vssd1 vccd1 vccd1 _5189_/B sky130_fd_sc_hd__or2_1
XANTENNA__6085__S _6098_/S vssd1 vssd1 vccd1 vccd1 sky130_fd_sc_hd__diode_2
X_4139_ _4136_/X _4140_/B vssd1 vssd1 vccd1 vccd1 _4209_/B sky130_fd_sc_hd__and2b_1
XFILLER_0_3_93 vssd1 vssd1 vccd1 vccd1 sky130_ef_sc_hd__decap_12
XFILLER_0_38_316 vssd1 vssd1 vccd1 vccd1 sky130_fd_sc_hd__fill_2
XFILLER_0_108_204 vssd1 vssd1 vccd1 vccd1 sky130_fd_sc_hd__fill_1
XANTENNA_fanout28_A _5844_/S vssd1 vssd1 vccd1 vccd1 sky130_fd_sc_hd__diode_2
XANTENNA__4841__B _5787_/A vssd1 vssd1 vccd1 vccd1 sky130_fd_sc_hd__diode_2
XFILLER_0_108_237 vssd1 vssd1 vccd1 vccd1 sky130_fd_sc_hd__fill_2
XFILLER_0_80_149 vssd1 vssd1 vccd1 vccd1 sky130_fd_sc_hd__fill_2
XFILLER_0_80_127 vssd1 vssd1 vccd1 vccd1 sky130_fd_sc_hd__fill_2
XFILLER_0_21_205 vssd1 vssd1 vccd1 vccd1 sky130_fd_sc_hd__fill_2
XANTENNA_clkbuf_leaf_2_clk_i_A clkbuf_leaf_9_clk_i/A vssd1 vssd1 vccd1 vccd1 sky130_fd_sc_hd__diode_2
XFILLER_0_44_27 vssd1 vssd1 vccd1 vccd1 sky130_fd_sc_hd__fill_1
XTAP_1150 vssd1 vccd1 sky130_fd_sc_hd__tapvpwrvgnd_1
XFILLER_0_96_282 vssd1 vssd1 vccd1 vccd1 sky130_fd_sc_hd__decap_4
XTAP_1183 vssd1 vccd1 sky130_fd_sc_hd__tapvpwrvgnd_1
XTAP_1172 vssd1 vccd1 sky130_fd_sc_hd__tapvpwrvgnd_1
XTAP_1161 vssd1 vccd1 sky130_fd_sc_hd__tapvpwrvgnd_1
XFILLER_0_60_37 vssd1 vssd1 vccd1 vccd1 sky130_fd_sc_hd__decap_3
XTAP_1194 vssd1 vccd1 sky130_fd_sc_hd__tapvpwrvgnd_1
XANTENNA__3367__B _5049_/B vssd1 vssd1 vccd1 vccd1 sky130_fd_sc_hd__diode_2
XFILLER_0_37_393 vssd1 vssd1 vccd1 vccd1 sky130_ef_sc_hd__decap_12
XFILLER_0_107_281 vssd1 vssd1 vccd1 vccd1 sky130_fd_sc_hd__fill_2
XFILLER_0_8_27 vssd1 vssd1 vccd1 vccd1 sky130_fd_sc_hd__fill_1
X_3510_ _5273_/A _5300_/B _5273_/B _5272_/A vssd1 vssd1 vccd1 vccd1 _3513_/B sky130_fd_sc_hd__a22oi_1
X_4490_ _6629_/Q _4534_/B _4488_/X vssd1 vssd1 vccd1 vccd1 _4496_/A sky130_fd_sc_hd__a21oi_1
XFILLER_0_69_57 vssd1 vssd1 vccd1 vccd1 sky130_fd_sc_hd__fill_2
XFILLER_0_52_374 vssd1 vssd1 vccd1 vccd1 sky130_ef_sc_hd__decap_12
XFILLER_0_122_262 vssd1 vssd1 vccd1 vccd1 sky130_fd_sc_hd__fill_2
XFILLER_0_122_251 vssd1 vssd1 vccd1 vccd1 sky130_fd_sc_hd__fill_1
X_3441_ _3483_/B _3441_/B _3442_/B vssd1 vssd1 vccd1 vccd1 _3441_/X sky130_fd_sc_hd__or3b_1
X_6160_ fb_i _6161_/B vssd1 vssd1 vccd1 vccd1 _6162_/A sky130_fd_sc_hd__nand2_1
XTAP_901 vssd1 vccd1 sky130_fd_sc_hd__tapvpwrvgnd_1
X_3372_ _3373_/A _3373_/B vssd1 vssd1 vccd1 vccd1 _3372_/Y sky130_fd_sc_hd__nand2b_1
XTAP_934 vssd1 vccd1 sky130_fd_sc_hd__tapvpwrvgnd_1
XTAP_923 vssd1 vccd1 sky130_fd_sc_hd__tapvpwrvgnd_1
XTAP_912 vssd1 vccd1 sky130_fd_sc_hd__tapvpwrvgnd_1
X_5111_ _5112_/A _5112_/B vssd1 vssd1 vccd1 vccd1 _5111_/X sky130_fd_sc_hd__or2_1
X_6091_ _6630_/Q hold275/X _6095_/S vssd1 vssd1 vccd1 vccd1 _6091_/X sky130_fd_sc_hd__mux2_1
XTAP_978 vssd1 vccd1 sky130_fd_sc_hd__tapvpwrvgnd_1
XTAP_967 vssd1 vccd1 sky130_fd_sc_hd__tapvpwrvgnd_1
XTAP_956 vssd1 vccd1 sky130_fd_sc_hd__tapvpwrvgnd_1
XTAP_945 vssd1 vccd1 sky130_fd_sc_hd__tapvpwrvgnd_1
XTAP_989 vssd1 vccd1 sky130_fd_sc_hd__tapvpwrvgnd_1
XFILLER_0_33_7 vssd1 vssd1 vccd1 vccd1 sky130_fd_sc_hd__fill_2
X_5042_ _5354_/B _5042_/B vssd1 vssd1 vccd1 vccd1 _5042_/Y sky130_fd_sc_hd__nand2b_1
XFILLER_0_79_249 vssd1 vssd1 vccd1 vccd1 sky130_fd_sc_hd__fill_1
XFILLER_0_79_238 vssd1 vssd1 vccd1 vccd1 sky130_fd_sc_hd__decap_3
X_5944_ _5944_/A tex_height_i[11] vssd1 vssd1 vccd1 vccd1 _5964_/A sky130_fd_sc_hd__nor2_1
XANTENNA__4942__A _4942_/A vssd1 vssd1 vccd1 vccd1 sky130_fd_sc_hd__diode_2
XFILLER_0_47_113 vssd1 vssd1 vccd1 vccd1 sky130_fd_sc_hd__fill_2
X_5875_ tex_addr_i[25] _5913_/B vssd1 vssd1 vccd1 vccd1 _5876_/B sky130_fd_sc_hd__nand2_1
XFILLER_0_34_93 vssd1 vssd1 vccd1 vccd1 sky130_fd_sc_hd__decap_4
XFILLER_0_7_221 vssd1 vssd1 vccd1 vccd1 sky130_fd_sc_hd__decap_3
X_4826_ _4826_/A _4826_/B vssd1 vssd1 vccd1 vccd1 _4839_/A sky130_fd_sc_hd__xor2_2
XANTENNA__4375__A2 _4614_/C vssd1 vssd1 vccd1 vccd1 sky130_fd_sc_hd__diode_2
XFILLER_0_28_371 vssd1 vssd1 vccd1 vccd1 sky130_fd_sc_hd__decap_8
XANTENNA__3708__D _5115_/D vssd1 vssd1 vccd1 vccd1 sky130_fd_sc_hd__diode_2
XFILLER_0_43_341 vssd1 vssd1 vccd1 vccd1 sky130_fd_sc_hd__fill_1
XFILLER_0_55_190 vssd1 vssd1 vccd1 vccd1 sky130_fd_sc_hd__fill_1
X_4757_ _4757_/A _4757_/B _4757_/C vssd1 vssd1 vccd1 vccd1 _4760_/A sky130_fd_sc_hd__nand3_2
X_4688_ _5645_/A _6621_/Q _4688_/C vssd1 vssd1 vccd1 vccd1 _5370_/A sky130_fd_sc_hd__and3_1
X_3708_ _5801_/A _5277_/B _5115_/C _5115_/D vssd1 vssd1 vccd1 vccd1 _3711_/A sky130_fd_sc_hd__nand4_2
X_6427_ _6427_/A _6427_/B _6427_/C vssd1 vssd1 vccd1 vccd1 _6427_/X sky130_fd_sc_hd__and3_1
X_3639_ _3639_/A _3639_/B vssd1 vssd1 vccd1 vccd1 _3706_/B sky130_fd_sc_hd__xnor2_1
X_6358_ _6381_/A vssd1 vssd1 vccd1 vccd1 _6416_/A sky130_fd_sc_hd__inv_2
XFILLER_0_11_260 vssd1 vssd1 vccd1 vccd1 sky130_fd_sc_hd__decap_3
XFILLER_0_11_293 vssd1 vssd1 vccd1 vccd1 sky130_fd_sc_hd__fill_2
X_5309_ _3525_/A _3525_/B _3526_/Y vssd1 vssd1 vccd1 vccd1 _5310_/B sky130_fd_sc_hd__a21oi_1
X_6289_ _6289_/A _6289_/B _6289_/C _6289_/D vssd1 vssd1 vccd1 vccd1 _6289_/X sky130_fd_sc_hd__or4_1
XANTENNA_clkbuf_2_2__f_clk_i_A clkbuf_0_clk_i/X vssd1 vssd1 vccd1 vccd1 sky130_fd_sc_hd__diode_2
XANTENNA__6052__A2 _6038_/B vssd1 vssd1 vccd1 vccd1 sky130_fd_sc_hd__diode_2
XPHY_200 vssd1 vssd1 vccd1 vccd1 sky130_fd_sc_hd__decap_3
XPHY_233 vssd1 vssd1 vccd1 vccd1 sky130_fd_sc_hd__decap_3
XPHY_222 vssd1 vssd1 vccd1 vccd1 sky130_fd_sc_hd__decap_3
XPHY_211 vssd1 vssd1 vccd1 vccd1 sky130_fd_sc_hd__decap_3
XPHY_277 vssd1 vssd1 vccd1 vccd1 sky130_fd_sc_hd__decap_3
XPHY_266 vssd1 vssd1 vccd1 vccd1 sky130_fd_sc_hd__decap_3
XPHY_255 vssd1 vssd1 vccd1 vccd1 sky130_fd_sc_hd__decap_3
XPHY_244 vssd1 vssd1 vccd1 vccd1 sky130_fd_sc_hd__decap_3
XFILLER_0_19_360 vssd1 vssd1 vccd1 vccd1 sky130_fd_sc_hd__decap_4
XFILLER_0_19_371 vssd1 vssd1 vccd1 vccd1 sky130_fd_sc_hd__decap_6
XFILLER_0_19_393 vssd1 vssd1 vccd1 vccd1 sky130_ef_sc_hd__decap_12
XFILLER_0_30_29 vssd1 vssd1 vccd1 vccd1 sky130_fd_sc_hd__decap_4
XFILLER_0_46_190 vssd1 vssd1 vccd1 vccd1 sky130_fd_sc_hd__fill_2
XFILLER_0_104_251 vssd1 vssd1 vccd1 vccd1 sky130_fd_sc_hd__fill_1
XANTENNA__5315__A1 _5299_/A vssd1 vssd1 vccd1 vccd1 sky130_fd_sc_hd__diode_2
XFILLER_0_39_27 vssd1 vssd1 vccd1 vccd1 sky130_fd_sc_hd__fill_1
Xhold4 hold4/A vssd1 vssd1 vccd1 vccd1 hold4/X sky130_fd_sc_hd__dlygate4sd3_1
XANTENNA__4746__B _5687_/B vssd1 vssd1 vccd1 vccd1 sky130_fd_sc_hd__diode_2
XANTENNA__3629__B2 _5277_/B vssd1 vssd1 vccd1 vccd1 sky130_fd_sc_hd__diode_2
XFILLER_0_55_48 vssd1 vssd1 vccd1 vccd1 sky130_fd_sc_hd__fill_1
XANTENNA__6043__A2 _6038_/B vssd1 vssd1 vccd1 vccd1 sky130_fd_sc_hd__diode_2
Xclkbuf_leaf_22_clk_i _6684_/CLK vssd1 vssd1 vccd1 vccd1 _6747_/CLK sky130_fd_sc_hd__clkbuf_16
XFILLER_0_71_14 vssd1 vssd1 vccd1 vccd1 sky130_fd_sc_hd__fill_2
X_3990_ _3990_/A _3990_/B vssd1 vssd1 vccd1 vccd1 _3992_/C sky130_fd_sc_hd__xor2_2
XFILLER_0_29_113 vssd1 vssd1 vccd1 vccd1 sky130_fd_sc_hd__fill_2
X_5660_ tex_addr_i[2] _5660_/B vssd1 vssd1 vccd1 vccd1 _5662_/A sky130_fd_sc_hd__xnor2_1
X_4611_ _4595_/A _4595_/B _4648_/A vssd1 vssd1 vccd1 vccd1 _4612_/B sky130_fd_sc_hd__o21ai_1
XFILLER_0_84_285 vssd1 vssd1 vccd1 vccd1 sky130_fd_sc_hd__decap_4
XFILLER_0_44_127 vssd1 vssd1 vccd1 vccd1 sky130_fd_sc_hd__fill_2
XFILLER_0_4_213 vssd1 vssd1 vccd1 vccd1 sky130_fd_sc_hd__fill_1
X_5591_ _5599_/A _5591_/B _5591_/C vssd1 vssd1 vccd1 vccd1 _5591_/X sky130_fd_sc_hd__and3_2
XFILLER_0_111_42 vssd1 vssd1 vccd1 vccd1 sky130_fd_sc_hd__decap_3
X_4542_ _4541_/A _4541_/Y _4498_/Y _4510_/X vssd1 vssd1 vccd1 vccd1 _4545_/A sky130_fd_sc_hd__a211oi_2
XFILLER_0_20_40 vssd1 vssd1 vccd1 vccd1 sky130_fd_sc_hd__fill_2
XFILLER_0_52_160 vssd1 vssd1 vccd1 vccd1 sky130_fd_sc_hd__decap_4
XANTENNA_hold53_A hold53/A vssd1 vssd1 vccd1 vccd1 sky130_fd_sc_hd__diode_2
XFILLER_0_111_75 vssd1 vssd1 vccd1 vccd1 sky130_fd_sc_hd__fill_2
X_4473_ _4473_/A _4473_/B _4473_/C vssd1 vssd1 vccd1 vccd1 _4480_/A sky130_fd_sc_hd__nand3_1
X_6212_ _6212_/A _6212_/B _6212_/C vssd1 vssd1 vccd1 vccd1 _6218_/A sky130_fd_sc_hd__or3_1
XFILLER_0_110_232 vssd1 vssd1 vccd1 vccd1 sky130_fd_sc_hd__fill_1
X_3424_ _3426_/B _3426_/A vssd1 vssd1 vccd1 vccd1 _3447_/A sky130_fd_sc_hd__and2b_1
XFILLER_0_40_377 vssd1 vssd1 vccd1 vccd1 sky130_fd_sc_hd__fill_1
X_6143_ _6152_/A _6143_/B vssd1 vssd1 vccd1 vccd1 _6143_/Y sky130_fd_sc_hd__nand2_1
XTAP_742 vssd1 vccd1 sky130_fd_sc_hd__tapvpwrvgnd_1
XTAP_731 vssd1 vccd1 sky130_fd_sc_hd__tapvpwrvgnd_1
X_3355_ _5327_/A _6689_/Q _6690_/Q _5290_/A vssd1 vssd1 vccd1 vccd1 _3359_/D sky130_fd_sc_hd__a22o_1
XTAP_720 vssd1 vccd1 sky130_fd_sc_hd__tapvpwrvgnd_1
X_6074_ hold82/X _6653_/Q _6315_/S vssd1 vssd1 vccd1 vccd1 hold83/A sky130_fd_sc_hd__mux2_1
XTAP_786 vssd1 vccd1 sky130_fd_sc_hd__tapvpwrvgnd_1
XTAP_775 vssd1 vccd1 sky130_fd_sc_hd__tapvpwrvgnd_1
XTAP_764 vssd1 vccd1 sky130_fd_sc_hd__tapvpwrvgnd_1
XTAP_753 vssd1 vccd1 sky130_fd_sc_hd__tapvpwrvgnd_1
X_3286_ tex_height_i[7] vssd1 vssd1 vccd1 vccd1 _3286_/Y sky130_fd_sc_hd__inv_2
XTAP_797 vssd1 vccd1 sky130_fd_sc_hd__tapvpwrvgnd_1
X_5025_ _5354_/B _5025_/B vssd1 vssd1 vccd1 vccd1 _5039_/B sky130_fd_sc_hd__nand2_1
XFILLER_0_24_3 vssd1 vssd1 vccd1 vccd1 sky130_ef_sc_hd__decap_12
XFILLER_0_136_83 vssd1 vssd1 vccd1 vccd1 sky130_fd_sc_hd__fill_1
XFILLER_0_45_70 vssd1 vssd1 vccd1 vccd1 sky130_fd_sc_hd__fill_1
X_6976_ vssd1 vssd1 vccd1 vccd1 _6976_/HI tex_mport_o[29] sky130_fd_sc_hd__conb_1
X_5927_ hold54/X tex_mport_i[2] _5932_/S vssd1 vssd1 vccd1 vccd1 _6655_/D sky130_fd_sc_hd__mux2_1
XFILLER_0_118_365 vssd1 vssd1 vccd1 vccd1 sky130_fd_sc_hd__fill_2
XFILLER_0_75_274 vssd1 vssd1 vccd1 vccd1 sky130_fd_sc_hd__decap_6
X_5858_ tex_addr_i[22] _5913_/B _5853_/Y vssd1 vssd1 vccd1 vccd1 _5859_/B sky130_fd_sc_hd__a21o_1
XFILLER_0_90_266 vssd1 vssd1 vccd1 vccd1 sky130_fd_sc_hd__decap_8
X_5789_ _6520_/Q _5802_/B _5788_/Y vssd1 vssd1 vccd1 vccd1 _5791_/B sky130_fd_sc_hd__a21o_1
X_4809_ _4971_/D _4970_/B _4966_/A _4966_/C vssd1 vssd1 vccd1 vccd1 _4809_/X sky130_fd_sc_hd__and4_1
XFILLER_0_90_288 vssd1 vssd1 vccd1 vccd1 sky130_fd_sc_hd__decap_3
XFILLER_0_43_160 vssd1 vssd1 vccd1 vccd1 sky130_fd_sc_hd__fill_2
XANTENNA__6637__SET_B fanout140/X vssd1 vssd1 vccd1 vccd1 sky130_fd_sc_hd__diode_2
XFILLER_0_9_81 vssd1 vssd1 vccd1 vccd1 sky130_ef_sc_hd__decap_12
XFILLER_0_31_388 vssd1 vssd1 vccd1 vccd1 sky130_fd_sc_hd__decap_4
XANTENNA_clkbuf_leaf_28_clk_i_A clkbuf_leaf_1_clk_i/A vssd1 vssd1 vccd1 vccd1 sky130_fd_sc_hd__diode_2
XFILLER_0_124_313 vssd1 vssd1 vccd1 vccd1 sky130_fd_sc_hd__decap_3
XFILLER_0_124_302 vssd1 vssd1 vccd1 vccd1 sky130_fd_sc_hd__fill_2
XANTENNA__3547__B1 _5277_/B vssd1 vssd1 vccd1 vccd1 sky130_fd_sc_hd__diode_2
XFILLER_0_22_344 vssd1 vssd1 vccd1 vccd1 sky130_fd_sc_hd__fill_1
XFILLER_0_34_182 vssd1 vssd1 vccd1 vccd1 sky130_fd_sc_hd__decap_3
XFILLER_0_66_25 vssd1 vssd1 vccd1 vccd1 sky130_fd_sc_hd__fill_1
XFILLER_0_5_39 vssd1 vssd1 vccd1 vccd1 sky130_ef_sc_hd__decap_12
XANTENNA__4476__B _4789_/C vssd1 vssd1 vccd1 vccd1 sky130_fd_sc_hd__diode_2
XFILLER_0_89_366 vssd1 vssd1 vccd1 vccd1 sky130_ef_sc_hd__decap_12
X_6830_ _6830_/CLK _6830_/D fanout152/X vssd1 vssd1 vccd1 vccd1 depth_mport_o[52]
+ sky130_fd_sc_hd__dfrtp_4
XANTENNA__5588__A _5599_/A vssd1 vssd1 vccd1 vccd1 sky130_fd_sc_hd__diode_2
XANTENNA__4027__A1 _4842_/A vssd1 vssd1 vccd1 vccd1 sky130_fd_sc_hd__diode_2
X_6761_ _6818_/CLK _6761_/D fanout150/X vssd1 vssd1 vccd1 vccd1 pix_mport_o[33] sky130_fd_sc_hd__dfrtp_4
XANTENNA__5775__A1 _5774_/Y vssd1 vssd1 vccd1 vccd1 sky130_fd_sc_hd__diode_2
XFILLER_0_15_84 vssd1 vssd1 vccd1 vccd1 sky130_fd_sc_hd__fill_1
XFILLER_0_15_73 vssd1 vssd1 vccd1 vccd1 sky130_fd_sc_hd__fill_2
XFILLER_0_15_51 vssd1 vssd1 vccd1 vccd1 sky130_fd_sc_hd__decap_4
X_5712_ tex_addr_i[7] _5712_/B vssd1 vssd1 vccd1 vccd1 _5713_/B sky130_fd_sc_hd__nand2_1
XFILLER_0_9_327 vssd1 vssd1 vccd1 vccd1 sky130_fd_sc_hd__fill_1
XANTENNA__3786__B1 _5115_/C vssd1 vssd1 vccd1 vccd1 sky130_fd_sc_hd__diode_2
X_3973_ _3973_/A _3973_/B _3973_/C vssd1 vssd1 vccd1 vccd1 _3973_/X sky130_fd_sc_hd__or3_1
X_6692_ _6693_/CLK _6692_/D vssd1 vssd1 vccd1 vccd1 _6692_/Q sky130_fd_sc_hd__dfxtp_1
X_5643_ hold150/X _5642_/X _5844_/S vssd1 vssd1 vccd1 vccd1 _6621_/D sky130_fd_sc_hd__mux2_1
X_5574_ _5599_/A _5574_/B _5588_/C vssd1 vssd1 vccd1 vccd1 _5574_/X sky130_fd_sc_hd__and3_1
XFILLER_0_25_160 vssd1 vssd1 vccd1 vccd1 sky130_fd_sc_hd__fill_1
Xhold201 _6785_/Q vssd1 vssd1 vccd1 vccd1 _6136_/B sky130_fd_sc_hd__dlygate4sd3_1
X_4525_ _4524_/A _4524_/B _4524_/C vssd1 vssd1 vccd1 vccd1 _4527_/D sky130_fd_sc_hd__a21o_1
Xhold212 _6862_/Q vssd1 vssd1 vccd1 vccd1 hold212/X sky130_fd_sc_hd__dlygate4sd3_1
Xhold223 _6553_/Q vssd1 vssd1 vccd1 vccd1 _6335_/B sky130_fd_sc_hd__dlygate4sd3_1
Xhold234 _6746_/Q vssd1 vssd1 vccd1 vccd1 hold234/X sky130_fd_sc_hd__dlygate4sd3_1
XFILLER_0_40_141 vssd1 vssd1 vccd1 vccd1 sky130_fd_sc_hd__fill_1
Xhold256 _6727_/Q vssd1 vssd1 vccd1 vccd1 hold256/X sky130_fd_sc_hd__dlygate4sd3_1
Xhold267 _6085_/X vssd1 vssd1 vccd1 vccd1 _6723_/D sky130_fd_sc_hd__dlygate4sd3_1
Xhold278 _6630_/Q vssd1 vssd1 vccd1 vccd1 hold278/X sky130_fd_sc_hd__dlygate4sd3_1
X_4456_ _4443_/A _4443_/B _4485_/A vssd1 vssd1 vccd1 vccd1 _4457_/C sky130_fd_sc_hd__o21ai_1
Xhold245 _6097_/X vssd1 vssd1 vccd1 vccd1 _6735_/D sky130_fd_sc_hd__dlygate4sd3_1
XFILLER_0_40_185 vssd1 vssd1 vccd1 vccd1 sky130_fd_sc_hd__decap_4
X_4387_ _4387_/A _4387_/B vssd1 vssd1 vccd1 vccd1 _4422_/A sky130_fd_sc_hd__xnor2_1
X_3407_ _6649_/Q _3688_/B vssd1 vssd1 vccd1 vccd1 _3689_/A sky130_fd_sc_hd__nand2_1
Xhold289 _6101_/X vssd1 vssd1 vccd1 vccd1 _6739_/D sky130_fd_sc_hd__dlygate4sd3_1
X_6126_ pix_mport_o[34] hold32/X _6224_/B vssd1 vssd1 vccd1 vccd1 _6762_/D sky130_fd_sc_hd__mux2_1
X_3338_ _3338_/A _3338_/B vssd1 vssd1 vccd1 vccd1 _3602_/A sky130_fd_sc_hd__nand2_1
XTAP_550 vssd1 vccd1 sky130_fd_sc_hd__tapvpwrvgnd_1
XTAP_561 vssd1 vccd1 sky130_fd_sc_hd__tapvpwrvgnd_1
XTAP_572 vssd1 vccd1 sky130_fd_sc_hd__tapvpwrvgnd_1
XTAP_583 vssd1 vccd1 sky130_fd_sc_hd__tapvpwrvgnd_1
XTAP_594 vssd1 vccd1 sky130_fd_sc_hd__tapvpwrvgnd_1
X_6057_ hold80/X hold98/X _6072_/S vssd1 vssd1 vccd1 vccd1 _6696_/D sky130_fd_sc_hd__mux2_1
XANTENNA__5463__B1 _5588_/C vssd1 vssd1 vccd1 vccd1 sky130_fd_sc_hd__diode_2
X_3269_ _6519_/Q vssd1 vssd1 vccd1 vccd1 _3269_/Y sky130_fd_sc_hd__inv_2
XANTENNA_107 sstream_i[7] vssd1 vssd1 vccd1 vccd1 sky130_fd_sc_hd__diode_2
X_5008_ _4794_/B _4488_/A _4128_/A _4131_/A vssd1 vssd1 vccd1 vccd1 _5015_/A sky130_fd_sc_hd__a31o_1
XANTENNA_118 sstream_i[9] vssd1 vssd1 vccd1 vccd1 sky130_fd_sc_hd__diode_2
XANTENNA__6093__S _6098_/S vssd1 vssd1 vccd1 vccd1 sky130_fd_sc_hd__diode_2
XANTENNA_129 tex_addr_i[14] vssd1 vssd1 vccd1 vccd1 sky130_fd_sc_hd__diode_2
XFILLER_0_138_405 vssd1 vssd1 vccd1 vccd1 sky130_fd_sc_hd__fill_2
X_6959_ vssd1 vssd1 vccd1 vccd1 _6959_/HI tex_mport_o[12] sky130_fd_sc_hd__conb_1
XFILLER_0_63_255 vssd1 vssd1 vccd1 vccd1 sky130_fd_sc_hd__fill_1
XFILLER_0_118_195 vssd1 vssd1 vccd1 vccd1 sky130_fd_sc_hd__fill_1
XFILLER_0_23_108 vssd1 vssd1 vccd1 vccd1 sky130_fd_sc_hd__fill_2
XFILLER_0_121_305 vssd1 vssd1 vccd1 vccd1 sky130_fd_sc_hd__fill_2
XANTENNA__3481__A _5051_/A vssd1 vssd1 vccd1 vccd1 sky130_fd_sc_hd__diode_2
XFILLER_0_86_303 vssd1 vssd1 vccd1 vccd1 sky130_fd_sc_hd__fill_2
XFILLER_0_129_405 vssd1 vssd1 vccd1 vccd1 sky130_fd_sc_hd__fill_2
XFILLER_0_86_358 vssd1 vssd1 vccd1 vccd1 sky130_fd_sc_hd__decap_6
XFILLER_0_52_27 vssd1 vssd1 vccd1 vccd1 sky130_fd_sc_hd__fill_1
XANTENNA__3359__C _5299_/A vssd1 vssd1 vccd1 vccd1 sky130_fd_sc_hd__diode_2
XANTENNA__5574__C _5588_/C vssd1 vssd1 vccd1 vccd1 sky130_fd_sc_hd__diode_2
XFILLER_0_42_406 vssd1 vssd1 vccd1 vccd1 sky130_fd_sc_hd__fill_1
XFILLER_0_22_141 vssd1 vssd1 vccd1 vccd1 sky130_fd_sc_hd__fill_2
XFILLER_0_22_152 vssd1 vssd1 vccd1 vccd1 sky130_fd_sc_hd__fill_2
X_4310_ _4301_/A _4301_/C _4301_/B vssd1 vssd1 vccd1 vccd1 _4310_/Y sky130_fd_sc_hd__o21ai_1
X_5290_ _5290_/A hold13/A vssd1 vssd1 vccd1 vccd1 _5291_/B sky130_fd_sc_hd__nand2_1
XFILLER_0_22_163 vssd1 vssd1 vccd1 vccd1 sky130_fd_sc_hd__fill_1
XANTENNA__4487__A _4488_/A vssd1 vssd1 vccd1 vccd1 sky130_fd_sc_hd__diode_2
X_4241_ _4241_/A _4241_/B vssd1 vssd1 vccd1 vccd1 _4244_/B sky130_fd_sc_hd__and2_2
X_4172_ _4842_/A _4966_/C _4841_/D _4966_/A vssd1 vssd1 vccd1 vccd1 _4172_/Y sky130_fd_sc_hd__a22oi_1
XANTENNA__5810__S _5923_/S vssd1 vssd1 vccd1 vccd1 sky130_fd_sc_hd__diode_2
XFILLER_0_117_52 vssd1 vssd1 vccd1 vccd1 sky130_fd_sc_hd__fill_2
XFILLER_0_117_74 vssd1 vssd1 vccd1 vccd1 sky130_fd_sc_hd__fill_2
XFILLER_0_77_303 vssd1 vssd1 vccd1 vccd1 sky130_fd_sc_hd__fill_1
X_6813_ _6863_/CLK _6813_/D _6073_/A vssd1 vssd1 vccd1 vccd1 depth_mport_o[35] sky130_fd_sc_hd__dfrtp_4
XFILLER_0_9_113 vssd1 vssd1 vccd1 vccd1 sky130_ef_sc_hd__decap_12
XFILLER_0_92_317 vssd1 vssd1 vccd1 vccd1 sky130_fd_sc_hd__decap_8
X_3956_ _3956_/A _3956_/B _3956_/C vssd1 vssd1 vccd1 vccd1 _5141_/A sky130_fd_sc_hd__nand3_1
X_6744_ _6745_/CLK _6744_/D fanout140/X vssd1 vssd1 vccd1 vccd1 _6744_/Q sky130_fd_sc_hd__dfstp_1
XFILLER_0_42_71 vssd1 vssd1 vccd1 vccd1 sky130_fd_sc_hd__fill_2
X_6675_ _6677_/CLK _6675_/D vssd1 vssd1 vccd1 vccd1 _6675_/Q sky130_fd_sc_hd__dfxtp_1
XFILLER_0_115_110 vssd1 vssd1 vccd1 vccd1 sky130_fd_sc_hd__fill_2
XFILLER_0_91_3 vssd1 vssd1 vccd1 vccd1 sky130_fd_sc_hd__fill_2
X_5626_ _5626_/A _5626_/B _5626_/C _5625_/X vssd1 vssd1 vccd1 vccd1 _5626_/X sky130_fd_sc_hd__or4b_1
XFILLER_0_5_330 vssd1 vssd1 vccd1 vccd1 sky130_fd_sc_hd__fill_1
X_3887_ _3885_/X _6683_/Q _5299_/A _3887_/D vssd1 vssd1 vccd1 vccd1 _3888_/B sky130_fd_sc_hd__and4b_1
XFILLER_0_5_374 vssd1 vssd1 vccd1 vccd1 sky130_fd_sc_hd__decap_4
XFILLER_0_130_124 vssd1 vssd1 vccd1 vccd1 sky130_fd_sc_hd__decap_3
XFILLER_0_13_152 vssd1 vssd1 vccd1 vccd1 sky130_fd_sc_hd__fill_2
XFILLER_0_5_385 vssd1 vssd1 vccd1 vccd1 sky130_fd_sc_hd__decap_6
X_5557_ _5599_/A _5458_/A _5458_/B _6113_/S vssd1 vssd1 vccd1 vccd1 _5557_/X sky130_fd_sc_hd__a31o_1
XANTENNA__4184__B1 _4966_/C vssd1 vssd1 vccd1 vccd1 sky130_fd_sc_hd__diode_2
X_4508_ _4500_/A _4501_/Y _4493_/X _4495_/X vssd1 vssd1 vccd1 vccd1 _4509_/B sky130_fd_sc_hd__o211ai_1
X_5488_ hold171/X sstream_i[79] _6450_/S vssd1 vssd1 vccd1 vccd1 _6521_/D sky130_fd_sc_hd__mux2_1
XFILLER_0_111_360 vssd1 vssd1 vccd1 vccd1 sky130_fd_sc_hd__fill_1
XANTENNA__6088__S _6098_/S vssd1 vssd1 vccd1 vccd1 sky130_fd_sc_hd__diode_2
X_4439_ _4438_/B _4438_/C _4438_/A vssd1 vssd1 vccd1 vccd1 _4440_/C sky130_fd_sc_hd__a21bo_1
XFILLER_0_111_393 vssd1 vssd1 vccd1 vccd1 sky130_ef_sc_hd__decap_12
XANTENNA__5684__B1 _5784_/S vssd1 vssd1 vccd1 vccd1 sky130_fd_sc_hd__diode_2
XANTENNA__4828__C _4971_/B vssd1 vssd1 vccd1 vccd1 sky130_fd_sc_hd__diode_2
XTAP_391 vssd1 vccd1 sky130_fd_sc_hd__tapvpwrvgnd_1
XTAP_380 vssd1 vccd1 sky130_fd_sc_hd__tapvpwrvgnd_1
X_6109_ _6648_/Q hold230/X _6113_/S vssd1 vssd1 vccd1 vccd1 _6109_/X sky130_fd_sc_hd__mux2_1
XFILLER_0_95_133 vssd1 vssd1 vccd1 vccd1 sky130_fd_sc_hd__decap_6
XFILLER_0_95_111 vssd1 vssd1 vccd1 vccd1 sky130_fd_sc_hd__fill_1
XPHY_31 vssd1 vssd1 vccd1 vccd1 sky130_fd_sc_hd__decap_3
XPHY_20 vssd1 vssd1 vccd1 vccd1 sky130_fd_sc_hd__decap_3
XPHY_42 vssd1 vssd1 vccd1 vccd1 sky130_fd_sc_hd__decap_3
XPHY_53 vssd1 vssd1 vccd1 vccd1 sky130_fd_sc_hd__decap_3
XPHY_64 vssd1 vssd1 vccd1 vccd1 sky130_fd_sc_hd__decap_3
XFILLER_0_138_246 vssd1 vssd1 vccd1 vccd1 sky130_fd_sc_hd__fill_2
XPHY_75 vssd1 vssd1 vccd1 vccd1 sky130_fd_sc_hd__decap_3
XPHY_86 vssd1 vssd1 vccd1 vccd1 sky130_fd_sc_hd__decap_3
XPHY_97 vssd1 vssd1 vccd1 vccd1 sky130_fd_sc_hd__decap_3
XFILLER_0_138_279 vssd1 vssd1 vccd1 vccd1 sky130_fd_sc_hd__fill_1
XFILLER_0_91_361 vssd1 vssd1 vccd1 vccd1 sky130_ef_sc_hd__decap_12
XFILLER_0_8_190 vssd1 vssd1 vccd1 vccd1 sky130_fd_sc_hd__fill_2
XANTENNA__3476__A _5299_/A vssd1 vssd1 vccd1 vccd1 sky130_fd_sc_hd__diode_2
XFILLER_0_24_406 vssd1 vssd1 vccd1 vccd1 sky130_fd_sc_hd__fill_1
XFILLER_0_106_154 vssd1 vssd1 vccd1 vccd1 sky130_fd_sc_hd__decap_3
XFILLER_0_51_225 vssd1 vssd1 vccd1 vccd1 sky130_fd_sc_hd__fill_1
XFILLER_0_51_247 vssd1 vssd1 vccd1 vccd1 sky130_ef_sc_hd__decap_12
XFILLER_0_121_113 vssd1 vssd1 vccd1 vccd1 sky130_fd_sc_hd__decap_3
XFILLER_0_121_102 vssd1 vssd1 vccd1 vccd1 sky130_fd_sc_hd__fill_2
XANTENNA__4175__B1 _4814_/D vssd1 vssd1 vccd1 vccd1 sky130_fd_sc_hd__diode_2
XFILLER_0_102_360 vssd1 vssd1 vccd1 vccd1 sky130_fd_sc_hd__decap_4
XFILLER_0_2_29 vssd1 vssd1 vccd1 vccd1 sky130_ef_sc_hd__decap_12
XFILLER_0_59_314 vssd1 vssd1 vccd1 vccd1 sky130_fd_sc_hd__decap_8
X_3810_ _3733_/B _3807_/Y _3809_/B vssd1 vssd1 vccd1 vccd1 _3811_/B sky130_fd_sc_hd__o21ba_1
X_4790_ _4790_/A _4790_/B vssd1 vssd1 vccd1 vccd1 _4792_/A sky130_fd_sc_hd__nor2_1
XANTENNA_29 sstream_i[13] vssd1 vssd1 vccd1 vccd1 sky130_fd_sc_hd__diode_2
XANTENNA_18 sstream_i[11] vssd1 vssd1 vccd1 vccd1 sky130_fd_sc_hd__diode_2
XFILLER_0_103_43 vssd1 vssd1 vccd1 vccd1 sky130_fd_sc_hd__decap_6
XFILLER_0_67_391 vssd1 vssd1 vccd1 vccd1 sky130_fd_sc_hd__fill_1
X_3741_ _3739_/X _3741_/B vssd1 vssd1 vccd1 vccd1 _3818_/A sky130_fd_sc_hd__nand2b_1
XFILLER_0_103_76 vssd1 vssd1 vccd1 vccd1 sky130_fd_sc_hd__fill_2
XFILLER_0_12_41 vssd1 vssd1 vccd1 vccd1 sky130_ef_sc_hd__decap_12
XFILLER_0_27_277 vssd1 vssd1 vccd1 vccd1 sky130_fd_sc_hd__decap_3
X_6460_ hold143/X sstream_i[18] _6465_/S vssd1 vssd1 vccd1 vccd1 _6851_/D sky130_fd_sc_hd__mux2_1
XFILLER_0_12_85 vssd1 vssd1 vccd1 vccd1 sky130_fd_sc_hd__decap_6
X_3672_ _3753_/A _3753_/B vssd1 vssd1 vccd1 vccd1 _3672_/Y sky130_fd_sc_hd__nor2_1
X_6391_ _6391_/A _6410_/A vssd1 vssd1 vccd1 vccd1 _6393_/A sky130_fd_sc_hd__xnor2_2
XFILLER_0_42_247 vssd1 vssd1 vccd1 vccd1 sky130_fd_sc_hd__decap_4
X_5411_ _5591_/B _5591_/C _6744_/Q vssd1 vssd1 vccd1 vccd1 _5411_/Y sky130_fd_sc_hd__a21oi_1
XFILLER_0_112_135 vssd1 vssd1 vccd1 vccd1 sky130_fd_sc_hd__fill_2
X_5342_ _5342_/A _5342_/B vssd1 vssd1 vccd1 vccd1 _5342_/Y sky130_fd_sc_hd__nor2_1
XFILLER_0_2_377 vssd1 vssd1 vccd1 vccd1 sky130_fd_sc_hd__fill_2
XFILLER_0_10_166 vssd1 vssd1 vccd1 vccd1 sky130_fd_sc_hd__fill_2
X_5273_ _5273_/A _5273_/B vssd1 vssd1 vccd1 vccd1 _5273_/X sky130_fd_sc_hd__and2_1
XANTENNA__5106__A _5106_/A vssd1 vssd1 vccd1 vccd1 sky130_fd_sc_hd__diode_2
X_4224_ _4224_/A _4224_/B vssd1 vssd1 vccd1 vccd1 _4232_/A sky130_fd_sc_hd__xnor2_4
XFILLER_0_128_62 vssd1 vssd1 vccd1 vccd1 sky130_fd_sc_hd__fill_2
X_4155_ _4816_/A _5687_/B vssd1 vssd1 vccd1 vccd1 _4158_/A sky130_fd_sc_hd__and2_1
X_4086_ _4086_/A _4086_/B vssd1 vssd1 vccd1 vccd1 _4296_/B sky130_fd_sc_hd__xnor2_1
XANTENNA__4641__A1 _4638_/A vssd1 vssd1 vccd1 vccd1 sky130_fd_sc_hd__diode_2
XFILLER_0_77_155 vssd1 vssd1 vccd1 vccd1 sky130_fd_sc_hd__decap_4
XFILLER_0_77_199 vssd1 vssd1 vccd1 vccd1 sky130_fd_sc_hd__fill_2
X_4988_ _4988_/A _4988_/B _4988_/C vssd1 vssd1 vccd1 vccd1 _4988_/Y sky130_fd_sc_hd__nor3_2
X_6727_ _6863_/CLK _6727_/D fanout145/X vssd1 vssd1 vccd1 vccd1 _6727_/Q sky130_fd_sc_hd__dfstp_1
X_3939_ _3932_/A _3932_/C _3932_/B vssd1 vssd1 vccd1 vccd1 _3939_/Y sky130_fd_sc_hd__o21ai_1
X_6658_ _6853_/CLK _6658_/D vssd1 vssd1 vccd1 vccd1 hold78/A sky130_fd_sc_hd__dfxtp_1
X_5609_ _3252_/Y _6508_/Q _6507_/Q _3251_/Y vssd1 vssd1 vccd1 vccd1 _5609_/X sky130_fd_sc_hd__a22o_1
XANTENNA__4157__B1 _4776_/A vssd1 vssd1 vccd1 vccd1 sky130_fd_sc_hd__diode_2
XANTENNA__6400__A _6543_/Q vssd1 vssd1 vccd1 vccd1 sky130_fd_sc_hd__diode_2
X_6589_ _6802_/CLK _6589_/D fanout150/X vssd1 vssd1 vccd1 vccd1 tex_mport_o[32] sky130_fd_sc_hd__dfrtp_4
XFILLER_0_103_157 vssd1 vssd1 vccd1 vccd1 sky130_fd_sc_hd__fill_2
XFILLER_0_126_238 vssd1 vssd1 vccd1 vccd1 sky130_fd_sc_hd__fill_2
XFILLER_0_83_169 vssd1 vssd1 vccd1 vccd1 sky130_fd_sc_hd__fill_2
XFILLER_0_91_180 vssd1 vssd1 vccd1 vccd1 sky130_fd_sc_hd__fill_2
XFILLER_0_24_225 vssd1 vssd1 vccd1 vccd1 sky130_fd_sc_hd__fill_2
XFILLER_0_91_191 vssd1 vssd1 vccd1 vccd1 sky130_fd_sc_hd__fill_2
XFILLER_0_102_190 vssd1 vssd1 vccd1 vccd1 sky130_fd_sc_hd__decap_4
XANTENNA__4765__A _4944_/B vssd1 vssd1 vccd1 vccd1 sky130_fd_sc_hd__diode_2
X_5960_ _6872_/Q _3286_/Y _5959_/X vssd1 vssd1 vccd1 vccd1 _5964_/B sky130_fd_sc_hd__o21a_1
X_4911_ _4911_/A _5010_/A vssd1 vssd1 vccd1 vccd1 _4917_/A sky130_fd_sc_hd__nand2_1
X_5891_ _5887_/A _5887_/B _5883_/B vssd1 vssd1 vccd1 vccd1 _5892_/B sky130_fd_sc_hd__o21ai_1
XFILLER_0_90_57 vssd1 vssd1 vccd1 vccd1 sky130_fd_sc_hd__fill_1
XFILLER_0_59_177 vssd1 vssd1 vccd1 vccd1 sky130_fd_sc_hd__fill_1
XFILLER_0_114_64 vssd1 vssd1 vccd1 vccd1 sky130_fd_sc_hd__fill_2
X_4842_ _4842_/A _5787_/B vssd1 vssd1 vccd1 vccd1 _4844_/B sky130_fd_sc_hd__and2_1
XFILLER_0_23_40 vssd1 vssd1 vccd1 vccd1 sky130_fd_sc_hd__fill_2
XFILLER_0_55_350 vssd1 vssd1 vccd1 vccd1 sky130_fd_sc_hd__fill_2
X_4773_ _4773_/A _4773_/B vssd1 vssd1 vccd1 vccd1 _4890_/A sky130_fd_sc_hd__xnor2_1
XFILLER_0_99_33 vssd1 vssd1 vccd1 vccd1 sky130_fd_sc_hd__fill_2
X_6512_ _6834_/CLK _6512_/D vssd1 vssd1 vccd1 vccd1 _6512_/Q sky130_fd_sc_hd__dfxtp_1
XFILLER_0_15_225 vssd1 vssd1 vccd1 vccd1 sky130_fd_sc_hd__decap_8
X_3724_ _4944_/B _5081_/C _5081_/D _5308_/A vssd1 vssd1 vccd1 vccd1 _3725_/D sky130_fd_sc_hd__a22o_1
X_6443_ hold194/X sstream_i[1] _6450_/S vssd1 vssd1 vccd1 vccd1 _6834_/D sky130_fd_sc_hd__mux2_1
X_3655_ _3655_/A _3655_/B _3655_/C vssd1 vssd1 vccd1 vccd1 _3655_/X sky130_fd_sc_hd__or3_1
X_6374_ hold60/A _6543_/Q vssd1 vssd1 vccd1 vccd1 _6375_/B sky130_fd_sc_hd__or2_1
X_3586_ _3587_/B _3587_/C _3587_/A vssd1 vssd1 vccd1 vccd1 _3588_/A sky130_fd_sc_hd__a21oi_1
XFILLER_0_2_141 vssd1 vssd1 vccd1 vccd1 sky130_fd_sc_hd__decap_3
X_5325_ _5325_/A _5325_/B vssd1 vssd1 vccd1 vccd1 _5329_/A sky130_fd_sc_hd__nor2_1
X_5256_ _4017_/B _5255_/X _5250_/X _5247_/Y vssd1 vssd1 vccd1 vccd1 _5256_/X sky130_fd_sc_hd__o211a_1
XFILLER_0_48_70 vssd1 vssd1 vccd1 vccd1 sky130_fd_sc_hd__fill_2
X_4207_ _4207_/A _4207_/B vssd1 vssd1 vccd1 vccd1 _4213_/A sky130_fd_sc_hd__xnor2_2
XFILLER_0_48_81 vssd1 vssd1 vccd1 vccd1 sky130_fd_sc_hd__fill_1
X_5187_ _5051_/B _4488_/A _4929_/A _4932_/A vssd1 vssd1 vccd1 vccd1 _5194_/A sky130_fd_sc_hd__a31o_1
X_4138_ _4966_/A _4841_/C _4841_/D _5754_/A vssd1 vssd1 vccd1 vccd1 _4140_/B sky130_fd_sc_hd__a22o_1
X_4069_ _4432_/A _4776_/A vssd1 vssd1 vccd1 vccd1 _4070_/B sky130_fd_sc_hd__nand2_1
XFILLER_0_64_80 vssd1 vssd1 vccd1 vccd1 sky130_fd_sc_hd__fill_2
XANTENNA__4841__C _4841_/C vssd1 vssd1 vccd1 vccd1 sky130_fd_sc_hd__diode_2
XFILLER_0_65_147 vssd1 vssd1 vccd1 vccd1 sky130_fd_sc_hd__fill_2
XFILLER_0_65_169 vssd1 vssd1 vccd1 vccd1 sky130_fd_sc_hd__fill_2
XFILLER_0_14_280 vssd1 vssd1 vccd1 vccd1 sky130_fd_sc_hd__fill_2
XFILLER_0_28_29 vssd1 vssd1 vccd1 vccd1 sky130_fd_sc_hd__decap_3
XTAP_1140 vssd1 vccd1 sky130_fd_sc_hd__tapvpwrvgnd_1
XFILLER_0_29_306 vssd1 vssd1 vccd1 vccd1 sky130_fd_sc_hd__decap_4
XFILLER_0_56_103 vssd1 vssd1 vccd1 vccd1 sky130_fd_sc_hd__fill_2
XTAP_1173 vssd1 vccd1 sky130_fd_sc_hd__tapvpwrvgnd_1
XTAP_1162 vssd1 vccd1 sky130_fd_sc_hd__tapvpwrvgnd_1
XTAP_1151 vssd1 vccd1 sky130_fd_sc_hd__tapvpwrvgnd_1
XFILLER_0_60_27 vssd1 vssd1 vccd1 vccd1 sky130_fd_sc_hd__fill_1
XTAP_1195 vssd1 vccd1 sky130_fd_sc_hd__tapvpwrvgnd_1
XTAP_1184 vssd1 vccd1 sky130_fd_sc_hd__tapvpwrvgnd_1
XFILLER_0_56_158 vssd1 vssd1 vccd1 vccd1 sky130_fd_sc_hd__fill_2
XFILLER_0_71_139 vssd1 vssd1 vccd1 vccd1 sky130_fd_sc_hd__fill_2
XANTENNA__3367__C _5286_/B vssd1 vssd1 vccd1 vccd1 sky130_fd_sc_hd__diode_2
XFILLER_0_4_406 vssd1 vssd1 vccd1 vccd1 sky130_fd_sc_hd__fill_1
XFILLER_0_52_320 vssd1 vssd1 vccd1 vccd1 sky130_fd_sc_hd__fill_1
XFILLER_0_64_191 vssd1 vssd1 vccd1 vccd1 sky130_fd_sc_hd__decap_3
XANTENNA__6032__A_N _6038_/C vssd1 vssd1 vccd1 vccd1 sky130_fd_sc_hd__diode_2
XFILLER_0_52_386 vssd1 vssd1 vccd1 vccd1 sky130_ef_sc_hd__decap_12
XFILLER_0_12_239 vssd1 vssd1 vccd1 vccd1 sky130_fd_sc_hd__fill_2
X_3440_ _3440_/A _3440_/B vssd1 vssd1 vccd1 vccd1 _3442_/B sky130_fd_sc_hd__or2_1
X_3371_ _3371_/A _3384_/A vssd1 vssd1 vccd1 vccd1 _3373_/B sky130_fd_sc_hd__or2_1
X_6090_ _6629_/Q hold260/X _6098_/S vssd1 vssd1 vccd1 vccd1 _6090_/X sky130_fd_sc_hd__mux2_1
XTAP_935 vssd1 vccd1 sky130_fd_sc_hd__tapvpwrvgnd_1
XTAP_924 vssd1 vccd1 sky130_fd_sc_hd__tapvpwrvgnd_1
XTAP_913 vssd1 vccd1 sky130_fd_sc_hd__tapvpwrvgnd_1
XTAP_902 vssd1 vccd1 sky130_fd_sc_hd__tapvpwrvgnd_1
XFILLER_0_20_261 vssd1 vssd1 vccd1 vccd1 sky130_fd_sc_hd__fill_1
X_5110_ _5110_/A _5110_/B vssd1 vssd1 vccd1 vccd1 _5112_/B sky130_fd_sc_hd__or2_1
XTAP_968 vssd1 vccd1 sky130_fd_sc_hd__tapvpwrvgnd_1
XTAP_957 vssd1 vccd1 sky130_fd_sc_hd__tapvpwrvgnd_1
XTAP_946 vssd1 vccd1 sky130_fd_sc_hd__tapvpwrvgnd_1
XFILLER_0_85_68 vssd1 vssd1 vccd1 vccd1 sky130_fd_sc_hd__fill_2
X_5041_ _5033_/B _5421_/B _5031_/X vssd1 vssd1 vccd1 vccd1 _5041_/X sky130_fd_sc_hd__a21o_1
XTAP_979 vssd1 vccd1 sky130_fd_sc_hd__tapvpwrvgnd_1
XFILLER_0_18_51 vssd1 vssd1 vccd1 vccd1 sky130_fd_sc_hd__fill_2
XFILLER_0_79_217 vssd1 vssd1 vccd1 vccd1 sky130_fd_sc_hd__decap_6
XFILLER_0_94_209 vssd1 vssd1 vccd1 vccd1 sky130_fd_sc_hd__decap_6
X_5943_ _5962_/B _5942_/X _5962_/A vssd1 vssd1 vccd1 vccd1 _5946_/A sky130_fd_sc_hd__a21oi_1
XANTENNA__4942__B _4942_/B vssd1 vssd1 vccd1 vccd1 sky130_fd_sc_hd__diode_2
X_5874_ tex_addr_i[25] _5913_/B vssd1 vssd1 vccd1 vccd1 _5876_/A sky130_fd_sc_hd__or2_1
XFILLER_0_47_125 vssd1 vssd1 vccd1 vccd1 sky130_fd_sc_hd__fill_1
XFILLER_0_47_169 vssd1 vssd1 vccd1 vccd1 sky130_fd_sc_hd__fill_2
X_4825_ _4966_/C _4824_/X _4823_/X vssd1 vssd1 vccd1 vccd1 _4826_/B sky130_fd_sc_hd__a21bo_1
XFILLER_0_105_208 vssd1 vssd1 vccd1 vccd1 sky130_fd_sc_hd__fill_2
XFILLER_0_7_266 vssd1 vssd1 vccd1 vccd1 sky130_fd_sc_hd__fill_2
X_4756_ _4748_/A _4748_/C _4748_/B vssd1 vssd1 vccd1 vccd1 _4757_/C sky130_fd_sc_hd__a21o_1
X_4687_ _4682_/B _4682_/C _6622_/Q vssd1 vssd1 vccd1 vccd1 _4689_/B sky130_fd_sc_hd__a21oi_1
X_3707_ _3707_/A _3707_/B vssd1 vssd1 vccd1 vccd1 _3713_/A sky130_fd_sc_hd__xnor2_1
XANTENNA__4780__B1 _4966_/C vssd1 vssd1 vccd1 vccd1 sky130_fd_sc_hd__diode_2
X_6426_ _6433_/B _6426_/B vssd1 vssd1 vccd1 vccd1 _6427_/C sky130_fd_sc_hd__or2_1
XFILLER_0_70_183 vssd1 vssd1 vccd1 vccd1 sky130_fd_sc_hd__decap_3
X_3638_ _3870_/A _5286_/A vssd1 vssd1 vccd1 vccd1 _3639_/B sky130_fd_sc_hd__nand2_1
X_6357_ _6348_/A _6349_/Y _6368_/S _6356_/X vssd1 vssd1 vccd1 vccd1 _6381_/A sky130_fd_sc_hd__o211a_1
X_3569_ _3567_/X _3569_/B vssd1 vssd1 vccd1 vccd1 _3594_/A sky130_fd_sc_hd__nand2b_1
X_5308_ _5308_/A _5308_/B vssd1 vssd1 vccd1 vccd1 _5310_/A sky130_fd_sc_hd__nand2_1
X_6288_ _3294_/Y _6863_/Q _3296_/Y _6862_/Q _6286_/X vssd1 vssd1 vccd1 vccd1 _6289_/D
+ sky130_fd_sc_hd__o221ai_1
XANTENNA__6096__S _6098_/S vssd1 vssd1 vccd1 vccd1 sky130_fd_sc_hd__diode_2
X_5239_ _5425_/B _5239_/B vssd1 vssd1 vccd1 vccd1 _5410_/A sky130_fd_sc_hd__or2_1
Xclkbuf_leaf_3_clk_i clkbuf_leaf_9_clk_i/A vssd1 vssd1 vccd1 vccd1 _6834_/CLK sky130_fd_sc_hd__clkbuf_16
XPHY_201 vssd1 vssd1 vccd1 vccd1 sky130_fd_sc_hd__decap_3
XFILLER_0_66_401 vssd1 vssd1 vccd1 vccd1 sky130_fd_sc_hd__decap_6
XPHY_234 vssd1 vssd1 vccd1 vccd1 sky130_fd_sc_hd__decap_3
XPHY_223 vssd1 vssd1 vccd1 vccd1 sky130_fd_sc_hd__decap_3
XPHY_212 vssd1 vssd1 vccd1 vccd1 sky130_fd_sc_hd__decap_3
XFILLER_0_93_220 vssd1 vssd1 vccd1 vccd1 sky130_fd_sc_hd__fill_2
XFILLER_0_78_294 vssd1 vssd1 vccd1 vccd1 sky130_fd_sc_hd__fill_2
XFILLER_0_38_136 vssd1 vssd1 vccd1 vccd1 sky130_fd_sc_hd__fill_2
XPHY_267 vssd1 vssd1 vccd1 vccd1 sky130_fd_sc_hd__decap_3
XPHY_256 vssd1 vssd1 vccd1 vccd1 sky130_fd_sc_hd__decap_3
XPHY_245 vssd1 vssd1 vccd1 vccd1 sky130_fd_sc_hd__decap_3
XFILLER_0_93_264 vssd1 vssd1 vccd1 vccd1 sky130_fd_sc_hd__fill_1
XFILLER_0_93_253 vssd1 vssd1 vccd1 vccd1 sky130_fd_sc_hd__fill_1
XFILLER_0_104_285 vssd1 vssd1 vccd1 vccd1 sky130_fd_sc_hd__decap_3
XANTENNA__5903__S _5922_/S vssd1 vssd1 vccd1 vccd1 sky130_fd_sc_hd__diode_2
XANTENNA__5079__A1 _5106_/A vssd1 vssd1 vccd1 vccd1 sky130_fd_sc_hd__diode_2
XANTENNA__3629__A2 _5115_/D vssd1 vssd1 vccd1 vccd1 sky130_fd_sc_hd__diode_2
XFILLER_0_55_16 vssd1 vssd1 vccd1 vccd1 sky130_fd_sc_hd__decap_3
Xhold5 hold5/A vssd1 vssd1 vccd1 vccd1 hold5/X sky130_fd_sc_hd__dlygate4sd3_1
XFILLER_0_76_209 vssd1 vssd1 vccd1 vccd1 sky130_fd_sc_hd__fill_2
XANTENNA__3659__A _5049_/A vssd1 vssd1 vccd1 vccd1 sky130_fd_sc_hd__diode_2
XFILLER_0_84_253 vssd1 vssd1 vccd1 vccd1 sky130_fd_sc_hd__decap_4
XFILLER_0_84_242 vssd1 vssd1 vccd1 vccd1 sky130_fd_sc_hd__fill_2
XFILLER_0_29_169 vssd1 vssd1 vccd1 vccd1 sky130_fd_sc_hd__fill_2
X_4610_ _4607_/A _4604_/Y _4597_/X _4599_/Y vssd1 vssd1 vccd1 vccd1 _4631_/B sky130_fd_sc_hd__o211ai_1
XFILLER_0_84_275 vssd1 vssd1 vccd1 vccd1 sky130_fd_sc_hd__decap_4
XFILLER_0_44_139 vssd1 vssd1 vccd1 vccd1 sky130_fd_sc_hd__fill_1
XFILLER_0_112_3 vssd1 vssd1 vccd1 vccd1 sky130_fd_sc_hd__fill_2
X_5590_ _5447_/X tex_mport_o[55] _5598_/S vssd1 vssd1 vccd1 vccd1 _6612_/D sky130_fd_sc_hd__mux2_1
XFILLER_0_111_54 vssd1 vssd1 vccd1 vccd1 sky130_fd_sc_hd__fill_2
X_4541_ _4541_/A _4541_/B _4541_/C vssd1 vssd1 vccd1 vccd1 _4541_/Y sky130_fd_sc_hd__nand3_1
XFILLER_0_20_52 vssd1 vssd1 vccd1 vccd1 sky130_fd_sc_hd__decap_3
X_4472_ _4471_/B _4471_/C _4471_/A vssd1 vssd1 vccd1 vccd1 _4473_/C sky130_fd_sc_hd__a21bo_1
XFILLER_0_20_63 vssd1 vssd1 vccd1 vccd1 sky130_fd_sc_hd__fill_2
X_6211_ _6209_/Y _6210_/X _6208_/B vssd1 vssd1 vccd1 vccd1 _6212_/C sky130_fd_sc_hd__o21a_1
X_3423_ _3470_/B _3423_/B vssd1 vssd1 vccd1 vccd1 _3426_/B sky130_fd_sc_hd__or2_1
X_6142_ _6150_/A _6141_/C hold69/A vssd1 vssd1 vccd1 vccd1 _6143_/B sky130_fd_sc_hd__a21o_1
XTAP_710 vssd1 vccd1 sky130_fd_sc_hd__tapvpwrvgnd_1
XFILLER_0_96_89 vssd1 vssd1 vccd1 vccd1 sky130_fd_sc_hd__fill_1
XTAP_743 vssd1 vccd1 sky130_fd_sc_hd__tapvpwrvgnd_1
XTAP_732 vssd1 vccd1 sky130_fd_sc_hd__tapvpwrvgnd_1
X_3354_ _3606_/A _3606_/B vssd1 vssd1 vccd1 vccd1 _3393_/B sky130_fd_sc_hd__and2_1
XTAP_721 vssd1 vccd1 sky130_fd_sc_hd__tapvpwrvgnd_1
X_6073_ _6073_/A _6661_/Q _6073_/C vssd1 vssd1 vccd1 vccd1 _6073_/X sky130_fd_sc_hd__and3_1
XTAP_776 vssd1 vccd1 sky130_fd_sc_hd__tapvpwrvgnd_1
XTAP_765 vssd1 vccd1 sky130_fd_sc_hd__tapvpwrvgnd_1
XTAP_754 vssd1 vccd1 sky130_fd_sc_hd__tapvpwrvgnd_1
X_3285_ tex_height_i[8] vssd1 vssd1 vccd1 vccd1 _3285_/Y sky130_fd_sc_hd__inv_2
XFILLER_0_29_83 vssd1 vssd1 vccd1 vccd1 sky130_fd_sc_hd__fill_2
XANTENNA__4817__A1 _4816_/A vssd1 vssd1 vccd1 vccd1 sky130_fd_sc_hd__diode_2
XTAP_798 vssd1 vccd1 sky130_fd_sc_hd__tapvpwrvgnd_1
XTAP_787 vssd1 vccd1 sky130_fd_sc_hd__tapvpwrvgnd_1
XANTENNA__6019__A0 _5081_/A vssd1 vssd1 vccd1 vccd1 sky130_fd_sc_hd__diode_2
X_5024_ _4924_/X _5003_/Y _5020_/Y _5022_/X vssd1 vssd1 vccd1 vccd1 _5025_/B sky130_fd_sc_hd__a211o_1
XFILLER_0_136_40 vssd1 vssd1 vccd1 vccd1 sky130_fd_sc_hd__decap_3
XFILLER_0_17_3 vssd1 vssd1 vccd1 vccd1 sky130_ef_sc_hd__decap_12
XFILLER_0_45_60 vssd1 vssd1 vccd1 vccd1 sky130_fd_sc_hd__fill_2
X_6975_ vssd1 vssd1 vccd1 vccd1 _6975_/HI tex_mport_o[28] sky130_fd_sc_hd__conb_1
XFILLER_0_67_209 vssd1 vssd1 vccd1 vccd1 sky130_fd_sc_hd__decap_3
XFILLER_0_45_93 vssd1 vssd1 vccd1 vccd1 sky130_fd_sc_hd__fill_1
X_5926_ hold106/X tex_mport_i[1] _5932_/S vssd1 vssd1 vccd1 vccd1 _6654_/D sky130_fd_sc_hd__mux2_1
XFILLER_0_75_231 vssd1 vssd1 vccd1 vccd1 sky130_fd_sc_hd__fill_1
XFILLER_0_90_201 vssd1 vssd1 vccd1 vccd1 sky130_fd_sc_hd__fill_2
X_5857_ tex_addr_i[23] _5913_/B vssd1 vssd1 vccd1 vccd1 _5863_/D sky130_fd_sc_hd__xnor2_1
XFILLER_0_61_92 vssd1 vssd1 vccd1 vccd1 sky130_fd_sc_hd__fill_1
X_5788_ _5786_/Y _5802_/C _5802_/B vssd1 vssd1 vccd1 vccd1 _5788_/Y sky130_fd_sc_hd__a21oi_1
X_4808_ _4808_/A _4808_/B vssd1 vssd1 vccd1 vccd1 _4821_/A sky130_fd_sc_hd__nand2_1
XFILLER_0_90_278 vssd1 vssd1 vccd1 vccd1 sky130_fd_sc_hd__fill_2
XFILLER_0_16_375 vssd1 vssd1 vccd1 vccd1 sky130_fd_sc_hd__decap_6
XFILLER_0_43_150 vssd1 vssd1 vccd1 vccd1 sky130_fd_sc_hd__decap_3
X_4739_ _4739_/A _4739_/B vssd1 vssd1 vccd1 vccd1 _4752_/A sky130_fd_sc_hd__xnor2_1
XFILLER_0_9_93 vssd1 vssd1 vccd1 vccd1 sky130_ef_sc_hd__decap_12
XFILLER_0_43_183 vssd1 vssd1 vccd1 vccd1 sky130_fd_sc_hd__decap_4
X_6409_ hold53/A hold7/A _6390_/A vssd1 vssd1 vccd1 vccd1 _6409_/Y sky130_fd_sc_hd__a21oi_1
XANTENNA_fanout88_A _5083_/B vssd1 vssd1 vccd1 vccd1 sky130_fd_sc_hd__diode_2
XFILLER_0_98_356 vssd1 vssd1 vccd1 vccd1 sky130_fd_sc_hd__fill_1
XANTENNA__3364__A1_N _5311_/A vssd1 vssd1 vccd1 vccd1 sky130_fd_sc_hd__diode_2
XANTENNA__3479__A _5049_/A vssd1 vssd1 vccd1 vccd1 sky130_fd_sc_hd__diode_2
XFILLER_0_66_253 vssd1 vssd1 vccd1 vccd1 sky130_fd_sc_hd__fill_1
XFILLER_0_66_231 vssd1 vssd1 vccd1 vccd1 sky130_fd_sc_hd__fill_2
XFILLER_0_136_141 vssd1 vssd1 vccd1 vccd1 sky130_fd_sc_hd__decap_3
XFILLER_0_81_201 vssd1 vssd1 vccd1 vccd1 sky130_fd_sc_hd__fill_2
XFILLER_0_26_128 vssd1 vssd1 vccd1 vccd1 sky130_fd_sc_hd__fill_2
XFILLER_0_136_174 vssd1 vssd1 vccd1 vccd1 sky130_fd_sc_hd__fill_1
XFILLER_0_136_163 vssd1 vssd1 vccd1 vccd1 sky130_fd_sc_hd__fill_2
XFILLER_0_109_366 vssd1 vssd1 vccd1 vccd1 sky130_ef_sc_hd__decap_12
XFILLER_0_19_191 vssd1 vssd1 vccd1 vccd1 sky130_fd_sc_hd__fill_2
XFILLER_0_26_139 vssd1 vssd1 vccd1 vccd1 sky130_fd_sc_hd__fill_1
XANTENNA__3547__A1 _5081_/B vssd1 vssd1 vccd1 vccd1 sky130_fd_sc_hd__diode_2
XFILLER_0_22_323 vssd1 vssd1 vccd1 vccd1 sky130_fd_sc_hd__fill_1
XANTENNA__4476__C _4518_/D vssd1 vssd1 vccd1 vccd1 sky130_fd_sc_hd__diode_2
XFILLER_0_89_312 vssd1 vssd1 vccd1 vccd1 sky130_fd_sc_hd__fill_2
XANTENNA__5588__B _5588_/B vssd1 vssd1 vccd1 vccd1 sky130_fd_sc_hd__diode_2
XFILLER_0_89_378 vssd1 vssd1 vccd1 vccd1 sky130_ef_sc_hd__decap_12
XANTENNA__6421__B1 hold70/A vssd1 vssd1 vccd1 vccd1 sky130_fd_sc_hd__diode_2
X_6760_ _6818_/CLK _6760_/D fanout150/X vssd1 vssd1 vccd1 vccd1 pix_mport_o[32] sky130_fd_sc_hd__dfrtp_4
XFILLER_0_119_119 vssd1 vssd1 vccd1 vccd1 sky130_fd_sc_hd__fill_2
X_5711_ tex_addr_i[7] _5712_/B vssd1 vssd1 vccd1 vccd1 _5711_/Y sky130_fd_sc_hd__nor2_1
XANTENNA__3786__A1 _5801_/A vssd1 vssd1 vccd1 vccd1 sky130_fd_sc_hd__diode_2
X_3972_ _3973_/A _3973_/B _3973_/C vssd1 vssd1 vccd1 vccd1 _3972_/Y sky130_fd_sc_hd__nor3_1
XFILLER_0_72_212 vssd1 vssd1 vccd1 vccd1 sky130_fd_sc_hd__fill_2
X_6691_ _6693_/CLK _6691_/D vssd1 vssd1 vccd1 vccd1 _6691_/Q sky130_fd_sc_hd__dfxtp_1
XANTENNA__3786__B2 _4832_/C vssd1 vssd1 vccd1 vccd1 sky130_fd_sc_hd__diode_2
XFILLER_0_57_297 vssd1 vssd1 vccd1 vccd1 sky130_fd_sc_hd__decap_3
X_5642_ _5796_/A _5559_/B _5652_/A _5641_/X vssd1 vssd1 vccd1 vccd1 _5642_/X sky130_fd_sc_hd__a22o_1
XFILLER_0_115_347 vssd1 vssd1 vccd1 vccd1 sky130_fd_sc_hd__fill_2
X_5573_ _5388_/B tex_mport_o[41] _5576_/S vssd1 vssd1 vccd1 vccd1 _6598_/D sky130_fd_sc_hd__mux2_1
XANTENNA__4735__B1 _5051_/B vssd1 vssd1 vccd1 vccd1 sky130_fd_sc_hd__diode_2
XFILLER_0_130_306 vssd1 vssd1 vccd1 vccd1 sky130_fd_sc_hd__fill_2
Xhold202 _6136_/Y vssd1 vssd1 vccd1 vccd1 hold202/X sky130_fd_sc_hd__dlygate4sd3_1
X_4524_ _4524_/A _4524_/B _4524_/C vssd1 vssd1 vccd1 vccd1 _4536_/A sky130_fd_sc_hd__nand3_2
XFILLER_0_13_312 vssd1 vssd1 vccd1 vccd1 sky130_fd_sc_hd__decap_3
Xhold213 _6850_/Q vssd1 vssd1 vccd1 vccd1 hold213/X sky130_fd_sc_hd__dlygate4sd3_1
Xhold235 _6108_/X vssd1 vssd1 vccd1 vccd1 _6746_/D sky130_fd_sc_hd__dlygate4sd3_1
Xhold224 _6875_/Q vssd1 vssd1 vccd1 vccd1 hold224/X sky130_fd_sc_hd__dlygate4sd3_1
XFILLER_0_123_391 vssd1 vssd1 vccd1 vccd1 sky130_fd_sc_hd__fill_1
Xhold257 _6089_/X vssd1 vssd1 vccd1 vccd1 _6727_/D sky130_fd_sc_hd__dlygate4sd3_1
Xhold268 _6632_/Q vssd1 vssd1 vccd1 vccd1 hold268/X sky130_fd_sc_hd__dlygate4sd3_1
X_4455_ _4455_/A _4455_/B vssd1 vssd1 vccd1 vccd1 _4457_/B sky130_fd_sc_hd__and2_1
Xhold246 _6736_/Q vssd1 vssd1 vccd1 vccd1 hold246/X sky130_fd_sc_hd__dlygate4sd3_1
XFILLER_0_40_175 vssd1 vssd1 vccd1 vccd1 sky130_fd_sc_hd__decap_4
X_4386_ _4386_/A _4440_/A vssd1 vssd1 vccd1 vccd1 _4394_/A sky130_fd_sc_hd__nand2_1
X_3406_ _3408_/A _3406_/B vssd1 vssd1 vccd1 vccd1 _3688_/B sky130_fd_sc_hd__and2_1
Xhold279 _6667_/Q vssd1 vssd1 vccd1 vccd1 hold279/X sky130_fd_sc_hd__dlygate4sd3_1
X_6125_ pix_mport_o[33] hold17/X _6224_/B vssd1 vssd1 vccd1 vccd1 _6761_/D sky130_fd_sc_hd__mux2_1
X_3337_ _3961_/A _5273_/A _5272_/A _3870_/A vssd1 vssd1 vccd1 vccd1 _3338_/B sky130_fd_sc_hd__a22o_1
XTAP_540 vssd1 vccd1 sky130_fd_sc_hd__tapvpwrvgnd_1
XTAP_551 vssd1 vccd1 sky130_fd_sc_hd__tapvpwrvgnd_1
XTAP_562 vssd1 vccd1 sky130_fd_sc_hd__tapvpwrvgnd_1
XTAP_573 vssd1 vccd1 sky130_fd_sc_hd__tapvpwrvgnd_1
XTAP_584 vssd1 vccd1 sky130_fd_sc_hd__tapvpwrvgnd_1
X_6056_ hold104/X _6539_/Q _6072_/S vssd1 vssd1 vccd1 vccd1 _6056_/X sky130_fd_sc_hd__mux2_1
XANTENNA__5463__B2 _5784_/S vssd1 vssd1 vccd1 vccd1 sky130_fd_sc_hd__diode_2
X_3268_ _6520_/Q vssd1 vssd1 vccd1 vccd1 _3268_/Y sky130_fd_sc_hd__inv_2
XTAP_595 vssd1 vccd1 sky130_fd_sc_hd__tapvpwrvgnd_1
X_5007_ _5018_/A vssd1 vssd1 vccd1 vccd1 _5007_/Y sky130_fd_sc_hd__inv_2
XANTENNA_108 sstream_i[7] vssd1 vssd1 vccd1 vccd1 sky130_fd_sc_hd__diode_2
XANTENNA_119 sstream_i[9] vssd1 vssd1 vccd1 vccd1 sky130_fd_sc_hd__diode_2
X_6958_ vssd1 vssd1 vccd1 vccd1 _6958_/HI tex_mport_o[11] sky130_fd_sc_hd__conb_1
XFILLER_0_48_231 vssd1 vssd1 vccd1 vccd1 sky130_fd_sc_hd__fill_1
XFILLER_0_48_253 vssd1 vssd1 vccd1 vccd1 sky130_fd_sc_hd__decap_8
X_6889_ _6892_/CLK _6889_/D vssd1 vssd1 vccd1 vccd1 hold85/A sky130_fd_sc_hd__dfxtp_1
XFILLER_0_63_212 vssd1 vssd1 vccd1 vccd1 sky130_fd_sc_hd__fill_2
X_5909_ _5909_/A _5909_/B vssd1 vssd1 vccd1 vccd1 _5909_/Y sky130_fd_sc_hd__xnor2_1
XFILLER_0_118_185 vssd1 vssd1 vccd1 vccd1 sky130_fd_sc_hd__fill_1
XFILLER_0_106_347 vssd1 vssd1 vccd1 vccd1 sky130_fd_sc_hd__fill_2
XFILLER_0_106_336 vssd1 vssd1 vccd1 vccd1 sky130_fd_sc_hd__decap_3
XFILLER_0_63_267 vssd1 vssd1 vccd1 vccd1 sky130_fd_sc_hd__fill_1
XFILLER_0_133_155 vssd1 vssd1 vccd1 vccd1 sky130_fd_sc_hd__fill_2
XFILLER_0_133_188 vssd1 vssd1 vccd1 vccd1 sky130_fd_sc_hd__decap_4
Xclkbuf_leaf_21_clk_i _6684_/CLK vssd1 vssd1 vccd1 vccd1 _6751_/CLK sky130_fd_sc_hd__clkbuf_16
XFILLER_0_31_164 vssd1 vssd1 vccd1 vccd1 sky130_fd_sc_hd__fill_2
XFILLER_0_6_3 vssd1 vssd1 vccd1 vccd1 sky130_ef_sc_hd__decap_12
XANTENNA__4257__A2 _4658_/D vssd1 vssd1 vccd1 vccd1 sky130_fd_sc_hd__diode_2
XFILLER_0_36_29 vssd1 vssd1 vccd1 vccd1 sky130_fd_sc_hd__decap_3
XANTENNA__6588__RESET_B fanout153/X vssd1 vssd1 vccd1 vccd1 sky130_fd_sc_hd__diode_2
XFILLER_0_39_253 vssd1 vssd1 vccd1 vccd1 sky130_fd_sc_hd__decap_6
XFILLER_0_54_201 vssd1 vssd1 vccd1 vccd1 sky130_fd_sc_hd__fill_2
XFILLER_0_22_131 vssd1 vssd1 vccd1 vccd1 sky130_fd_sc_hd__fill_2
XFILLER_0_77_14 vssd1 vssd1 vccd1 vccd1 sky130_fd_sc_hd__decap_4
XANTENNA__4487__B _4551_/D vssd1 vssd1 vccd1 vccd1 sky130_fd_sc_hd__diode_2
X_4240_ _4240_/A _4241_/A _4240_/C _4240_/D vssd1 vssd1 vccd1 vccd1 _4241_/B sky130_fd_sc_hd__nand4_1
XFILLER_0_10_359 vssd1 vssd1 vccd1 vccd1 sky130_fd_sc_hd__decap_4
XANTENNA__3886__A1_N _5299_/A vssd1 vssd1 vccd1 vccd1 sky130_fd_sc_hd__diode_2
X_4171_ _4842_/A _4966_/A _4966_/C _4841_/D vssd1 vssd1 vccd1 vccd1 _4171_/X sky130_fd_sc_hd__and4_1
XFILLER_0_89_131 vssd1 vssd1 vccd1 vccd1 sky130_fd_sc_hd__fill_1
XFILLER_0_26_40 vssd1 vssd1 vccd1 vccd1 sky130_fd_sc_hd__fill_2
XANTENNA__5599__A _5599_/A vssd1 vssd1 vccd1 vccd1 sky130_fd_sc_hd__diode_2
XFILLER_0_117_86 vssd1 vssd1 vccd1 vccd1 sky130_fd_sc_hd__fill_2
X_6812_ _6812_/CLK _6812_/D _6073_/A vssd1 vssd1 vccd1 vccd1 depth_mport_o[34] sky130_fd_sc_hd__dfrtp_4
XFILLER_0_89_197 vssd1 vssd1 vccd1 vccd1 sky130_fd_sc_hd__fill_2
XFILLER_0_9_125 vssd1 vssd1 vccd1 vccd1 sky130_fd_sc_hd__decap_6
XFILLER_0_133_63 vssd1 vssd1 vccd1 vccd1 sky130_fd_sc_hd__fill_2
X_3955_ _3949_/A _3949_/B _3949_/C vssd1 vssd1 vccd1 vccd1 _3956_/C sky130_fd_sc_hd__a21o_1
XFILLER_0_45_212 vssd1 vssd1 vccd1 vccd1 sky130_fd_sc_hd__fill_2
X_6743_ _6751_/CLK _6743_/D fanout139/X vssd1 vssd1 vccd1 vccd1 _6743_/Q sky130_fd_sc_hd__dfstp_1
XFILLER_0_9_169 vssd1 vssd1 vccd1 vccd1 sky130_fd_sc_hd__fill_2
X_6674_ _6677_/CLK _6674_/D vssd1 vssd1 vccd1 vccd1 _6674_/Q sky130_fd_sc_hd__dfxtp_1
XFILLER_0_115_122 vssd1 vssd1 vccd1 vccd1 sky130_fd_sc_hd__fill_2
X_5625_ _5754_/B _3270_/Y _3271_/Y _5732_/A vssd1 vssd1 vccd1 vccd1 _5625_/X sky130_fd_sc_hd__o22a_1
X_3886_ _5299_/A _5286_/B _3884_/Y _3885_/X vssd1 vssd1 vccd1 vccd1 _3888_/A sky130_fd_sc_hd__o2bb2a_1
XFILLER_0_5_353 vssd1 vssd1 vccd1 vccd1 sky130_fd_sc_hd__fill_2
XANTENNA__4184__A1 _4842_/A vssd1 vssd1 vccd1 vccd1 sky130_fd_sc_hd__diode_2
X_5556_ depth_mport_o[31] hold225/X _5556_/S vssd1 vssd1 vccd1 vccd1 _6587_/D sky130_fd_sc_hd__mux2_1
XFILLER_0_13_120 vssd1 vssd1 vccd1 vccd1 sky130_fd_sc_hd__decap_3
XANTENNA__4184__B2 _4971_/B vssd1 vssd1 vccd1 vccd1 sky130_fd_sc_hd__diode_2
X_4507_ _4507_/A _4507_/B vssd1 vssd1 vccd1 vccd1 _5361_/A sky130_fd_sc_hd__nor2_1
X_5487_ hold142/X sstream_i[78] _6501_/S vssd1 vssd1 vccd1 vccd1 _6520_/D sky130_fd_sc_hd__mux2_1
X_4438_ _4438_/A _4438_/B _4438_/C vssd1 vssd1 vccd1 vccd1 _4482_/A sky130_fd_sc_hd__nand3_1
XFILLER_0_6_83 vssd1 vssd1 vccd1 vccd1 sky130_fd_sc_hd__fill_1
XANTENNA__4828__D _5787_/A vssd1 vssd1 vccd1 vccd1 sky130_fd_sc_hd__diode_2
X_4369_ _4366_/A _4364_/Y _4356_/Y _4358_/Y vssd1 vssd1 vccd1 vccd1 _4370_/B sky130_fd_sc_hd__o211a_1
XTAP_392 vssd1 vccd1 sky130_fd_sc_hd__tapvpwrvgnd_1
XTAP_381 vssd1 vccd1 sky130_fd_sc_hd__tapvpwrvgnd_1
XTAP_370 vssd1 vccd1 sky130_fd_sc_hd__tapvpwrvgnd_1
X_6108_ _6647_/Q hold234/X _6113_/S vssd1 vssd1 vccd1 vccd1 _6108_/X sky130_fd_sc_hd__mux2_1
X_6039_ _5308_/A _6038_/B _6038_/Y vssd1 vssd1 vccd1 vccd1 _6678_/D sky130_fd_sc_hd__a21o_1
XANTENNA__3998__A1 _5093_/A vssd1 vssd1 vccd1 vccd1 sky130_fd_sc_hd__diode_2
XFILLER_0_68_315 vssd1 vssd1 vccd1 vccd1 sky130_fd_sc_hd__fill_1
XPHY_21 vssd1 vssd1 vccd1 vccd1 sky130_fd_sc_hd__decap_3
XPHY_10 vssd1 vssd1 vccd1 vccd1 sky130_fd_sc_hd__decap_3
XFILLER_0_138_225 vssd1 vssd1 vccd1 vccd1 sky130_fd_sc_hd__decap_6
XPHY_32 vssd1 vssd1 vccd1 vccd1 sky130_fd_sc_hd__decap_3
XPHY_43 vssd1 vssd1 vccd1 vccd1 sky130_fd_sc_hd__decap_3
XPHY_54 vssd1 vssd1 vccd1 vccd1 sky130_fd_sc_hd__decap_3
XPHY_65 vssd1 vssd1 vccd1 vccd1 sky130_fd_sc_hd__decap_3
XANTENNA__6610__RESET_B fanout140/X vssd1 vssd1 vccd1 vccd1 sky130_fd_sc_hd__diode_2
XPHY_76 vssd1 vssd1 vccd1 vccd1 sky130_fd_sc_hd__decap_3
XPHY_87 vssd1 vssd1 vccd1 vccd1 sky130_fd_sc_hd__decap_3
XPHY_98 vssd1 vssd1 vccd1 vccd1 sky130_fd_sc_hd__decap_3
XFILLER_0_91_373 vssd1 vssd1 vccd1 vccd1 sky130_ef_sc_hd__decap_12
XFILLER_0_36_256 vssd1 vssd1 vccd1 vccd1 sky130_ef_sc_hd__decap_12
XANTENNA__4175__A1 _4518_/D vssd1 vssd1 vccd1 vccd1 sky130_fd_sc_hd__diode_2
XFILLER_0_121_125 vssd1 vssd1 vccd1 vccd1 sky130_fd_sc_hd__fill_2
XFILLER_0_51_259 vssd1 vssd1 vccd1 vccd1 sky130_fd_sc_hd__decap_3
XANTENNA__4175__B2 _4476_/D vssd1 vssd1 vccd1 vccd1 sky130_fd_sc_hd__diode_2
XFILLER_0_121_169 vssd1 vssd1 vccd1 vccd1 sky130_fd_sc_hd__fill_2
XANTENNA__5911__S _5923_/S vssd1 vssd1 vccd1 vccd1 sky130_fd_sc_hd__diode_2
XANTENNA__6769__RESET_B fanout153/X vssd1 vssd1 vccd1 vccd1 sky130_fd_sc_hd__diode_2
XFILLER_0_59_304 vssd1 vssd1 vccd1 vccd1 sky130_fd_sc_hd__decap_6
XFILLER_0_129_225 vssd1 vssd1 vccd1 vccd1 sky130_ef_sc_hd__decap_12
XFILLER_0_27_201 vssd1 vssd1 vccd1 vccd1 sky130_fd_sc_hd__fill_2
XANTENNA_19 sstream_i[11] vssd1 vssd1 vccd1 vccd1 sky130_fd_sc_hd__diode_2
XANTENNA__3667__A _5290_/A vssd1 vssd1 vccd1 vccd1 sky130_fd_sc_hd__diode_2
X_3740_ _5049_/A _5300_/B _5106_/B _5049_/B vssd1 vssd1 vccd1 vccd1 _3741_/B sky130_fd_sc_hd__a22o_1
XFILLER_0_12_53 vssd1 vssd1 vccd1 vccd1 sky130_ef_sc_hd__decap_12
XFILLER_0_6_139 vssd1 vssd1 vccd1 vccd1 sky130_fd_sc_hd__fill_1
XFILLER_0_12_97 vssd1 vssd1 vccd1 vccd1 sky130_fd_sc_hd__decap_4
X_3671_ _3671_/A _3671_/B vssd1 vssd1 vccd1 vccd1 _3753_/B sky130_fd_sc_hd__xor2_1
X_6390_ _6390_/A _6390_/B vssd1 vssd1 vccd1 vccd1 _6410_/A sky130_fd_sc_hd__nor2_1
XFILLER_0_88_24 vssd1 vssd1 vccd1 vccd1 sky130_fd_sc_hd__fill_2
X_5410_ _5410_/A _5410_/B _5410_/C _5410_/D vssd1 vssd1 vccd1 vccd1 _5591_/C sky130_fd_sc_hd__nand4_1
XFILLER_0_88_79 vssd1 vssd1 vccd1 vccd1 sky130_fd_sc_hd__fill_2
XFILLER_0_88_68 vssd1 vssd1 vccd1 vccd1 sky130_fd_sc_hd__fill_2
XFILLER_0_88_57 vssd1 vssd1 vccd1 vccd1 sky130_fd_sc_hd__fill_2
X_5341_ _5340_/A _5591_/B _5340_/B vssd1 vssd1 vccd1 vccd1 _5342_/B sky130_fd_sc_hd__a21oi_1
XFILLER_0_112_169 vssd1 vssd1 vccd1 vccd1 sky130_fd_sc_hd__decap_3
X_5272_ _5272_/A _5272_/B vssd1 vssd1 vccd1 vccd1 _5280_/A sky130_fd_sc_hd__nand2_2
XFILLER_0_56_7 vssd1 vssd1 vccd1 vccd1 sky130_fd_sc_hd__decap_3
X_4223_ _4225_/A _4237_/A vssd1 vssd1 vccd1 vccd1 _4223_/Y sky130_fd_sc_hd__nand2_1
XANTENNA__5821__S _5922_/S vssd1 vssd1 vccd1 vccd1 sky130_fd_sc_hd__diode_2
X_4154_ _4154_/A _4154_/B vssd1 vssd1 vccd1 vccd1 _4163_/A sky130_fd_sc_hd__xnor2_1
XFILLER_0_128_85 vssd1 vssd1 vccd1 vccd1 sky130_fd_sc_hd__fill_2
X_4085_ _4086_/B _4086_/A vssd1 vssd1 vccd1 vccd1 _4088_/A sky130_fd_sc_hd__nand2b_1
XFILLER_0_37_94 vssd1 vssd1 vccd1 vccd1 sky130_fd_sc_hd__fill_2
XFILLER_0_77_167 vssd1 vssd1 vccd1 vccd1 sky130_fd_sc_hd__fill_1
X_6726_ _6863_/CLK _6726_/D fanout145/X vssd1 vssd1 vccd1 vccd1 _6726_/Q sky130_fd_sc_hd__dfstp_1
XFILLER_0_92_126 vssd1 vssd1 vccd1 vccd1 sky130_fd_sc_hd__fill_1
XFILLER_0_18_234 vssd1 vssd1 vccd1 vccd1 sky130_fd_sc_hd__fill_1
X_4987_ _4983_/X _4985_/Y _4855_/B _4855_/Y vssd1 vssd1 vccd1 vccd1 _4988_/C sky130_fd_sc_hd__o211a_1
X_3938_ _3938_/A _3938_/B vssd1 vssd1 vccd1 vccd1 _5264_/A sky130_fd_sc_hd__nand2_1
X_6657_ _6853_/CLK _6657_/D vssd1 vssd1 vccd1 vccd1 hold66/A sky130_fd_sc_hd__dfxtp_1
XFILLER_0_73_384 vssd1 vssd1 vccd1 vccd1 sky130_fd_sc_hd__decap_8
X_3869_ _3959_/B _5081_/C _5081_/D _5049_/D vssd1 vssd1 vccd1 vccd1 _3870_/D sky130_fd_sc_hd__a22o_1
XFILLER_0_33_204 vssd1 vssd1 vccd1 vccd1 sky130_fd_sc_hd__decap_3
XFILLER_0_33_215 vssd1 vssd1 vccd1 vccd1 sky130_fd_sc_hd__fill_1
X_6588_ _6792_/CLK _6588_/D fanout153/X vssd1 vssd1 vccd1 vccd1 tex_mport_o[64] sky130_fd_sc_hd__dfrtp_4
X_5608_ _3251_/Y _6507_/Q _6506_/Q _3250_/Y vssd1 vssd1 vccd1 vccd1 _5608_/X sky130_fd_sc_hd__o211a_1
XANTENNA__4157__B2 _4942_/B vssd1 vssd1 vccd1 vccd1 sky130_fd_sc_hd__diode_2
XANTENNA__4157__A1 _4942_/A vssd1 vssd1 vccd1 vccd1 sky130_fd_sc_hd__diode_2
X_5539_ depth_mport_o[14] hold155/X _5541_/S vssd1 vssd1 vccd1 vccd1 _6570_/D sky130_fd_sc_hd__mux2_1
XANTENNA__6400__B hold70/A vssd1 vssd1 vccd1 vccd1 sky130_fd_sc_hd__diode_2
XANTENNA__3380__A2 _5272_/B vssd1 vssd1 vccd1 vccd1 sky130_fd_sc_hd__diode_2
XFILLER_0_68_145 vssd1 vssd1 vccd1 vccd1 sky130_fd_sc_hd__fill_2
XFILLER_0_68_123 vssd1 vssd1 vccd1 vccd1 sky130_fd_sc_hd__fill_2
XFILLER_0_56_318 vssd1 vssd1 vccd1 vccd1 sky130_fd_sc_hd__fill_1
XFILLER_0_64_340 vssd1 vssd1 vccd1 vccd1 sky130_fd_sc_hd__decap_4
XFILLER_0_64_373 vssd1 vssd1 vccd1 vccd1 sky130_fd_sc_hd__fill_2
XFILLER_0_24_204 vssd1 vssd1 vccd1 vccd1 sky130_fd_sc_hd__decap_3
XFILLER_0_134_261 vssd1 vssd1 vccd1 vccd1 sky130_fd_sc_hd__fill_2
XFILLER_0_32_270 vssd1 vssd1 vccd1 vccd1 sky130_ef_sc_hd__decap_12
XFILLER_0_102_180 vssd1 vssd1 vccd1 vccd1 sky130_fd_sc_hd__decap_3
XANTENNA__4111__A _5311_/A vssd1 vssd1 vccd1 vccd1 sky130_fd_sc_hd__diode_2
XANTENNA__4468__D _4658_/D vssd1 vssd1 vccd1 vccd1 sky130_fd_sc_hd__diode_2
XANTENNA__3950__A _5766_/A vssd1 vssd1 vccd1 vccd1 sky130_fd_sc_hd__diode_2
XANTENNA_clkbuf_leaf_19_clk_i_A clkbuf_2_3__f_clk_i/X vssd1 vssd1 vccd1 vccd1 sky130_fd_sc_hd__diode_2
XANTENNA__4765__B _5666_/A vssd1 vssd1 vccd1 vccd1 sky130_fd_sc_hd__diode_2
XFILLER_0_99_281 vssd1 vssd1 vccd1 vccd1 sky130_fd_sc_hd__decap_4
XFILLER_0_90_36 vssd1 vssd1 vccd1 vccd1 sky130_fd_sc_hd__fill_2
XFILLER_0_90_25 vssd1 vssd1 vccd1 vccd1 sky130_fd_sc_hd__decap_3
X_4910_ _6637_/Q _5009_/B vssd1 vssd1 vccd1 vccd1 _5010_/A sky130_fd_sc_hd__nand2_1
X_5890_ tex_addr_i[27] _5913_/B vssd1 vssd1 vccd1 vccd1 _5892_/A sky130_fd_sc_hd__xnor2_1
XFILLER_0_59_167 vssd1 vssd1 vccd1 vccd1 sky130_fd_sc_hd__fill_1
X_4841_ _5801_/A _5787_/A _4841_/C _4841_/D vssd1 vssd1 vccd1 vccd1 _4844_/A sky130_fd_sc_hd__nand4_2
XFILLER_0_23_52 vssd1 vssd1 vccd1 vccd1 sky130_fd_sc_hd__fill_2
XFILLER_0_74_159 vssd1 vssd1 vccd1 vccd1 sky130_fd_sc_hd__fill_2
X_4772_ _4773_/B _4773_/A vssd1 vssd1 vccd1 vccd1 _4772_/Y sky130_fd_sc_hd__nand2b_1
XFILLER_0_132_209 vssd1 vssd1 vccd1 vccd1 sky130_fd_sc_hd__fill_1
X_6511_ _6834_/CLK _6511_/D vssd1 vssd1 vccd1 vccd1 _6511_/Q sky130_fd_sc_hd__dfxtp_1
XFILLER_0_15_204 vssd1 vssd1 vccd1 vccd1 sky130_fd_sc_hd__fill_2
X_3723_ _5308_/A _4944_/B _5296_/A _5276_/A vssd1 vssd1 vccd1 vccd1 _3725_/C sky130_fd_sc_hd__nand4_1
XFILLER_0_55_384 vssd1 vssd1 vccd1 vccd1 sky130_fd_sc_hd__decap_8
X_6442_ hold206/X sstream_i[0] _6450_/S vssd1 vssd1 vccd1 vccd1 _6833_/D sky130_fd_sc_hd__mux2_1
XFILLER_0_15_259 vssd1 vssd1 vccd1 vccd1 sky130_fd_sc_hd__fill_2
XFILLER_0_15_248 vssd1 vssd1 vccd1 vccd1 sky130_fd_sc_hd__fill_1
X_3654_ _3655_/A _3655_/B _3655_/C vssd1 vssd1 vccd1 vccd1 _3654_/Y sky130_fd_sc_hd__nor3_2
XFILLER_0_70_365 vssd1 vssd1 vccd1 vccd1 sky130_ef_sc_hd__decap_12
X_6373_ hold60/A _6543_/Q vssd1 vssd1 vccd1 vccd1 _6375_/A sky130_fd_sc_hd__nand2_1
X_3585_ _3585_/A _3585_/B _3585_/C vssd1 vssd1 vccd1 vccd1 _3587_/C sky130_fd_sc_hd__or3_2
XFILLER_0_23_281 vssd1 vssd1 vccd1 vccd1 sky130_fd_sc_hd__fill_2
XFILLER_0_100_139 vssd1 vssd1 vccd1 vccd1 sky130_fd_sc_hd__fill_1
X_5324_ _3488_/X _3492_/A _3999_/A _6690_/Q vssd1 vssd1 vccd1 vccd1 _5325_/B sky130_fd_sc_hd__o211a_1
XFILLER_0_2_197 vssd1 vssd1 vccd1 vccd1 sky130_fd_sc_hd__fill_1
X_5255_ _4017_/A _4015_/Y _4007_/X _4009_/Y vssd1 vssd1 vccd1 vccd1 _5255_/X sky130_fd_sc_hd__o211a_1
X_4206_ _4205_/B _4205_/C _4205_/A vssd1 vssd1 vccd1 vccd1 _4206_/X sky130_fd_sc_hd__a21o_1
XANTENNA__3860__A _5081_/A vssd1 vssd1 vccd1 vccd1 sky130_fd_sc_hd__diode_2
XFILLER_0_47_3 vssd1 vssd1 vccd1 vccd1 sky130_fd_sc_hd__fill_2
X_5186_ _4988_/B _4988_/Y _5173_/X _5185_/X vssd1 vssd1 vccd1 vccd1 _5197_/A sky130_fd_sc_hd__o211ai_4
X_4137_ _4614_/C _4822_/B vssd1 vssd1 vccd1 vccd1 _4209_/A sky130_fd_sc_hd__nand2_1
XFILLER_0_3_51 vssd1 vssd1 vccd1 vccd1 sky130_fd_sc_hd__decap_4
X_4068_ _4068_/A _4068_/B vssd1 vssd1 vccd1 vccd1 _4070_/A sky130_fd_sc_hd__nor2_1
XFILLER_0_64_70 vssd1 vssd1 vccd1 vccd1 sky130_fd_sc_hd__fill_2
XANTENNA__5787__A _5787_/A vssd1 vssd1 vccd1 vccd1 sky130_fd_sc_hd__diode_2
XANTENNA__4841__D _4841_/D vssd1 vssd1 vccd1 vccd1 sky130_fd_sc_hd__diode_2
XFILLER_0_65_159 vssd1 vssd1 vccd1 vccd1 sky130_fd_sc_hd__fill_2
X_6709_ _6818_/CLK hold35/X vssd1 vssd1 vccd1 vccd1 hold34/A sky130_fd_sc_hd__dfxtp_1
XANTENNA_hold215_A _6543_/Q vssd1 vssd1 vccd1 vccd1 sky130_fd_sc_hd__diode_2
XFILLER_0_80_118 vssd1 vssd1 vccd1 vccd1 sky130_fd_sc_hd__decap_3
XFILLER_0_104_401 vssd1 vssd1 vccd1 vccd1 sky130_fd_sc_hd__decap_6
XFILLER_0_73_181 vssd1 vssd1 vccd1 vccd1 sky130_fd_sc_hd__fill_1
XANTENNA__4550__A1 _4816_/B vssd1 vssd1 vccd1 vccd1 sky130_fd_sc_hd__diode_2
Xfanout150 fanout153/X vssd1 vssd1 vccd1 vccd1 fanout150/X sky130_fd_sc_hd__clkbuf_8
XANTENNA_clkbuf_leaf_20_clk_i_A _6684_/CLK vssd1 vssd1 vccd1 vccd1 sky130_fd_sc_hd__diode_2
XANTENNA__6055__A1 hold75/X vssd1 vssd1 vccd1 vccd1 sky130_fd_sc_hd__diode_2
XANTENNA__4066__B1 _4789_/C vssd1 vssd1 vccd1 vccd1 sky130_fd_sc_hd__diode_2
XTAP_1141 vssd1 vccd1 sky130_fd_sc_hd__tapvpwrvgnd_1
XTAP_1130 vssd1 vccd1 sky130_fd_sc_hd__tapvpwrvgnd_1
XFILLER_0_96_273 vssd1 vssd1 vccd1 vccd1 sky130_fd_sc_hd__decap_3
XFILLER_0_29_318 vssd1 vssd1 vccd1 vccd1 sky130_fd_sc_hd__decap_8
XTAP_1174 vssd1 vccd1 sky130_fd_sc_hd__tapvpwrvgnd_1
XTAP_1163 vssd1 vccd1 sky130_fd_sc_hd__tapvpwrvgnd_1
XTAP_1152 vssd1 vccd1 sky130_fd_sc_hd__tapvpwrvgnd_1
XFILLER_0_56_137 vssd1 vssd1 vccd1 vccd1 sky130_fd_sc_hd__decap_3
XTAP_1196 vssd1 vccd1 sky130_fd_sc_hd__tapvpwrvgnd_1
XTAP_1185 vssd1 vccd1 sky130_fd_sc_hd__tapvpwrvgnd_1
XANTENNA__3367__D _5296_/B vssd1 vssd1 vccd1 vccd1 sky130_fd_sc_hd__diode_2
XFILLER_0_8_29 vssd1 vssd1 vccd1 vccd1 sky130_ef_sc_hd__decap_12
XFILLER_0_12_229 vssd1 vssd1 vccd1 vccd1 sky130_fd_sc_hd__fill_1
XFILLER_0_52_398 vssd1 vssd1 vccd1 vccd1 sky130_fd_sc_hd__decap_8
XFILLER_0_122_297 vssd1 vssd1 vccd1 vccd1 sky130_fd_sc_hd__fill_1
X_3370_ _5311_/A _5276_/B _3370_/C _3370_/D vssd1 vssd1 vccd1 vccd1 _3384_/A sky130_fd_sc_hd__and4_1
XTAP_925 vssd1 vccd1 sky130_fd_sc_hd__tapvpwrvgnd_1
XTAP_914 vssd1 vccd1 sky130_fd_sc_hd__tapvpwrvgnd_1
XTAP_903 vssd1 vccd1 sky130_fd_sc_hd__tapvpwrvgnd_1
XANTENNA__4776__A _4776_/A vssd1 vssd1 vccd1 vccd1 sky130_fd_sc_hd__diode_2
XTAP_958 vssd1 vccd1 sky130_fd_sc_hd__tapvpwrvgnd_1
XTAP_947 vssd1 vccd1 sky130_fd_sc_hd__tapvpwrvgnd_1
XTAP_936 vssd1 vccd1 sky130_fd_sc_hd__tapvpwrvgnd_1
X_5040_ _4714_/Y _4715_/Y _5039_/X vssd1 vssd1 vccd1 vccd1 _5425_/A sky130_fd_sc_hd__a21o_1
XTAP_969 vssd1 vccd1 sky130_fd_sc_hd__tapvpwrvgnd_1
XANTENNA__6046__A1 _5276_/B vssd1 vssd1 vccd1 vccd1 sky130_fd_sc_hd__diode_2
XFILLER_0_18_85 vssd1 vssd1 vccd1 vccd1 sky130_fd_sc_hd__decap_3
XFILLER_0_79_229 vssd1 vssd1 vccd1 vccd1 sky130_fd_sc_hd__fill_1
X_5942_ _3283_/Y tex_height_i[10] _3284_/Y tex_height_i[9] vssd1 vssd1 vccd1 vccd1
+ _5942_/X sky130_fd_sc_hd__o22a_1
XFILLER_0_87_262 vssd1 vssd1 vccd1 vccd1 sky130_fd_sc_hd__fill_2
XANTENNA__3804__B1 _5081_/D vssd1 vssd1 vccd1 vccd1 sky130_fd_sc_hd__diode_2
XANTENNA__4942__C _5083_/A vssd1 vssd1 vccd1 vccd1 sky130_fd_sc_hd__diode_2
X_5873_ hold162/X _5872_/Y _5923_/S vssd1 vssd1 vccd1 vccd1 _6645_/D sky130_fd_sc_hd__mux2_1
XFILLER_0_28_340 vssd1 vssd1 vccd1 vccd1 sky130_ef_sc_hd__decap_12
X_4824_ _4970_/B _4966_/A _4966_/B vssd1 vssd1 vccd1 vccd1 _4824_/X sky130_fd_sc_hd__and3_1
X_4755_ _4158_/A _4158_/C _4158_/B vssd1 vssd1 vccd1 vccd1 _4757_/B sky130_fd_sc_hd__a21bo_1
X_3706_ _3706_/A _3706_/B vssd1 vssd1 vccd1 vccd1 _3721_/A sky130_fd_sc_hd__xor2_1
XANTENNA_fanout120_A _4832_/C vssd1 vssd1 vccd1 vccd1 sky130_fd_sc_hd__diode_2
XANTENNA__4780__A1 _4971_/B vssd1 vssd1 vccd1 vccd1 sky130_fd_sc_hd__diode_2
XFILLER_0_50_83 vssd1 vssd1 vccd1 vccd1 sky130_fd_sc_hd__fill_1
X_4686_ _4686_/A _4686_/B vssd1 vssd1 vccd1 vccd1 _5378_/A sky130_fd_sc_hd__xor2_2
XANTENNA__4780__B2 _4971_/D vssd1 vssd1 vccd1 vccd1 sky130_fd_sc_hd__diode_2
X_6425_ _6425_/A _6425_/B vssd1 vssd1 vccd1 vccd1 _6426_/B sky130_fd_sc_hd__and2_1
X_3637_ _3637_/A _3637_/B vssd1 vssd1 vccd1 vccd1 _3639_/A sky130_fd_sc_hd__nand2_1
X_6356_ _6365_/A _6355_/C _6346_/B vssd1 vssd1 vccd1 vccd1 _6356_/X sky130_fd_sc_hd__a21bo_1
XFILLER_0_11_240 vssd1 vssd1 vccd1 vccd1 sky130_fd_sc_hd__fill_2
X_3568_ _5081_/A _5308_/B _5277_/B _5081_/B vssd1 vssd1 vccd1 vccd1 _3569_/B sky130_fd_sc_hd__a22o_1
XFILLER_0_11_273 vssd1 vssd1 vccd1 vccd1 sky130_fd_sc_hd__fill_2
X_5307_ _5307_/A _5307_/B vssd1 vssd1 vccd1 vccd1 _5313_/A sky130_fd_sc_hd__xnor2_1
XFILLER_0_59_81 vssd1 vssd1 vccd1 vccd1 sky130_fd_sc_hd__decap_4
XFILLER_0_59_92 vssd1 vssd1 vccd1 vccd1 sky130_fd_sc_hd__fill_2
X_6287_ depth_mport_i[30] _3295_/Y depth_mport_i[29] _3297_/Y vssd1 vssd1 vccd1 vccd1
+ _6287_/X sky130_fd_sc_hd__a22o_1
X_3499_ _5320_/A _5276_/B vssd1 vssd1 vccd1 vccd1 _3502_/A sky130_fd_sc_hd__nand2_1
X_5238_ _5238_/A _5445_/B _5416_/A _5425_/C vssd1 vssd1 vccd1 vccd1 _5239_/B sky130_fd_sc_hd__or4_1
X_5169_ _4984_/B _4984_/Y _5156_/Y _5167_/X vssd1 vssd1 vccd1 vccd1 _5169_/X sky130_fd_sc_hd__a211o_1
XFILLER_0_78_251 vssd1 vssd1 vccd1 vccd1 sky130_fd_sc_hd__fill_1
XFILLER_0_38_104 vssd1 vssd1 vccd1 vccd1 sky130_fd_sc_hd__fill_2
XPHY_224 vssd1 vssd1 vccd1 vccd1 sky130_fd_sc_hd__decap_3
XPHY_213 vssd1 vssd1 vccd1 vccd1 sky130_fd_sc_hd__decap_3
XPHY_202 vssd1 vssd1 vccd1 vccd1 sky130_fd_sc_hd__decap_3
XANTENNA_fanout33_A _3261_/Y vssd1 vssd1 vccd1 vccd1 sky130_fd_sc_hd__diode_2
XFILLER_0_91_90 vssd1 vssd1 vccd1 vccd1 sky130_fd_sc_hd__fill_2
XANTENNA__3749__B _5276_/B vssd1 vssd1 vccd1 vccd1 sky130_fd_sc_hd__diode_2
XPHY_268 vssd1 vssd1 vccd1 vccd1 sky130_fd_sc_hd__decap_3
XPHY_257 vssd1 vssd1 vccd1 vccd1 sky130_fd_sc_hd__decap_3
XPHY_246 vssd1 vssd1 vccd1 vccd1 sky130_fd_sc_hd__decap_3
XPHY_235 vssd1 vssd1 vccd1 vccd1 sky130_fd_sc_hd__decap_3
XFILLER_0_81_405 vssd1 vssd1 vccd1 vccd1 sky130_fd_sc_hd__fill_2
XFILLER_0_19_351 vssd1 vssd1 vccd1 vccd1 sky130_fd_sc_hd__fill_1
XFILLER_0_38_148 vssd1 vssd1 vccd1 vccd1 sky130_fd_sc_hd__fill_2
XFILLER_0_136_345 vssd1 vssd1 vccd1 vccd1 sky130_fd_sc_hd__fill_2
XFILLER_0_46_181 vssd1 vssd1 vccd1 vccd1 sky130_fd_sc_hd__fill_2
XFILLER_0_104_253 vssd1 vssd1 vccd1 vccd1 sky130_fd_sc_hd__fill_1
XFILLER_0_34_387 vssd1 vssd1 vccd1 vccd1 sky130_ef_sc_hd__decap_12
XFILLER_0_104_297 vssd1 vssd1 vccd1 vccd1 sky130_fd_sc_hd__decap_3
XANTENNA__5079__A2 _5064_/B vssd1 vssd1 vccd1 vccd1 sky130_fd_sc_hd__diode_2
Xhold6 hold6/A vssd1 vssd1 vccd1 vccd1 hold6/X sky130_fd_sc_hd__dlygate4sd3_1
XANTENNA__4039__B1 _4736_/D vssd1 vssd1 vccd1 vccd1 sky130_fd_sc_hd__diode_2
XANTENNA__3659__B _5049_/B vssd1 vssd1 vccd1 vccd1 sky130_fd_sc_hd__diode_2
XFILLER_0_127_323 vssd1 vssd1 vccd1 vccd1 sky130_fd_sc_hd__fill_2
XFILLER_0_29_148 vssd1 vssd1 vccd1 vccd1 sky130_fd_sc_hd__fill_2
XFILLER_0_127_345 vssd1 vssd1 vccd1 vccd1 sky130_fd_sc_hd__decap_3
XFILLER_0_25_310 vssd1 vssd1 vccd1 vccd1 sky130_fd_sc_hd__fill_1
XFILLER_0_111_11 vssd1 vssd1 vccd1 vccd1 sky130_fd_sc_hd__fill_2
XFILLER_0_4_204 vssd1 vssd1 vccd1 vccd1 sky130_fd_sc_hd__fill_2
XFILLER_0_37_192 vssd1 vssd1 vccd1 vccd1 sky130_fd_sc_hd__fill_2
XFILLER_0_105_3 vssd1 vssd1 vccd1 vccd1 sky130_fd_sc_hd__fill_2
X_4540_ _4541_/A _4541_/B _4541_/C vssd1 vssd1 vccd1 vccd1 _4574_/A sky130_fd_sc_hd__and3_1
XFILLER_0_111_66 vssd1 vssd1 vccd1 vccd1 sky130_fd_sc_hd__fill_2
X_4471_ _4471_/A _4471_/B _4471_/C vssd1 vssd1 vccd1 vccd1 _4515_/A sky130_fd_sc_hd__nand3_1
XFILLER_0_52_184 vssd1 vssd1 vccd1 vccd1 sky130_fd_sc_hd__fill_2
X_6210_ _6791_/Q _6792_/Q hold49/A vssd1 vssd1 vccd1 vccd1 _6210_/X sky130_fd_sc_hd__and3_1
X_3422_ _5320_/A _5286_/B _3419_/Y _3470_/A vssd1 vssd1 vccd1 vccd1 _3423_/B sky130_fd_sc_hd__o2bb2a_1
X_6141_ hold69/A _6150_/A _6141_/C vssd1 vssd1 vccd1 vccd1 _6152_/A sky130_fd_sc_hd__nand3_1
XTAP_700 vssd1 vccd1 sky130_fd_sc_hd__tapvpwrvgnd_1
XFILLER_0_110_289 vssd1 vssd1 vccd1 vccd1 sky130_fd_sc_hd__fill_2
XTAP_733 vssd1 vccd1 sky130_fd_sc_hd__tapvpwrvgnd_1
XTAP_722 vssd1 vccd1 sky130_fd_sc_hd__tapvpwrvgnd_1
X_3353_ _3353_/A _3353_/B vssd1 vssd1 vccd1 vccd1 _3606_/B sky130_fd_sc_hd__xnor2_1
XTAP_711 vssd1 vccd1 sky130_fd_sc_hd__tapvpwrvgnd_1
X_6072_ hold40/X _6555_/Q _6072_/S vssd1 vssd1 vccd1 vccd1 hold41/A sky130_fd_sc_hd__mux2_1
XTAP_777 vssd1 vccd1 sky130_fd_sc_hd__tapvpwrvgnd_1
XTAP_766 vssd1 vccd1 sky130_fd_sc_hd__tapvpwrvgnd_1
XTAP_755 vssd1 vccd1 sky130_fd_sc_hd__tapvpwrvgnd_1
XTAP_744 vssd1 vccd1 sky130_fd_sc_hd__tapvpwrvgnd_1
X_3284_ _6874_/Q vssd1 vssd1 vccd1 vccd1 _3284_/Y sky130_fd_sc_hd__inv_2
XTAP_799 vssd1 vccd1 sky130_fd_sc_hd__tapvpwrvgnd_1
XTAP_788 vssd1 vccd1 sky130_fd_sc_hd__tapvpwrvgnd_1
XANTENNA__4817__A2 _4816_/B vssd1 vssd1 vccd1 vccd1 sky130_fd_sc_hd__diode_2
X_5023_ _5020_/Y _5022_/X _4924_/X _5003_/Y vssd1 vssd1 vccd1 vccd1 _5354_/B sky130_fd_sc_hd__o211ai_2
X_6974_ vssd1 vssd1 vccd1 vccd1 _6974_/HI tex_mport_o[27] sky130_fd_sc_hd__conb_1
X_5925_ hold110/X tex_mport_i[0] _5932_/S vssd1 vssd1 vccd1 vccd1 _6653_/D sky130_fd_sc_hd__mux2_1
XFILLER_0_0_41 vssd1 vssd1 vccd1 vccd1 sky130_ef_sc_hd__decap_12
XFILLER_0_63_405 vssd1 vssd1 vccd1 vccd1 sky130_fd_sc_hd__fill_2
XFILLER_0_0_85 vssd1 vssd1 vccd1 vccd1 sky130_ef_sc_hd__decap_12
X_5856_ hold177/X _5855_/X _5923_/S vssd1 vssd1 vccd1 vccd1 _6643_/D sky130_fd_sc_hd__mux2_1
XFILLER_0_75_287 vssd1 vssd1 vccd1 vccd1 sky130_fd_sc_hd__fill_2
XFILLER_0_35_118 vssd1 vssd1 vccd1 vccd1 sky130_fd_sc_hd__fill_2
X_4807_ _4804_/Y _4805_/X _4752_/B _4754_/B vssd1 vssd1 vccd1 vccd1 _4872_/B sky130_fd_sc_hd__o211ai_2
X_5787_ _5787_/A _5787_/B _5787_/C vssd1 vssd1 vccd1 vccd1 _5802_/C sky130_fd_sc_hd__or3_4
XFILLER_0_133_359 vssd1 vssd1 vccd1 vccd1 sky130_fd_sc_hd__decap_4
XFILLER_0_133_337 vssd1 vssd1 vccd1 vccd1 sky130_ef_sc_hd__decap_12
XFILLER_0_16_365 vssd1 vssd1 vccd1 vccd1 sky130_fd_sc_hd__fill_1
X_4738_ _4944_/B _5656_/A vssd1 vssd1 vccd1 vccd1 _4739_/B sky130_fd_sc_hd__nand2_1
X_4669_ _4670_/A _4670_/B _4668_/X vssd1 vssd1 vccd1 vccd1 _4669_/X sky130_fd_sc_hd__o21ba_1
XFILLER_0_16_387 vssd1 vssd1 vccd1 vccd1 sky130_ef_sc_hd__decap_12
XFILLER_0_31_335 vssd1 vssd1 vccd1 vccd1 sky130_fd_sc_hd__fill_1
XFILLER_0_43_173 vssd1 vssd1 vccd1 vccd1 sky130_fd_sc_hd__fill_1
X_6408_ _6408_/A _6408_/B vssd1 vssd1 vccd1 vccd1 _6413_/A sky130_fd_sc_hd__xnor2_1
X_6339_ _6539_/Q hold44/A vssd1 vssd1 vccd1 vccd1 _6350_/A sky130_fd_sc_hd__nand2_1
XANTENNA__6022__A_N _6038_/C vssd1 vssd1 vccd1 vccd1 sky130_fd_sc_hd__diode_2
XANTENNA__4582__C _4614_/C vssd1 vssd1 vccd1 vccd1 sky130_fd_sc_hd__diode_2
XFILLER_0_128_109 vssd1 vssd1 vccd1 vccd1 sky130_fd_sc_hd__fill_2
XFILLER_0_109_312 vssd1 vssd1 vccd1 vccd1 sky130_fd_sc_hd__fill_2
XFILLER_0_66_243 vssd1 vssd1 vccd1 vccd1 sky130_fd_sc_hd__fill_2
XFILLER_0_109_334 vssd1 vssd1 vccd1 vccd1 sky130_fd_sc_hd__fill_2
XFILLER_0_54_405 vssd1 vssd1 vccd1 vccd1 sky130_fd_sc_hd__fill_2
XFILLER_0_109_378 vssd1 vssd1 vccd1 vccd1 sky130_ef_sc_hd__decap_12
XFILLER_0_81_246 vssd1 vssd1 vccd1 vccd1 sky130_ef_sc_hd__decap_12
XFILLER_0_136_197 vssd1 vssd1 vccd1 vccd1 sky130_fd_sc_hd__fill_1
XANTENNA__6739__SET_B _5937_/A vssd1 vssd1 vccd1 vccd1 sky130_fd_sc_hd__diode_2
XFILLER_0_66_38 vssd1 vssd1 vccd1 vccd1 sky130_fd_sc_hd__fill_2
XANTENNA__4476__D _4476_/D vssd1 vssd1 vccd1 vccd1 sky130_fd_sc_hd__diode_2
XFILLER_0_89_335 vssd1 vssd1 vccd1 vccd1 sky130_fd_sc_hd__fill_1
XANTENNA__5588__C _5588_/C vssd1 vssd1 vccd1 vccd1 sky130_fd_sc_hd__diode_2
XANTENNA__6421__A1 hold7/A vssd1 vssd1 vccd1 vccd1 sky130_fd_sc_hd__diode_2
XFILLER_0_106_55 vssd1 vssd1 vccd1 vccd1 sky130_fd_sc_hd__fill_2
XFILLER_0_15_64 vssd1 vssd1 vccd1 vccd1 sky130_fd_sc_hd__decap_3
X_3971_ _3958_/A _3958_/B _3958_/C vssd1 vssd1 vccd1 vccd1 _3973_/C sky130_fd_sc_hd__a21oi_1
XFILLER_0_57_221 vssd1 vssd1 vccd1 vccd1 sky130_fd_sc_hd__decap_3
X_5710_ _5709_/Y _6513_/Q _5802_/B vssd1 vssd1 vccd1 vccd1 _5712_/B sky130_fd_sc_hd__mux2_1
XANTENNA__3786__A2 _4966_/B vssd1 vssd1 vccd1 vccd1 sky130_fd_sc_hd__diode_2
XFILLER_0_72_202 vssd1 vssd1 vccd1 vccd1 sky130_fd_sc_hd__decap_4
X_6690_ _6693_/CLK _6690_/D vssd1 vssd1 vccd1 vccd1 _6690_/Q sky130_fd_sc_hd__dfxtp_2
XFILLER_0_45_405 vssd1 vssd1 vccd1 vccd1 sky130_fd_sc_hd__fill_2
XFILLER_0_57_265 vssd1 vssd1 vccd1 vccd1 sky130_fd_sc_hd__decap_3
X_5641_ tex_addr_i[0] _5640_/B _5784_/S vssd1 vssd1 vccd1 vccd1 _5641_/X sky130_fd_sc_hd__o21a_1
XFILLER_0_72_235 vssd1 vssd1 vccd1 vccd1 sky130_fd_sc_hd__decap_4
XFILLER_0_115_337 vssd1 vssd1 vccd1 vccd1 sky130_fd_sc_hd__fill_2
X_5572_ _5728_/B tex_mport_o[40] _5576_/S vssd1 vssd1 vccd1 vccd1 _6597_/D sky130_fd_sc_hd__mux2_1
XFILLER_0_72_268 vssd1 vssd1 vccd1 vccd1 sky130_fd_sc_hd__fill_2
XANTENNA__4735__B2 _4789_/C vssd1 vssd1 vccd1 vccd1 sky130_fd_sc_hd__diode_2
XANTENNA__4735__A1 _5071_/A vssd1 vssd1 vccd1 vccd1 sky130_fd_sc_hd__diode_2
X_4523_ _4522_/B _4522_/C _4522_/A vssd1 vssd1 vccd1 vccd1 _4524_/C sky130_fd_sc_hd__a21bo_1
Xhold225 _6864_/Q vssd1 vssd1 vccd1 vccd1 hold225/X sky130_fd_sc_hd__dlygate4sd3_1
Xhold203 _6138_/X vssd1 vssd1 vccd1 vccd1 _6767_/D sky130_fd_sc_hd__dlygate4sd3_1
Xhold214 _6546_/Q vssd1 vssd1 vccd1 vccd1 hold214/X sky130_fd_sc_hd__dlygate4sd3_1
Xclkbuf_leaf_2_clk_i clkbuf_leaf_9_clk_i/A vssd1 vssd1 vccd1 vccd1 _6627_/CLK sky130_fd_sc_hd__clkbuf_16
XFILLER_0_80_290 vssd1 vssd1 vccd1 vccd1 sky130_fd_sc_hd__fill_2
XFILLER_0_40_121 vssd1 vssd1 vccd1 vccd1 sky130_fd_sc_hd__fill_2
XFILLER_0_40_154 vssd1 vssd1 vccd1 vccd1 sky130_fd_sc_hd__decap_3
Xhold258 _6722_/Q vssd1 vssd1 vccd1 vccd1 hold258/X sky130_fd_sc_hd__dlygate4sd3_1
Xhold269 _6093_/X vssd1 vssd1 vccd1 vccd1 _6731_/D sky130_fd_sc_hd__dlygate4sd3_1
X_4454_ _4454_/A _4454_/B vssd1 vssd1 vccd1 vccd1 _4455_/B sky130_fd_sc_hd__or2_1
Xhold236 _6634_/Q vssd1 vssd1 vccd1 vccd1 hold236/X sky130_fd_sc_hd__dlygate4sd3_1
Xhold247 _6098_/X vssd1 vssd1 vccd1 vccd1 _6736_/D sky130_fd_sc_hd__dlygate4sd3_1
X_4385_ _4386_/A _4385_/B _4385_/C vssd1 vssd1 vccd1 vccd1 _4440_/A sky130_fd_sc_hd__nand3_1
X_3405_ _3999_/A _6687_/Q _3387_/X _3390_/B vssd1 vssd1 vccd1 vccd1 _3406_/B sky130_fd_sc_hd__a211o_1
X_6124_ pix_mport_o[32] hold48/X _6224_/B vssd1 vssd1 vccd1 vccd1 _6760_/D sky130_fd_sc_hd__mux2_1
X_3336_ _3870_/A _3961_/A _5273_/A _5272_/A vssd1 vssd1 vccd1 vccd1 _3338_/A sky130_fd_sc_hd__nand4_1
XTAP_530 vssd1 vccd1 sky130_fd_sc_hd__tapvpwrvgnd_1
XTAP_541 vssd1 vccd1 sky130_fd_sc_hd__tapvpwrvgnd_1
XTAP_552 vssd1 vccd1 sky130_fd_sc_hd__tapvpwrvgnd_1
X_6055_ hold55/X hold75/X _6072_/S vssd1 vssd1 vccd1 vccd1 _6694_/D sky130_fd_sc_hd__mux2_1
XTAP_563 vssd1 vccd1 sky130_fd_sc_hd__tapvpwrvgnd_1
XTAP_574 vssd1 vccd1 sky130_fd_sc_hd__tapvpwrvgnd_1
XTAP_585 vssd1 vccd1 sky130_fd_sc_hd__tapvpwrvgnd_1
X_3267_ _6521_/Q vssd1 vssd1 vccd1 vccd1 _3267_/Y sky130_fd_sc_hd__inv_2
X_5006_ _4217_/A _4217_/Y _4904_/Y _5005_/X vssd1 vssd1 vccd1 vccd1 _5018_/A sky130_fd_sc_hd__o211ai_4
XTAP_596 vssd1 vccd1 sky130_fd_sc_hd__tapvpwrvgnd_1
XANTENNA_109 sstream_i[7] vssd1 vssd1 vccd1 vccd1 sky130_fd_sc_hd__diode_2
X_6957_ vssd1 vssd1 vccd1 vccd1 _6957_/HI tex_mport_o[10] sky130_fd_sc_hd__conb_1
XFILLER_0_48_210 vssd1 vssd1 vccd1 vccd1 sky130_fd_sc_hd__fill_2
X_6888_ _6892_/CLK _6888_/D vssd1 vssd1 vccd1 vccd1 hold14/A sky130_fd_sc_hd__dfxtp_1
X_5908_ _5902_/A _5902_/B _5897_/B vssd1 vssd1 vccd1 vccd1 _5909_/B sky130_fd_sc_hd__o21ai_1
XFILLER_0_48_276 vssd1 vssd1 vccd1 vccd1 sky130_fd_sc_hd__fill_1
XFILLER_0_63_246 vssd1 vssd1 vccd1 vccd1 sky130_fd_sc_hd__fill_2
X_5839_ tex_addr_i[16] tex_addr_i[17] tex_addr_i[18] tex_addr_i[19] _5882_/B vssd1
+ vssd1 vccd1 vccd1 _5841_/B sky130_fd_sc_hd__o41ai_1
XANTENNA__6816__RESET_B fanout153/X vssd1 vssd1 vccd1 vccd1 sky130_fd_sc_hd__diode_2
XFILLER_0_31_154 vssd1 vssd1 vccd1 vccd1 sky130_fd_sc_hd__decap_4
XFILLER_0_98_132 vssd1 vssd1 vccd1 vccd1 sky130_fd_sc_hd__fill_1
XFILLER_0_98_187 vssd1 vssd1 vccd1 vccd1 sky130_fd_sc_hd__fill_1
XFILLER_0_86_316 vssd1 vssd1 vccd1 vccd1 sky130_fd_sc_hd__fill_2
XFILLER_0_39_210 vssd1 vssd1 vccd1 vccd1 sky130_fd_sc_hd__fill_2
XFILLER_0_27_405 vssd1 vssd1 vccd1 vccd1 sky130_fd_sc_hd__fill_2
XFILLER_0_54_235 vssd1 vssd1 vccd1 vccd1 sky130_fd_sc_hd__fill_2
XFILLER_0_62_290 vssd1 vssd1 vccd1 vccd1 sky130_fd_sc_hd__fill_1
XANTENNA__3953__A _5081_/A vssd1 vssd1 vccd1 vccd1 sky130_fd_sc_hd__diode_2
XFILLER_0_105_381 vssd1 vssd1 vccd1 vccd1 sky130_fd_sc_hd__decap_8
X_4170_ _4170_/A _4170_/B vssd1 vssd1 vccd1 vccd1 _4181_/A sky130_fd_sc_hd__nand2_1
XFILLER_0_89_110 vssd1 vssd1 vccd1 vccd1 sky130_fd_sc_hd__fill_2
XFILLER_0_89_154 vssd1 vssd1 vccd1 vccd1 sky130_fd_sc_hd__fill_2
X_6811_ _6818_/CLK _6811_/D fanout150/X vssd1 vssd1 vccd1 vccd1 hold71/A sky130_fd_sc_hd__dfrtp_4
XFILLER_0_26_85 vssd1 vssd1 vccd1 vccd1 sky130_fd_sc_hd__decap_3
XFILLER_0_18_405 vssd1 vssd1 vccd1 vccd1 sky130_fd_sc_hd__fill_2
X_3954_ _3954_/A _3954_/B vssd1 vssd1 vccd1 vccd1 _3956_/B sky130_fd_sc_hd__xnor2_1
X_6742_ _6745_/CLK _6742_/D fanout139/X vssd1 vssd1 vccd1 vccd1 _6742_/Q sky130_fd_sc_hd__dfstp_1
XANTENNA__6223__B _6223_/B vssd1 vssd1 vccd1 vccd1 sky130_fd_sc_hd__diode_2
XFILLER_0_133_97 vssd1 vssd1 vccd1 vccd1 sky130_fd_sc_hd__fill_1
XFILLER_0_85_393 vssd1 vssd1 vccd1 vccd1 sky130_ef_sc_hd__decap_12
X_6673_ _6677_/CLK _6673_/D vssd1 vssd1 vccd1 vccd1 _6673_/Q sky130_fd_sc_hd__dfxtp_1
X_3885_ _5290_/A _5091_/B _6684_/Q _6685_/Q vssd1 vssd1 vccd1 vccd1 _3885_/X sky130_fd_sc_hd__and4_1
X_5624_ _3256_/Y _6517_/Q _3270_/Y _4822_/B vssd1 vssd1 vccd1 vccd1 _5626_/C sky130_fd_sc_hd__a2bb2o_1
XFILLER_0_45_279 vssd1 vssd1 vccd1 vccd1 sky130_fd_sc_hd__fill_1
XFILLER_0_60_227 vssd1 vssd1 vccd1 vccd1 sky130_fd_sc_hd__decap_3
X_5555_ depth_mport_o[30] hold141/X _5556_/S vssd1 vssd1 vccd1 vccd1 _6586_/D sky130_fd_sc_hd__mux2_1
XFILLER_0_115_178 vssd1 vssd1 vccd1 vccd1 sky130_fd_sc_hd__fill_2
XFILLER_0_115_167 vssd1 vssd1 vccd1 vccd1 sky130_fd_sc_hd__fill_1
XANTENNA__3863__A _4794_/B vssd1 vssd1 vccd1 vccd1 sky130_fd_sc_hd__diode_2
XANTENNA__4184__A2 _4966_/A vssd1 vssd1 vccd1 vccd1 sky130_fd_sc_hd__diode_2
XFILLER_0_130_137 vssd1 vssd1 vccd1 vccd1 sky130_fd_sc_hd__decap_3
X_4506_ _4460_/Y _4503_/X _4509_/A _4500_/Y vssd1 vssd1 vccd1 vccd1 _4507_/B sky130_fd_sc_hd__o211a_1
XFILLER_0_77_3 vssd1 vssd1 vccd1 vccd1 sky130_fd_sc_hd__fill_2
X_5486_ hold126/X sstream_i[77] _6486_/S vssd1 vssd1 vccd1 vccd1 _6519_/D sky130_fd_sc_hd__mux2_1
XFILLER_0_13_165 vssd1 vssd1 vccd1 vccd1 sky130_fd_sc_hd__decap_3
X_4437_ _4431_/A _4431_/B _4431_/C vssd1 vssd1 vccd1 vccd1 _4438_/C sky130_fd_sc_hd__a21o_1
XFILLER_0_13_187 vssd1 vssd1 vccd1 vccd1 sky130_fd_sc_hd__fill_2
X_4368_ _4713_/B _4367_/X _4713_/A vssd1 vssd1 vccd1 vccd1 _4368_/X sky130_fd_sc_hd__o21ba_1
XTAP_360 vssd1 vccd1 sky130_fd_sc_hd__tapvpwrvgnd_1
X_6107_ _6646_/Q hold262/X _6113_/S vssd1 vssd1 vccd1 vccd1 _6107_/X sky130_fd_sc_hd__mux2_1
X_3319_ depth_mport_i[9] vssd1 vssd1 vccd1 vccd1 _6255_/A sky130_fd_sc_hd__inv_2
X_4299_ _4299_/A _4299_/B vssd1 vssd1 vccd1 vccd1 _4301_/B sky130_fd_sc_hd__xnor2_1
XTAP_393 vssd1 vccd1 sky130_fd_sc_hd__tapvpwrvgnd_1
XTAP_382 vssd1 vccd1 sky130_fd_sc_hd__tapvpwrvgnd_1
XTAP_371 vssd1 vccd1 sky130_fd_sc_hd__tapvpwrvgnd_1
X_6038_ tex_height_i[15] _6038_/B _6038_/C _6038_/D vssd1 vssd1 vccd1 vccd1 _6038_/Y
+ sky130_fd_sc_hd__nor4_4
XANTENNA__3998__A2 _6682_/Q vssd1 vssd1 vccd1 vccd1 sky130_fd_sc_hd__diode_2
XFILLER_0_95_124 vssd1 vssd1 vccd1 vccd1 sky130_fd_sc_hd__fill_2
XFILLER_0_95_113 vssd1 vssd1 vccd1 vccd1 sky130_fd_sc_hd__fill_2
XPHY_22 vssd1 vssd1 vccd1 vccd1 sky130_fd_sc_hd__decap_3
XPHY_11 vssd1 vssd1 vccd1 vccd1 sky130_fd_sc_hd__decap_3
XPHY_33 vssd1 vssd1 vccd1 vccd1 sky130_fd_sc_hd__decap_3
XPHY_44 vssd1 vssd1 vccd1 vccd1 sky130_fd_sc_hd__decap_3
XPHY_55 vssd1 vssd1 vccd1 vccd1 sky130_fd_sc_hd__decap_3
XFILLER_0_83_319 vssd1 vssd1 vccd1 vccd1 sky130_fd_sc_hd__fill_1
XPHY_66 vssd1 vssd1 vccd1 vccd1 sky130_fd_sc_hd__decap_3
XPHY_77 vssd1 vssd1 vccd1 vccd1 sky130_fd_sc_hd__decap_3
XPHY_88 vssd1 vssd1 vccd1 vccd1 sky130_fd_sc_hd__decap_3
XFILLER_0_91_330 vssd1 vssd1 vccd1 vccd1 sky130_fd_sc_hd__fill_1
XFILLER_0_36_213 vssd1 vssd1 vccd1 vccd1 sky130_fd_sc_hd__fill_2
XFILLER_0_36_235 vssd1 vssd1 vccd1 vccd1 sky130_fd_sc_hd__fill_1
XPHY_99 vssd1 vssd1 vccd1 vccd1 sky130_fd_sc_hd__decap_3
XFILLER_0_106_101 vssd1 vssd1 vccd1 vccd1 sky130_fd_sc_hd__fill_2
XFILLER_0_36_268 vssd1 vssd1 vccd1 vccd1 sky130_fd_sc_hd__decap_3
XFILLER_0_36_279 vssd1 vssd1 vccd1 vccd1 sky130_fd_sc_hd__fill_2
XFILLER_0_91_385 vssd1 vssd1 vccd1 vccd1 sky130_fd_sc_hd__decap_6
XFILLER_0_51_205 vssd1 vssd1 vccd1 vccd1 sky130_fd_sc_hd__fill_2
XFILLER_0_121_137 vssd1 vssd1 vccd1 vccd1 sky130_fd_sc_hd__fill_1
XANTENNA__4109__A _4794_/B vssd1 vssd1 vccd1 vccd1 sky130_fd_sc_hd__diode_2
XFILLER_0_86_124 vssd1 vssd1 vccd1 vccd1 sky130_fd_sc_hd__fill_2
XFILLER_0_86_168 vssd1 vssd1 vccd1 vccd1 sky130_fd_sc_hd__fill_2
XFILLER_0_67_393 vssd1 vssd1 vccd1 vccd1 sky130_ef_sc_hd__decap_12
XANTENNA__3667__B _5327_/A vssd1 vssd1 vccd1 vccd1 sky130_fd_sc_hd__diode_2
XFILLER_0_82_363 vssd1 vssd1 vccd1 vccd1 sky130_fd_sc_hd__fill_1
XFILLER_0_27_257 vssd1 vssd1 vccd1 vccd1 sky130_fd_sc_hd__fill_2
XANTENNA_clkbuf_leaf_15_clk_i_A clkbuf_2_3__f_clk_i/X vssd1 vssd1 vccd1 vccd1 sky130_fd_sc_hd__diode_2
XFILLER_0_12_65 vssd1 vssd1 vccd1 vccd1 sky130_ef_sc_hd__decap_12
X_3670_ _3670_/A _3670_/B vssd1 vssd1 vccd1 vccd1 _3753_/A sky130_fd_sc_hd__or2_1
XANTENNA__5882__B _5882_/B vssd1 vssd1 vccd1 vccd1 sky130_fd_sc_hd__diode_2
XFILLER_0_112_104 vssd1 vssd1 vccd1 vccd1 sky130_fd_sc_hd__fill_2
XFILLER_0_42_238 vssd1 vssd1 vccd1 vccd1 sky130_fd_sc_hd__decap_6
XANTENNA__4779__A _4970_/B vssd1 vssd1 vccd1 vccd1 sky130_fd_sc_hd__diode_2
X_5340_ _5340_/A _5340_/B _5591_/B vssd1 vssd1 vccd1 vccd1 _5342_/A sky130_fd_sc_hd__and3_1
X_5271_ _5454_/A _5454_/B _3699_/X vssd1 vssd1 vccd1 vccd1 _5334_/A sky130_fd_sc_hd__a21o_1
X_4222_ _4222_/A _4222_/B _4222_/C vssd1 vssd1 vccd1 vccd1 _4237_/A sky130_fd_sc_hd__and3_2
X_4153_ _5083_/A _4432_/A vssd1 vssd1 vccd1 vccd1 _4154_/B sky130_fd_sc_hd__nand2_1
X_4084_ _4488_/A _4776_/A vssd1 vssd1 vccd1 vccd1 _4086_/B sky130_fd_sc_hd__nand2_1
XFILLER_0_77_113 vssd1 vssd1 vccd1 vccd1 sky130_fd_sc_hd__decap_4
XFILLER_0_77_146 vssd1 vssd1 vccd1 vccd1 sky130_fd_sc_hd__fill_1
Xclkbuf_leaf_20_clk_i _6684_/CLK vssd1 vssd1 vccd1 vccd1 _6745_/CLK sky130_fd_sc_hd__clkbuf_16
XFILLER_0_53_61 vssd1 vssd1 vccd1 vccd1 sky130_fd_sc_hd__fill_2
XANTENNA_fanout150_A fanout153/X vssd1 vssd1 vccd1 vccd1 sky130_fd_sc_hd__diode_2
XFILLER_0_92_116 vssd1 vssd1 vccd1 vccd1 sky130_fd_sc_hd__fill_2
XFILLER_0_77_179 vssd1 vssd1 vccd1 vccd1 sky130_fd_sc_hd__decap_3
X_4986_ _4855_/B _4855_/Y _4983_/X _4985_/Y vssd1 vssd1 vccd1 vccd1 _4988_/B sky130_fd_sc_hd__a211oi_4
X_6725_ _6863_/CLK _6725_/D _6073_/A vssd1 vssd1 vccd1 vccd1 _6725_/Q sky130_fd_sc_hd__dfstp_1
X_3937_ _3936_/B _3936_/C _3936_/A vssd1 vssd1 vccd1 vccd1 _3938_/B sky130_fd_sc_hd__o21ai_1
XFILLER_0_58_382 vssd1 vssd1 vccd1 vccd1 sky130_ef_sc_hd__decap_12
XFILLER_0_85_190 vssd1 vssd1 vccd1 vccd1 sky130_fd_sc_hd__fill_1
XFILLER_0_18_246 vssd1 vssd1 vccd1 vccd1 sky130_fd_sc_hd__decap_4
XFILLER_0_18_268 vssd1 vssd1 vccd1 vccd1 sky130_fd_sc_hd__fill_1
X_6656_ _6853_/CLK _6656_/D vssd1 vssd1 vccd1 vccd1 _6656_/Q sky130_fd_sc_hd__dfxtp_1
X_3868_ _3959_/B _3961_/A _5081_/C _5081_/D vssd1 vssd1 vccd1 vccd1 _3870_/C sky130_fd_sc_hd__nand4_2
X_6587_ _6818_/CLK _6587_/D fanout151/X vssd1 vssd1 vccd1 vccd1 depth_mport_o[31]
+ sky130_fd_sc_hd__dfrtp_4
X_5607_ _5612_/B _5606_/X _5612_/A vssd1 vssd1 vccd1 vccd1 _5607_/Y sky130_fd_sc_hd__a21oi_1
X_3799_ _3801_/B _3919_/A _3801_/A vssd1 vssd1 vccd1 vccd1 _3815_/A sky130_fd_sc_hd__o21a_1
XFILLER_0_33_238 vssd1 vssd1 vccd1 vccd1 sky130_fd_sc_hd__fill_1
XFILLER_0_33_249 vssd1 vssd1 vccd1 vccd1 sky130_ef_sc_hd__decap_12
XANTENNA__4157__A2 _4774_/B vssd1 vssd1 vccd1 vccd1 sky130_fd_sc_hd__diode_2
X_5538_ depth_mport_o[13] hold147/X _5541_/S vssd1 vssd1 vccd1 vccd1 _6569_/D sky130_fd_sc_hd__mux2_1
X_5469_ hold47/X sstream_i[60] _6486_/S vssd1 vssd1 vccd1 vccd1 _6502_/D sky130_fd_sc_hd__mux2_1
XANTENNA_hold195_A _6539_/Q vssd1 vssd1 vccd1 vccd1 sky130_fd_sc_hd__diode_2
XANTENNA_fanout63_A _4966_/B vssd1 vssd1 vccd1 vccd1 sky130_fd_sc_hd__diode_2
XANTENNA__6831__RESET_B fanout153/X vssd1 vssd1 vccd1 vccd1 sky130_fd_sc_hd__diode_2
XFILLER_0_83_149 vssd1 vssd1 vccd1 vccd1 sky130_fd_sc_hd__fill_1
XFILLER_0_83_116 vssd1 vssd1 vccd1 vccd1 sky130_fd_sc_hd__fill_2
XFILLER_0_49_393 vssd1 vssd1 vccd1 vccd1 sky130_ef_sc_hd__decap_12
XFILLER_0_91_160 vssd1 vssd1 vccd1 vccd1 sky130_fd_sc_hd__fill_1
XFILLER_0_64_363 vssd1 vssd1 vccd1 vccd1 sky130_fd_sc_hd__fill_1
XFILLER_0_32_282 vssd1 vssd1 vccd1 vccd1 sky130_fd_sc_hd__fill_1
XFILLER_0_102_170 vssd1 vssd1 vccd1 vccd1 sky130_fd_sc_hd__fill_1
XANTENNA__4111__B _4776_/A vssd1 vssd1 vccd1 vccd1 sky130_fd_sc_hd__diode_2
XANTENNA__5922__S _5922_/S vssd1 vssd1 vccd1 vccd1 sky130_fd_sc_hd__diode_2
XANTENNA__6038__B _6038_/B vssd1 vssd1 vccd1 vccd1 sky130_fd_sc_hd__diode_2
XFILLER_0_59_124 vssd1 vssd1 vccd1 vccd1 sky130_fd_sc_hd__fill_1
XFILLER_0_59_146 vssd1 vssd1 vccd1 vccd1 sky130_fd_sc_hd__fill_1
XFILLER_0_114_33 vssd1 vssd1 vccd1 vccd1 sky130_fd_sc_hd__fill_2
XFILLER_0_47_308 vssd1 vssd1 vccd1 vccd1 sky130_fd_sc_hd__decap_6
X_4840_ _4839_/B _4839_/C _4839_/A vssd1 vssd1 vccd1 vccd1 _4852_/B sky130_fd_sc_hd__a21o_1
XFILLER_0_135_3 vssd1 vssd1 vccd1 vccd1 sky130_fd_sc_hd__decap_3
XFILLER_0_74_138 vssd1 vssd1 vccd1 vccd1 sky130_fd_sc_hd__fill_2
XFILLER_0_7_405 vssd1 vssd1 vccd1 vccd1 sky130_fd_sc_hd__fill_2
X_6510_ _6834_/CLK _6510_/D vssd1 vssd1 vccd1 vccd1 _6510_/Q sky130_fd_sc_hd__dfxtp_1
X_4771_ _4771_/A _4771_/B vssd1 vssd1 vccd1 vccd1 _4773_/B sky130_fd_sc_hd__xnor2_1
XFILLER_0_82_160 vssd1 vssd1 vccd1 vccd1 sky130_fd_sc_hd__fill_2
X_3722_ _5308_/A _4944_/B _5081_/C _5276_/A vssd1 vssd1 vccd1 vccd1 _3733_/A sky130_fd_sc_hd__and4_1
X_6441_ depth_mport_o[66] _6441_/B vssd1 vssd1 vccd1 vccd1 _6832_/D sky130_fd_sc_hd__or2_1
XFILLER_0_99_57 vssd1 vssd1 vccd1 vccd1 sky130_fd_sc_hd__fill_2
X_3653_ _3653_/A _3653_/B vssd1 vssd1 vccd1 vccd1 _3655_/C sky130_fd_sc_hd__xnor2_1
X_6372_ hold53/A _6368_/S _6367_/A vssd1 vssd1 vccd1 vccd1 _6377_/A sky130_fd_sc_hd__o21a_1
XFILLER_0_70_377 vssd1 vssd1 vccd1 vccd1 sky130_ef_sc_hd__decap_12
XFILLER_0_2_121 vssd1 vssd1 vccd1 vccd1 sky130_ef_sc_hd__decap_12
X_3584_ _3449_/A _3447_/Y _3372_/Y _3374_/X vssd1 vssd1 vccd1 vccd1 _3585_/C sky130_fd_sc_hd__o211a_1
X_5323_ _3999_/A _6690_/Q _3488_/X _3492_/A vssd1 vssd1 vccd1 vccd1 _5325_/A sky130_fd_sc_hd__a211oi_1
X_5254_ _5254_/A _5254_/B vssd1 vssd1 vccd1 vccd1 _5410_/D sky130_fd_sc_hd__xnor2_1
X_4205_ _4205_/A _4205_/B _4205_/C vssd1 vssd1 vccd1 vccd1 _4205_/Y sky130_fd_sc_hd__nand3_2
XANTENNA__3860__B _5766_/A vssd1 vssd1 vccd1 vccd1 sky130_fd_sc_hd__diode_2
X_5185_ _5173_/A _5173_/C _5171_/Y _5169_/X vssd1 vssd1 vccd1 vccd1 _5185_/X sky130_fd_sc_hd__a2bb2o_1
XFILLER_0_48_94 vssd1 vssd1 vccd1 vccd1 sky130_fd_sc_hd__decap_4
X_4136_ _4966_/A _4966_/C _4841_/C _4841_/D vssd1 vssd1 vccd1 vccd1 _4136_/X sky130_fd_sc_hd__and4_1
X_4067_ _4816_/A _4794_/B _4736_/B _4736_/D vssd1 vssd1 vccd1 vccd1 _4068_/B sky130_fd_sc_hd__and4_1
XANTENNA__5787__B _5787_/B vssd1 vssd1 vccd1 vccd1 sky130_fd_sc_hd__diode_2
XFILLER_0_65_127 vssd1 vssd1 vccd1 vccd1 sky130_fd_sc_hd__decap_3
XFILLER_0_80_70 vssd1 vssd1 vccd1 vccd1 sky130_fd_sc_hd__fill_1
X_4969_ _4969_/A _4969_/B vssd1 vssd1 vccd1 vccd1 _4978_/A sky130_fd_sc_hd__xnor2_2
X_6708_ _6827_/CLK hold94/X vssd1 vssd1 vccd1 vccd1 hold93/A sky130_fd_sc_hd__dfxtp_1
XFILLER_0_80_108 vssd1 vssd1 vccd1 vccd1 sky130_fd_sc_hd__fill_2
XFILLER_0_73_160 vssd1 vssd1 vccd1 vccd1 sky130_fd_sc_hd__fill_2
XFILLER_0_46_363 vssd1 vssd1 vccd1 vccd1 sky130_fd_sc_hd__fill_1
X_6639_ _6751_/CLK _6639_/D fanout140/X vssd1 vssd1 vccd1 vccd1 _6639_/Q sky130_fd_sc_hd__dfstp_1
XFILLER_0_61_366 vssd1 vssd1 vccd1 vccd1 sky130_ef_sc_hd__decap_12
XFILLER_0_131_276 vssd1 vssd1 vccd1 vccd1 sky130_fd_sc_hd__fill_2
XANTENNA__5742__S _5844_/S vssd1 vssd1 vccd1 vccd1 sky130_fd_sc_hd__diode_2
XANTENNA__4550__A2 _4527_/B vssd1 vssd1 vccd1 vccd1 sky130_fd_sc_hd__diode_2
Xfanout140 _5937_/A vssd1 vssd1 vccd1 vccd1 fanout140/X sky130_fd_sc_hd__clkbuf_8
Xfanout151 fanout153/X vssd1 vssd1 vccd1 vccd1 fanout151/X sky130_fd_sc_hd__clkbuf_8
XANTENNA__4585__C _5656_/A vssd1 vssd1 vccd1 vccd1 sky130_fd_sc_hd__diode_2
XANTENNA__3510__B1 _5273_/B vssd1 vssd1 vccd1 vccd1 sky130_fd_sc_hd__diode_2
XANTENNA__4066__A1 _4794_/B vssd1 vssd1 vccd1 vccd1 sky130_fd_sc_hd__diode_2
XANTENNA__4066__B2 _4816_/A vssd1 vssd1 vccd1 vccd1 sky130_fd_sc_hd__diode_2
XTAP_1131 vssd1 vccd1 sky130_fd_sc_hd__tapvpwrvgnd_1
XTAP_1120 vssd1 vccd1 sky130_fd_sc_hd__tapvpwrvgnd_1
XTAP_1164 vssd1 vccd1 sky130_fd_sc_hd__tapvpwrvgnd_1
XTAP_1153 vssd1 vccd1 sky130_fd_sc_hd__tapvpwrvgnd_1
XTAP_1142 vssd1 vccd1 sky130_fd_sc_hd__tapvpwrvgnd_1
XTAP_1197 vssd1 vccd1 sky130_fd_sc_hd__tapvpwrvgnd_1
XTAP_1186 vssd1 vccd1 sky130_fd_sc_hd__tapvpwrvgnd_1
XTAP_1175 vssd1 vccd1 sky130_fd_sc_hd__tapvpwrvgnd_1
XFILLER_0_37_363 vssd1 vssd1 vccd1 vccd1 sky130_fd_sc_hd__decap_3
XFILLER_0_114_8 vssd1 vssd1 vccd1 vccd1 sky130_fd_sc_hd__fill_2
XANTENNA__3945__B _4966_/B vssd1 vssd1 vccd1 vccd1 sky130_fd_sc_hd__diode_2
XANTENNA__3961__A _3961_/A vssd1 vssd1 vccd1 vccd1 sky130_fd_sc_hd__diode_2
XTAP_926 vssd1 vccd1 sky130_fd_sc_hd__tapvpwrvgnd_1
XTAP_915 vssd1 vccd1 sky130_fd_sc_hd__tapvpwrvgnd_1
XTAP_904 vssd1 vccd1 sky130_fd_sc_hd__tapvpwrvgnd_1
XFILLER_0_20_274 vssd1 vssd1 vccd1 vccd1 sky130_fd_sc_hd__fill_2
XANTENNA__4776__B _4816_/B vssd1 vssd1 vccd1 vccd1 sky130_fd_sc_hd__diode_2
XTAP_959 vssd1 vccd1 sky130_fd_sc_hd__tapvpwrvgnd_1
XTAP_948 vssd1 vccd1 sky130_fd_sc_hd__tapvpwrvgnd_1
XTAP_937 vssd1 vccd1 sky130_fd_sc_hd__tapvpwrvgnd_1
XANTENNA__4829__B1 _4971_/B vssd1 vssd1 vccd1 vccd1 sky130_fd_sc_hd__diode_2
XFILLER_0_109_33 vssd1 vssd1 vccd1 vccd1 sky130_fd_sc_hd__decap_3
XFILLER_0_109_99 vssd1 vssd1 vccd1 vccd1 sky130_fd_sc_hd__decap_3
XANTENNA__6046__A2 _6038_/B vssd1 vssd1 vccd1 vccd1 sky130_fd_sc_hd__diode_2
XFILLER_0_87_230 vssd1 vssd1 vccd1 vccd1 sky130_fd_sc_hd__decap_4
X_5941_ _3285_/Y _6873_/Q _3284_/Y tex_height_i[9] vssd1 vssd1 vccd1 vccd1 _5962_/B
+ sky130_fd_sc_hd__a2bb2o_1
XANTENNA__3804__A1 _5049_/D vssd1 vssd1 vccd1 vccd1 sky130_fd_sc_hd__diode_2
XANTENNA__4942__D _5049_/D vssd1 vssd1 vccd1 vccd1 sky130_fd_sc_hd__diode_2
XFILLER_0_87_285 vssd1 vssd1 vccd1 vccd1 sky130_fd_sc_hd__fill_1
X_5872_ _5867_/Y _5871_/X _5591_/X vssd1 vssd1 vccd1 vccd1 _5872_/Y sky130_fd_sc_hd__o21bai_1
XANTENNA__5557__A1 _5599_/A vssd1 vssd1 vccd1 vccd1 sky130_fd_sc_hd__diode_2
X_4823_ _4970_/B _4966_/A _4966_/B _4966_/C vssd1 vssd1 vccd1 vccd1 _4823_/X sky130_fd_sc_hd__a22o_1
XANTENNA__3568__B1 _5277_/B vssd1 vssd1 vccd1 vccd1 sky130_fd_sc_hd__diode_2
XFILLER_0_28_352 vssd1 vssd1 vccd1 vccd1 sky130_ef_sc_hd__decap_12
X_4754_ _4754_/A _4754_/B _4754_/C vssd1 vssd1 vccd1 vccd1 _4754_/X sky130_fd_sc_hd__and3_1
XFILLER_0_62_108 vssd1 vssd1 vccd1 vccd1 sky130_fd_sc_hd__fill_2
XFILLER_0_7_279 vssd1 vssd1 vccd1 vccd1 sky130_fd_sc_hd__fill_1
X_3705_ _3655_/A _3655_/B _3655_/C vssd1 vssd1 vccd1 vccd1 _3705_/Y sky130_fd_sc_hd__o21ai_1
XFILLER_0_55_193 vssd1 vssd1 vccd1 vccd1 sky130_fd_sc_hd__fill_2
X_4685_ _4678_/A _4680_/A _4678_/D _4684_/Y vssd1 vssd1 vccd1 vccd1 _4686_/B sky130_fd_sc_hd__a31o_1
XFILLER_0_70_141 vssd1 vssd1 vccd1 vccd1 sky130_fd_sc_hd__decap_3
XANTENNA__4780__A2 _5766_/A vssd1 vssd1 vccd1 vccd1 sky130_fd_sc_hd__diode_2
X_6424_ _6425_/A _6425_/B vssd1 vssd1 vccd1 vccd1 _6433_/B sky130_fd_sc_hd__nor2_1
XFILLER_0_101_405 vssd1 vssd1 vccd1 vccd1 sky130_fd_sc_hd__fill_2
X_3636_ _3959_/B _3961_/A _5273_/A _5272_/A vssd1 vssd1 vccd1 vccd1 _3637_/B sky130_fd_sc_hd__nand4_1
X_6355_ _6346_/B _6365_/A _6355_/C vssd1 vssd1 vccd1 vccd1 _6368_/S sky130_fd_sc_hd__nand3b_4
XFILLER_0_113_287 vssd1 vssd1 vccd1 vccd1 sky130_fd_sc_hd__fill_1
X_3567_ _5081_/A _5081_/B _5308_/B _5277_/B vssd1 vssd1 vccd1 vccd1 _3567_/X sky130_fd_sc_hd__and4_1
X_6286_ depth_mport_i[29] _3297_/Y _3298_/Y depth_mport_i[28] vssd1 vssd1 vccd1 vccd1
+ _6286_/X sky130_fd_sc_hd__o22a_1
X_5306_ _5306_/A _6687_/Q vssd1 vssd1 vccd1 vccd1 _5307_/B sky130_fd_sc_hd__nand2_1
X_3498_ _5286_/A _5273_/B _3496_/B _3494_/X vssd1 vssd1 vccd1 vccd1 _3505_/A sky130_fd_sc_hd__a31o_1
X_5237_ _5237_/A _5237_/B vssd1 vssd1 vccd1 vccd1 _5425_/C sky130_fd_sc_hd__xnor2_1
X_5168_ _4984_/B _4984_/Y _5156_/Y _5167_/X vssd1 vssd1 vccd1 vccd1 _5173_/B sky130_fd_sc_hd__a211oi_2
X_4119_ _4119_/A _4119_/B _4119_/C vssd1 vssd1 vccd1 vccd1 _4121_/B sky130_fd_sc_hd__nand3_2
X_5099_ _5098_/B _5098_/C _5098_/A vssd1 vssd1 vccd1 vccd1 _5100_/C sky130_fd_sc_hd__a21o_1
XPHY_225 vssd1 vssd1 vccd1 vccd1 sky130_fd_sc_hd__decap_3
XPHY_214 vssd1 vssd1 vccd1 vccd1 sky130_fd_sc_hd__decap_3
XPHY_203 vssd1 vssd1 vccd1 vccd1 sky130_fd_sc_hd__decap_3
XFILLER_0_93_200 vssd1 vssd1 vccd1 vccd1 sky130_fd_sc_hd__fill_2
XFILLER_0_78_274 vssd1 vssd1 vccd1 vccd1 sky130_fd_sc_hd__fill_2
XANTENNA__3749__C _5299_/A vssd1 vssd1 vccd1 vccd1 sky130_fd_sc_hd__diode_2
XFILLER_0_38_127 vssd1 vssd1 vccd1 vccd1 sky130_fd_sc_hd__fill_2
XPHY_258 vssd1 vssd1 vccd1 vccd1 sky130_fd_sc_hd__decap_3
XPHY_247 vssd1 vssd1 vccd1 vccd1 sky130_fd_sc_hd__decap_3
XPHY_236 vssd1 vssd1 vccd1 vccd1 sky130_fd_sc_hd__decap_3
XANTENNA_fanout26_A _6061_/S vssd1 vssd1 vccd1 vccd1 sky130_fd_sc_hd__diode_2
XFILLER_0_93_233 vssd1 vssd1 vccd1 vccd1 sky130_fd_sc_hd__fill_2
XPHY_269 vssd1 vssd1 vccd1 vccd1 sky130_fd_sc_hd__decap_3
XFILLER_0_93_299 vssd1 vssd1 vccd1 vccd1 sky130_fd_sc_hd__decap_6
XFILLER_0_136_368 vssd1 vssd1 vccd1 vccd1 sky130_ef_sc_hd__decap_12
XFILLER_0_34_399 vssd1 vssd1 vccd1 vccd1 sky130_fd_sc_hd__decap_8
XFILLER_0_61_185 vssd1 vssd1 vccd1 vccd1 sky130_fd_sc_hd__decap_4
XFILLER_0_61_196 vssd1 vssd1 vccd1 vccd1 sky130_fd_sc_hd__fill_2
Xhold7 hold7/A vssd1 vssd1 vccd1 vccd1 hold7/X sky130_fd_sc_hd__dlygate4sd3_1
XANTENNA__4039__A1 _5083_/A vssd1 vssd1 vccd1 vccd1 sky130_fd_sc_hd__diode_2
XANTENNA__6028__A2 _6038_/C vssd1 vssd1 vccd1 vccd1 sky130_fd_sc_hd__diode_2
XANTENNA__4039__B2 _4794_/B vssd1 vssd1 vccd1 vccd1 sky130_fd_sc_hd__diode_2
XANTENNA__3659__C _5273_/B vssd1 vssd1 vccd1 vccd1 sky130_fd_sc_hd__diode_2
XFILLER_0_72_406 vssd1 vssd1 vccd1 vccd1 sky130_fd_sc_hd__fill_1
XFILLER_0_37_160 vssd1 vssd1 vccd1 vccd1 sky130_fd_sc_hd__fill_2
XFILLER_0_44_119 vssd1 vssd1 vccd1 vccd1 sky130_fd_sc_hd__fill_2
XFILLER_0_111_23 vssd1 vssd1 vccd1 vccd1 sky130_fd_sc_hd__fill_2
XFILLER_0_25_333 vssd1 vssd1 vccd1 vccd1 sky130_fd_sc_hd__decap_3
XFILLER_0_52_141 vssd1 vssd1 vccd1 vccd1 sky130_fd_sc_hd__fill_1
XFILLER_0_52_152 vssd1 vssd1 vccd1 vccd1 sky130_fd_sc_hd__fill_1
X_4470_ _4942_/A _4527_/B _4841_/C _4942_/B vssd1 vssd1 vccd1 vccd1 _4471_/C sky130_fd_sc_hd__a22o_1
XFILLER_0_52_174 vssd1 vssd1 vccd1 vccd1 sky130_fd_sc_hd__fill_2
X_3421_ _3470_/A _5286_/B _5320_/A _3421_/D vssd1 vssd1 vccd1 vccd1 _3470_/B sky130_fd_sc_hd__and4b_1
X_6140_ _6785_/Q _6787_/Q vssd1 vssd1 vccd1 vccd1 _6141_/C sky130_fd_sc_hd__or2_1
X_3352_ _3352_/A _3649_/A vssd1 vssd1 vccd1 vccd1 _3606_/A sky130_fd_sc_hd__or2_1
XTAP_701 vssd1 vccd1 sky130_fd_sc_hd__tapvpwrvgnd_1
XTAP_734 vssd1 vccd1 sky130_fd_sc_hd__tapvpwrvgnd_1
XTAP_723 vssd1 vccd1 sky130_fd_sc_hd__tapvpwrvgnd_1
XFILLER_0_29_52 vssd1 vssd1 vccd1 vccd1 sky130_fd_sc_hd__fill_2
XTAP_712 vssd1 vccd1 sky130_fd_sc_hd__tapvpwrvgnd_1
X_6071_ hold1/X hold44/X _6072_/S vssd1 vssd1 vccd1 vccd1 _6710_/D sky130_fd_sc_hd__mux2_1
XTAP_767 vssd1 vccd1 sky130_fd_sc_hd__tapvpwrvgnd_1
XTAP_756 vssd1 vccd1 sky130_fd_sc_hd__tapvpwrvgnd_1
XTAP_745 vssd1 vccd1 sky130_fd_sc_hd__tapvpwrvgnd_1
X_3283_ _6875_/Q vssd1 vssd1 vccd1 vccd1 _3283_/Y sky130_fd_sc_hd__inv_2
XTAP_789 vssd1 vccd1 sky130_fd_sc_hd__tapvpwrvgnd_1
XTAP_778 vssd1 vccd1 sky130_fd_sc_hd__tapvpwrvgnd_1
X_5022_ _5012_/Y _5014_/X _5020_/A _5021_/X vssd1 vssd1 vccd1 vccd1 _5022_/X sky130_fd_sc_hd__o211a_1
X_6973_ vssd1 vssd1 vccd1 vccd1 _6973_/HI tex_mport_o[26] sky130_fd_sc_hd__conb_1
X_5924_ _6073_/A _5924_/B vssd1 vssd1 vccd1 vccd1 _5932_/S sky130_fd_sc_hd__and2_4
XFILLER_0_0_53 vssd1 vssd1 vccd1 vccd1 sky130_fd_sc_hd__decap_3
X_5855_ _5853_/Y _5854_/X _5599_/A _5588_/B vssd1 vssd1 vccd1 vccd1 _5855_/X sky130_fd_sc_hd__a2bb2o_1
XFILLER_0_118_346 vssd1 vssd1 vccd1 vccd1 sky130_fd_sc_hd__fill_2
XFILLER_0_0_97 vssd1 vssd1 vccd1 vccd1 sky130_ef_sc_hd__decap_12
X_4806_ _4752_/B _4754_/B _4804_/Y _4805_/X vssd1 vssd1 vccd1 vccd1 _4926_/B sky130_fd_sc_hd__a211o_1
XFILLER_0_133_316 vssd1 vssd1 vccd1 vccd1 sky130_ef_sc_hd__decap_12
X_5786_ _5787_/B _5787_/C _5787_/A vssd1 vssd1 vccd1 vccd1 _5786_/Y sky130_fd_sc_hd__o21ai_1
XFILLER_0_9_51 vssd1 vssd1 vccd1 vccd1 sky130_fd_sc_hd__decap_4
XFILLER_0_16_344 vssd1 vssd1 vccd1 vccd1 sky130_fd_sc_hd__fill_2
XFILLER_0_43_141 vssd1 vssd1 vccd1 vccd1 sky130_fd_sc_hd__decap_3
X_4737_ _4737_/A _4737_/B vssd1 vssd1 vccd1 vccd1 _4739_/A sky130_fd_sc_hd__nor2_1
X_4668_ _4668_/A _4668_/B vssd1 vssd1 vccd1 vccd1 _4668_/X sky130_fd_sc_hd__or2_1
XFILLER_0_16_399 vssd1 vssd1 vccd1 vccd1 sky130_fd_sc_hd__decap_8
X_6407_ hold7/A _6546_/Q vssd1 vssd1 vccd1 vccd1 _6408_/B sky130_fd_sc_hd__xor2_1
X_3619_ _3620_/A _3619_/B vssd1 vssd1 vccd1 vccd1 _3619_/X sky130_fd_sc_hd__and2b_1
X_4599_ _4600_/B _4600_/A vssd1 vssd1 vccd1 vccd1 _4599_/Y sky130_fd_sc_hd__nand2b_1
X_6338_ _6539_/Q hold44/A vssd1 vssd1 vccd1 vccd1 _6340_/C sky130_fd_sc_hd__or2_1
X_6269_ _6841_/Q _3320_/Y _6249_/X _6255_/X vssd1 vssd1 vccd1 vccd1 _6269_/X sky130_fd_sc_hd__o211a_1
XFILLER_0_98_314 vssd1 vssd1 vccd1 vccd1 sky130_fd_sc_hd__fill_1
XANTENNA__6604__RESET_B fanout144/X vssd1 vssd1 vccd1 vccd1 sky130_fd_sc_hd__diode_2
XFILLER_0_98_369 vssd1 vssd1 vccd1 vccd1 sky130_fd_sc_hd__fill_2
XFILLER_0_66_288 vssd1 vssd1 vccd1 vccd1 sky130_fd_sc_hd__decap_8
XFILLER_0_124_349 vssd1 vssd1 vccd1 vccd1 sky130_fd_sc_hd__fill_2
XFILLER_0_81_258 vssd1 vssd1 vccd1 vccd1 sky130_fd_sc_hd__decap_6
XFILLER_0_34_141 vssd1 vssd1 vccd1 vccd1 sky130_fd_sc_hd__decap_3
XFILLER_0_34_152 vssd1 vssd1 vccd1 vccd1 sky130_fd_sc_hd__fill_2
XFILLER_0_22_314 vssd1 vssd1 vccd1 vccd1 sky130_fd_sc_hd__fill_1
XFILLER_0_22_336 vssd1 vssd1 vccd1 vccd1 sky130_fd_sc_hd__fill_1
XFILLER_0_22_358 vssd1 vssd1 vccd1 vccd1 sky130_fd_sc_hd__decap_6
XANTENNA__5930__S _5932_/S vssd1 vssd1 vccd1 vccd1 sky130_fd_sc_hd__diode_2
XFILLER_0_100_290 vssd1 vssd1 vccd1 vccd1 sky130_ef_sc_hd__decap_12
XANTENNA__6421__A2 _6546_/Q vssd1 vssd1 vccd1 vccd1 sky130_fd_sc_hd__diode_2
XANTENNA__3389__C _5299_/A vssd1 vssd1 vccd1 vccd1 sky130_fd_sc_hd__diode_2
X_3970_ _3970_/A _3970_/B vssd1 vssd1 vccd1 vccd1 _3973_/B sky130_fd_sc_hd__xnor2_1
XFILLER_0_9_308 vssd1 vssd1 vccd1 vccd1 sky130_fd_sc_hd__decap_4
XANTENNA_clkbuf_2_1__f_clk_i_A clkbuf_0_clk_i/X vssd1 vssd1 vccd1 vccd1 sky130_fd_sc_hd__diode_2
XFILLER_0_57_288 vssd1 vssd1 vccd1 vccd1 sky130_fd_sc_hd__decap_3
X_5640_ tex_addr_i[0] _5640_/B vssd1 vssd1 vccd1 vccd1 _5652_/A sky130_fd_sc_hd__nand2_1
XFILLER_0_72_247 vssd1 vssd1 vccd1 vccd1 sky130_fd_sc_hd__fill_2
XFILLER_0_72_225 vssd1 vssd1 vccd1 vccd1 sky130_fd_sc_hd__fill_2
XFILLER_0_31_31 vssd1 vssd1 vccd1 vccd1 sky130_fd_sc_hd__fill_2
X_5571_ _5385_/B tex_mport_o[39] _5576_/S vssd1 vssd1 vccd1 vccd1 _6596_/D sky130_fd_sc_hd__mux2_1
XFILLER_0_72_258 vssd1 vssd1 vccd1 vccd1 sky130_fd_sc_hd__decap_3
XFILLER_0_31_86 vssd1 vssd1 vccd1 vccd1 sky130_fd_sc_hd__fill_2
XANTENNA__4735__A2 _4736_/B vssd1 vssd1 vccd1 vccd1 sky130_fd_sc_hd__diode_2
X_4522_ _4522_/A _4522_/B _4522_/C vssd1 vssd1 vccd1 vccd1 _4568_/A sky130_fd_sc_hd__and3_1
XFILLER_0_31_97 vssd1 vssd1 vccd1 vccd1 sky130_fd_sc_hd__fill_1
XFILLER_0_40_111 vssd1 vssd1 vccd1 vccd1 sky130_fd_sc_hd__fill_2
Xhold204 _6782_/Q vssd1 vssd1 vccd1 vccd1 hold204/X sky130_fd_sc_hd__dlygate4sd3_1
Xhold215 _6543_/Q vssd1 vssd1 vccd1 vccd1 hold215/X sky130_fd_sc_hd__dlygate4sd3_1
X_4453_ _4454_/A _4454_/B vssd1 vssd1 vccd1 vccd1 _4455_/A sky130_fd_sc_hd__nand2_2
Xhold226 _6651_/Q vssd1 vssd1 vccd1 vccd1 hold226/X sky130_fd_sc_hd__dlygate4sd3_1
XFILLER_0_123_393 vssd1 vssd1 vccd1 vccd1 sky130_ef_sc_hd__decap_12
Xhold259 _6084_/X vssd1 vssd1 vccd1 vccd1 _6722_/D sky130_fd_sc_hd__dlygate4sd3_1
Xhold237 _6622_/Q vssd1 vssd1 vccd1 vccd1 hold237/X sky130_fd_sc_hd__dlygate4sd3_1
Xhold248 _6734_/Q vssd1 vssd1 vccd1 vccd1 hold248/X sky130_fd_sc_hd__dlygate4sd3_1
X_3404_ _3387_/X _3390_/B _3999_/A _6687_/Q vssd1 vssd1 vccd1 vccd1 _3408_/A sky130_fd_sc_hd__o211ai_1
XFILLER_0_40_166 vssd1 vssd1 vccd1 vccd1 sky130_fd_sc_hd__fill_2
X_4384_ _4378_/A _4378_/B _4378_/C vssd1 vssd1 vccd1 vccd1 _4385_/C sky130_fd_sc_hd__a21o_1
XANTENNA__6001__S _6037_/S vssd1 vssd1 vccd1 vccd1 sky130_fd_sc_hd__diode_2
X_6123_ hold16/X pix_mport_o[7] _6223_/B vssd1 vssd1 vccd1 vccd1 _6759_/D sky130_fd_sc_hd__mux2_1
X_3335_ _6784_/Q _3335_/B vssd1 vssd1 vccd1 vccd1 sstream_o sky130_fd_sc_hd__and2b_4
XTAP_520 vssd1 vccd1 sky130_fd_sc_hd__tapvpwrvgnd_1
XTAP_531 vssd1 vccd1 sky130_fd_sc_hd__tapvpwrvgnd_1
XTAP_542 vssd1 vccd1 sky130_fd_sc_hd__tapvpwrvgnd_1
X_3266_ _3266_/A vssd1 vssd1 vccd1 vccd1 _3266_/Y sky130_fd_sc_hd__inv_2
X_6054_ hold13/X _5937_/Y _6054_/B1 vssd1 vssd1 vccd1 vccd1 _6693_/D sky130_fd_sc_hd__a21o_1
XTAP_553 vssd1 vccd1 sky130_fd_sc_hd__tapvpwrvgnd_1
XTAP_564 vssd1 vccd1 sky130_fd_sc_hd__tapvpwrvgnd_1
XTAP_575 vssd1 vccd1 sky130_fd_sc_hd__tapvpwrvgnd_1
X_5005_ _4904_/C _4904_/B _4902_/Y vssd1 vssd1 vccd1 vccd1 _5005_/X sky130_fd_sc_hd__a21bo_1
XTAP_586 vssd1 vccd1 sky130_fd_sc_hd__tapvpwrvgnd_1
XTAP_597 vssd1 vccd1 sky130_fd_sc_hd__tapvpwrvgnd_1
XFILLER_0_56_83 vssd1 vssd1 vccd1 vccd1 sky130_fd_sc_hd__fill_1
XFILLER_0_22_3 vssd1 vssd1 vccd1 vccd1 sky130_ef_sc_hd__decap_12
XFILLER_0_56_94 vssd1 vssd1 vccd1 vccd1 sky130_fd_sc_hd__decap_3
X_6956_ vssd1 vssd1 vccd1 vccd1 _6956_/HI tex_mport_o[9] sky130_fd_sc_hd__conb_1
XANTENNA__5620__B1 _5787_/B vssd1 vssd1 vccd1 vccd1 sky130_fd_sc_hd__diode_2
X_5907_ _5907_/A _5907_/B vssd1 vssd1 vccd1 vccd1 _5909_/A sky130_fd_sc_hd__nand2_1
X_6887_ _6892_/CLK _6887_/D vssd1 vssd1 vccd1 vccd1 hold99/A sky130_fd_sc_hd__dfxtp_1
XFILLER_0_36_406 vssd1 vssd1 vccd1 vccd1 sky130_fd_sc_hd__fill_1
XFILLER_0_106_305 vssd1 vssd1 vccd1 vccd1 sky130_fd_sc_hd__decap_3
XFILLER_0_63_236 vssd1 vssd1 vccd1 vccd1 sky130_fd_sc_hd__fill_2
XFILLER_0_8_352 vssd1 vssd1 vccd1 vccd1 sky130_fd_sc_hd__fill_2
X_5838_ _5807_/B _5812_/X _5837_/Y _5804_/A vssd1 vssd1 vccd1 vccd1 _5841_/A sky130_fd_sc_hd__o211ai_2
XFILLER_0_133_113 vssd1 vssd1 vccd1 vccd1 sky130_fd_sc_hd__fill_2
X_5769_ tex_addr_i[12] _5770_/B vssd1 vssd1 vccd1 vccd1 _5782_/A sky130_fd_sc_hd__and2_1
XFILLER_0_16_141 vssd1 vssd1 vccd1 vccd1 sky130_fd_sc_hd__fill_2
XFILLER_0_16_185 vssd1 vssd1 vccd1 vccd1 sky130_fd_sc_hd__fill_1
XFILLER_0_133_179 vssd1 vssd1 vccd1 vccd1 sky130_fd_sc_hd__decap_4
XFILLER_0_31_111 vssd1 vssd1 vccd1 vccd1 sky130_fd_sc_hd__fill_1
XANTENNA__5051__A _5051_/A vssd1 vssd1 vccd1 vccd1 sky130_fd_sc_hd__diode_2
XFILLER_0_52_19 vssd1 vssd1 vccd1 vccd1 sky130_fd_sc_hd__fill_2
XFILLER_0_79_391 vssd1 vssd1 vccd1 vccd1 sky130_fd_sc_hd__fill_1
XANTENNA__4198__A2_N _4822_/B vssd1 vssd1 vccd1 vccd1 sky130_fd_sc_hd__diode_2
XFILLER_0_54_214 vssd1 vssd1 vccd1 vccd1 sky130_fd_sc_hd__fill_1
XANTENNA__5925__S _5932_/S vssd1 vssd1 vccd1 vccd1 sky130_fd_sc_hd__diode_2
XFILLER_0_22_122 vssd1 vssd1 vccd1 vccd1 sky130_fd_sc_hd__fill_2
XANTENNA__3953__B _5286_/A vssd1 vssd1 vccd1 vccd1 sky130_fd_sc_hd__diode_2
XFILLER_0_105_393 vssd1 vssd1 vccd1 vccd1 sky130_ef_sc_hd__decap_12
XFILLER_0_120_363 vssd1 vssd1 vccd1 vccd1 sky130_fd_sc_hd__fill_1
XANTENNA_clkbuf_leaf_11_clk_i_A clkbuf_2_3__f_clk_i/X vssd1 vssd1 vccd1 vccd1 sky130_fd_sc_hd__diode_2
XFILLER_0_93_37 vssd1 vssd1 vccd1 vccd1 sky130_fd_sc_hd__decap_3
XFILLER_0_89_122 vssd1 vssd1 vccd1 vccd1 sky130_fd_sc_hd__fill_2
XFILLER_0_89_100 vssd1 vssd1 vccd1 vccd1 sky130_fd_sc_hd__decap_3
XFILLER_0_89_144 vssd1 vssd1 vccd1 vccd1 sky130_fd_sc_hd__decap_3
X_6810_ _6855_/CLK filt_depth_fly_o _6073_/A vssd1 vssd1 vccd1 vccd1 _6810_/Q sky130_fd_sc_hd__dfrtp_1
XFILLER_0_89_166 vssd1 vssd1 vccd1 vccd1 sky130_fd_sc_hd__fill_2
XANTENNA__5602__A0 _5796_/A vssd1 vssd1 vccd1 vccd1 sky130_fd_sc_hd__diode_2
XFILLER_0_9_105 vssd1 vssd1 vccd1 vccd1 sky130_fd_sc_hd__decap_6
XFILLER_0_85_350 vssd1 vssd1 vccd1 vccd1 sky130_fd_sc_hd__fill_2
X_3953_ _5081_/A _5286_/A vssd1 vssd1 vccd1 vccd1 _3954_/B sky130_fd_sc_hd__nand2_1
XFILLER_0_42_52 vssd1 vssd1 vccd1 vccd1 sky130_fd_sc_hd__decap_3
X_6741_ _6745_/CLK _6741_/D fanout139/X vssd1 vssd1 vccd1 vccd1 _6741_/Q sky130_fd_sc_hd__dfstp_1
X_6672_ _6677_/CLK _6672_/D vssd1 vssd1 vccd1 vccd1 _6672_/Q sky130_fd_sc_hd__dfxtp_1
X_3884_ _3887_/D vssd1 vssd1 vccd1 vccd1 _3884_/Y sky130_fd_sc_hd__inv_2
XFILLER_0_42_63 vssd1 vssd1 vccd1 vccd1 sky130_fd_sc_hd__fill_2
XFILLER_0_42_85 vssd1 vssd1 vccd1 vccd1 sky130_fd_sc_hd__fill_2
XFILLER_0_42_96 vssd1 vssd1 vccd1 vccd1 sky130_fd_sc_hd__fill_2
XFILLER_0_115_102 vssd1 vssd1 vccd1 vccd1 sky130_fd_sc_hd__fill_2
X_5623_ _5718_/A _5623_/B vssd1 vssd1 vccd1 vccd1 _5626_/B sky130_fd_sc_hd__nor2_1
XFILLER_0_45_258 vssd1 vssd1 vccd1 vccd1 sky130_fd_sc_hd__fill_1
XFILLER_0_5_344 vssd1 vssd1 vccd1 vccd1 sky130_fd_sc_hd__fill_2
XANTENNA__5835__S _5923_/S vssd1 vssd1 vccd1 vccd1 sky130_fd_sc_hd__diode_2
X_5554_ depth_mport_o[29] hold212/X _5554_/S vssd1 vssd1 vccd1 vccd1 _6585_/D sky130_fd_sc_hd__mux2_1
XFILLER_0_130_116 vssd1 vssd1 vccd1 vccd1 sky130_fd_sc_hd__fill_1
XFILLER_0_5_366 vssd1 vssd1 vccd1 vccd1 sky130_fd_sc_hd__fill_2
XANTENNA__3863__B _5286_/A vssd1 vssd1 vccd1 vccd1 sky130_fd_sc_hd__diode_2
X_4505_ _4500_/Y _4509_/A _4503_/X _4460_/Y vssd1 vssd1 vccd1 vccd1 _4505_/X sky130_fd_sc_hd__a211o_1
X_5485_ hold135/X sstream_i[76] _6486_/S vssd1 vssd1 vccd1 vccd1 _6518_/D sky130_fd_sc_hd__mux2_1
X_4436_ _4436_/A _4436_/B vssd1 vssd1 vccd1 vccd1 _4438_/B sky130_fd_sc_hd__xnor2_1
XANTENNA__4040__A _4794_/B vssd1 vssd1 vccd1 vccd1 sky130_fd_sc_hd__diode_2
XANTENNA__3345__A2_N _5272_/B vssd1 vssd1 vccd1 vccd1 sky130_fd_sc_hd__diode_2
XFILLER_0_6_41 vssd1 vssd1 vccd1 vccd1 sky130_ef_sc_hd__decap_12
X_4367_ _4712_/A _4712_/B vssd1 vssd1 vccd1 vccd1 _4367_/X sky130_fd_sc_hd__and2b_1
X_3318_ depth_mport_i[10] vssd1 vssd1 vccd1 vccd1 _3318_/Y sky130_fd_sc_hd__inv_2
XTAP_350 vssd1 vccd1 sky130_fd_sc_hd__tapvpwrvgnd_1
XFILLER_0_6_85 vssd1 vssd1 vccd1 vccd1 sky130_ef_sc_hd__decap_12
X_6106_ hold162/X _6744_/Q _6113_/S vssd1 vssd1 vccd1 vccd1 _6106_/X sky130_fd_sc_hd__mux2_1
X_4298_ _4298_/A _4298_/B vssd1 vssd1 vccd1 vccd1 _4299_/B sky130_fd_sc_hd__xnor2_1
XTAP_394 vssd1 vccd1 sky130_fd_sc_hd__tapvpwrvgnd_1
XTAP_383 vssd1 vccd1 sky130_fd_sc_hd__tapvpwrvgnd_1
XTAP_372 vssd1 vccd1 sky130_fd_sc_hd__tapvpwrvgnd_1
XTAP_361 vssd1 vccd1 sky130_fd_sc_hd__tapvpwrvgnd_1
X_3249_ _5687_/B vssd1 vssd1 vccd1 vccd1 _3249_/Y sky130_fd_sc_hd__inv_2
X_6037_ _3870_/A _6036_/X _6037_/S vssd1 vssd1 vccd1 vccd1 _6677_/D sky130_fd_sc_hd__mux2_1
XFILLER_0_83_81 vssd1 vssd1 vccd1 vccd1 sky130_fd_sc_hd__decap_3
XFILLER_0_68_339 vssd1 vssd1 vccd1 vccd1 sky130_fd_sc_hd__fill_1
XPHY_12 vssd1 vssd1 vccd1 vccd1 sky130_fd_sc_hd__decap_3
XFILLER_0_138_216 vssd1 vssd1 vccd1 vccd1 sky130_fd_sc_hd__decap_8
XPHY_23 vssd1 vssd1 vccd1 vccd1 sky130_fd_sc_hd__decap_3
XPHY_34 vssd1 vssd1 vccd1 vccd1 sky130_fd_sc_hd__decap_3
XPHY_45 vssd1 vssd1 vccd1 vccd1 sky130_fd_sc_hd__decap_3
XPHY_56 vssd1 vssd1 vccd1 vccd1 sky130_fd_sc_hd__decap_3
X_6939_ vssd1 vssd1 vccd1 vccd1 _6939_/HI pix_mport_o[59] sky130_fd_sc_hd__conb_1
XFILLER_0_138_238 vssd1 vssd1 vccd1 vccd1 sky130_fd_sc_hd__fill_2
XFILLER_0_95_169 vssd1 vssd1 vccd1 vccd1 sky130_fd_sc_hd__decap_6
XFILLER_0_83_309 vssd1 vssd1 vccd1 vccd1 sky130_fd_sc_hd__decap_3
XFILLER_0_76_361 vssd1 vssd1 vccd1 vccd1 sky130_fd_sc_hd__fill_1
XPHY_67 vssd1 vssd1 vccd1 vccd1 sky130_fd_sc_hd__decap_3
XPHY_78 vssd1 vssd1 vccd1 vccd1 sky130_fd_sc_hd__decap_3
XPHY_89 vssd1 vssd1 vccd1 vccd1 sky130_fd_sc_hd__decap_3
XFILLER_0_51_217 vssd1 vssd1 vccd1 vccd1 sky130_fd_sc_hd__fill_1
XANTENNA__3383__A1 _5311_/A vssd1 vssd1 vccd1 vccd1 sky130_fd_sc_hd__diode_2
XANTENNA__4332__B1 _4776_/A vssd1 vssd1 vccd1 vccd1 sky130_fd_sc_hd__diode_2
XFILLER_0_86_114 vssd1 vssd1 vccd1 vccd1 sky130_fd_sc_hd__fill_2
XANTENNA__4109__B _4432_/A vssd1 vssd1 vccd1 vccd1 sky130_fd_sc_hd__diode_2
Xclkbuf_2_1__f_clk_i clkbuf_0_clk_i/X vssd1 vssd1 vccd1 vccd1 _6684_/CLK sky130_fd_sc_hd__clkbuf_16
XFILLER_0_129_216 vssd1 vssd1 vccd1 vccd1 sky130_fd_sc_hd__fill_1
XFILLER_0_86_147 vssd1 vssd1 vccd1 vccd1 sky130_fd_sc_hd__decap_3
XFILLER_0_86_136 vssd1 vssd1 vccd1 vccd1 sky130_fd_sc_hd__fill_2
Xclkbuf_leaf_1_clk_i clkbuf_leaf_1_clk_i/A vssd1 vssd1 vccd1 vccd1 _6884_/CLK sky130_fd_sc_hd__clkbuf_16
XFILLER_0_74_309 vssd1 vssd1 vccd1 vccd1 sky130_fd_sc_hd__decap_6
XFILLER_0_82_320 vssd1 vssd1 vccd1 vccd1 sky130_ef_sc_hd__decap_12
XFILLER_0_27_225 vssd1 vssd1 vccd1 vccd1 sky130_fd_sc_hd__decap_6
XFILLER_0_137_271 vssd1 vssd1 vccd1 vccd1 sky130_fd_sc_hd__fill_2
XFILLER_0_103_57 vssd1 vssd1 vccd1 vccd1 sky130_fd_sc_hd__fill_1
XFILLER_0_82_353 vssd1 vssd1 vccd1 vccd1 sky130_fd_sc_hd__fill_2
XFILLER_0_27_269 vssd1 vssd1 vccd1 vccd1 sky130_fd_sc_hd__fill_1
XFILLER_0_12_77 vssd1 vssd1 vccd1 vccd1 sky130_fd_sc_hd__decap_6
XANTENNA__6340__A hold75/X vssd1 vssd1 vccd1 vccd1 sky130_fd_sc_hd__diode_2
XANTENNA__3438__A1_N _5311_/A vssd1 vssd1 vccd1 vccd1 sky130_fd_sc_hd__diode_2
XANTENNA__4779__B _4822_/B vssd1 vssd1 vccd1 vccd1 sky130_fd_sc_hd__diode_2
XFILLER_0_112_116 vssd1 vssd1 vccd1 vccd1 sky130_fd_sc_hd__fill_2
XFILLER_0_2_325 vssd1 vssd1 vccd1 vccd1 sky130_fd_sc_hd__fill_1
XFILLER_0_10_125 vssd1 vssd1 vccd1 vccd1 sky130_fd_sc_hd__fill_1
XFILLER_0_2_369 vssd1 vssd1 vccd1 vccd1 sky130_fd_sc_hd__fill_2
XFILLER_0_2_358 vssd1 vssd1 vccd1 vccd1 sky130_fd_sc_hd__decap_3
X_5270_ _5438_/A _5442_/A _5437_/B _3778_/A vssd1 vssd1 vccd1 vccd1 _5454_/B sky130_fd_sc_hd__o31a_1
XFILLER_0_120_171 vssd1 vssd1 vccd1 vccd1 sky130_fd_sc_hd__decap_4
X_4221_ _4221_/A _4221_/B vssd1 vssd1 vccd1 vccd1 _4222_/C sky130_fd_sc_hd__xnor2_1
XFILLER_0_10_147 vssd1 vssd1 vccd1 vccd1 sky130_fd_sc_hd__decap_4
XFILLER_0_10_136 vssd1 vssd1 vccd1 vccd1 sky130_fd_sc_hd__fill_2
XFILLER_0_128_21 vssd1 vssd1 vccd1 vccd1 sky130_fd_sc_hd__fill_1
X_4152_ _4152_/A _4152_/B vssd1 vssd1 vccd1 vccd1 _4154_/A sky130_fd_sc_hd__nor2_1
XFILLER_0_49_8 vssd1 vssd1 vccd1 vccd1 sky130_fd_sc_hd__fill_2
X_4083_ _4432_/A _4776_/A _4070_/A _4068_/B vssd1 vssd1 vccd1 vccd1 _4086_/A sky130_fd_sc_hd__a31o_1
XFILLER_0_37_74 vssd1 vssd1 vccd1 vccd1 sky130_fd_sc_hd__fill_2
XFILLER_0_92_106 vssd1 vssd1 vccd1 vccd1 sky130_fd_sc_hd__decap_3
X_4985_ _4984_/B _4984_/C _4984_/A vssd1 vssd1 vccd1 vccd1 _4985_/Y sky130_fd_sc_hd__a21oi_2
XFILLER_0_58_361 vssd1 vssd1 vccd1 vccd1 sky130_fd_sc_hd__decap_3
XFILLER_0_135_208 vssd1 vssd1 vccd1 vccd1 sky130_fd_sc_hd__fill_1
X_6724_ _6855_/CLK _6724_/D _6073_/A vssd1 vssd1 vccd1 vccd1 _6724_/Q sky130_fd_sc_hd__dfstp_1
XANTENNA_fanout143_A fanout144/X vssd1 vssd1 vccd1 vccd1 sky130_fd_sc_hd__diode_2
XFILLER_0_18_225 vssd1 vssd1 vccd1 vccd1 sky130_fd_sc_hd__fill_1
X_3936_ _3936_/A _3936_/B _3936_/C vssd1 vssd1 vccd1 vccd1 _3938_/A sky130_fd_sc_hd__or3_2
XFILLER_0_58_394 vssd1 vssd1 vccd1 vccd1 sky130_ef_sc_hd__decap_12
X_6655_ _6864_/CLK _6655_/D vssd1 vssd1 vccd1 vccd1 hold54/A sky130_fd_sc_hd__dfxtp_1
X_3867_ _3813_/B _3867_/B _3867_/C vssd1 vssd1 vccd1 vccd1 _3891_/A sky130_fd_sc_hd__and3b_1
X_6586_ _6818_/CLK _6586_/D fanout151/X vssd1 vssd1 vccd1 vccd1 depth_mport_o[30]
+ sky130_fd_sc_hd__dfrtp_4
X_5606_ _4942_/A _3274_/Y _3275_/Y _5687_/A vssd1 vssd1 vccd1 vccd1 _5606_/X sky130_fd_sc_hd__o22a_1
X_3798_ _3798_/A _3798_/B _3798_/C vssd1 vssd1 vccd1 vccd1 _3919_/A sky130_fd_sc_hd__and3_1
XFILLER_0_26_291 vssd1 vssd1 vccd1 vccd1 sky130_fd_sc_hd__fill_2
X_5537_ depth_mport_o[12] hold144/X _5541_/S vssd1 vssd1 vccd1 vccd1 _6568_/D sky130_fd_sc_hd__mux2_1
XFILLER_0_103_116 vssd1 vssd1 vccd1 vccd1 sky130_fd_sc_hd__decap_4
XANTENNA__4562__B1 _4841_/C vssd1 vssd1 vccd1 vccd1 sky130_fd_sc_hd__diode_2
X_5468_ _5468_/A sstream_i[114] sstream_o vssd1 vssd1 vccd1 vccd1 _5468_/X sky130_fd_sc_hd__and3_2
XFILLER_0_78_81 vssd1 vssd1 vccd1 vccd1 sky130_fd_sc_hd__decap_3
X_4419_ _4418_/B _4416_/X _4409_/X _4411_/X vssd1 vssd1 vccd1 vccd1 _4419_/X sky130_fd_sc_hd__a211o_1
X_5399_ _5392_/A _5392_/B _4707_/A vssd1 vssd1 vccd1 vccd1 _5400_/B sky130_fd_sc_hd__a21oi_1
XFILLER_0_94_91 vssd1 vssd1 vccd1 vccd1 sky130_fd_sc_hd__fill_2
XFILLER_0_96_401 vssd1 vssd1 vccd1 vccd1 sky130_fd_sc_hd__decap_6
XANTENNA_fanout56_A _6673_/Q vssd1 vssd1 vccd1 vccd1 sky130_fd_sc_hd__diode_2
XFILLER_0_83_106 vssd1 vssd1 vccd1 vccd1 sky130_fd_sc_hd__fill_2
XFILLER_0_49_350 vssd1 vssd1 vccd1 vccd1 sky130_fd_sc_hd__fill_1
XFILLER_0_56_309 vssd1 vssd1 vccd1 vccd1 sky130_fd_sc_hd__fill_1
XFILLER_0_83_139 vssd1 vssd1 vccd1 vccd1 sky130_fd_sc_hd__fill_2
XANTENNA__4553__B1 _4551_/D vssd1 vssd1 vccd1 vccd1 sky130_fd_sc_hd__diode_2
XANTENNA__3950__C _5115_/D vssd1 vssd1 vccd1 vccd1 sky130_fd_sc_hd__diode_2
XANTENNA__6038__C _6038_/C vssd1 vssd1 vccd1 vccd1 sky130_fd_sc_hd__diode_2
XANTENNA__3959__A _5081_/B vssd1 vssd1 vccd1 vccd1 sky130_fd_sc_hd__diode_2
XANTENNA__6335__A hold75/X vssd1 vssd1 vccd1 vccd1 sky130_fd_sc_hd__diode_2
XFILLER_0_99_294 vssd1 vssd1 vccd1 vccd1 sky130_fd_sc_hd__fill_1
XFILLER_0_114_12 vssd1 vssd1 vccd1 vccd1 sky130_ef_sc_hd__decap_12
XFILLER_0_59_158 vssd1 vssd1 vccd1 vccd1 sky130_fd_sc_hd__fill_2
XFILLER_0_59_169 vssd1 vssd1 vccd1 vccd1 sky130_fd_sc_hd__fill_2
XFILLER_0_114_56 vssd1 vssd1 vccd1 vccd1 sky130_fd_sc_hd__fill_2
XFILLER_0_128_3 vssd1 vssd1 vccd1 vccd1 sky130_fd_sc_hd__decap_3
XFILLER_0_114_89 vssd1 vssd1 vccd1 vccd1 sky130_fd_sc_hd__decap_3
X_4770_ _4771_/A _4771_/B vssd1 vssd1 vccd1 vccd1 _4770_/X sky130_fd_sc_hd__or2_1
X_3721_ _3721_/A _3721_/B _3721_/C vssd1 vssd1 vccd1 vccd1 _3735_/B sky130_fd_sc_hd__nor3_1
XFILLER_0_23_98 vssd1 vssd1 vccd1 vccd1 sky130_fd_sc_hd__fill_1
X_6440_ depth_mport_o[53] _6440_/B vssd1 vssd1 vccd1 vccd1 _6831_/D sky130_fd_sc_hd__and2_1
XFILLER_0_130_33 vssd1 vssd1 vccd1 vccd1 sky130_fd_sc_hd__decap_3
XFILLER_0_82_183 vssd1 vssd1 vccd1 vccd1 sky130_fd_sc_hd__decap_4
X_3652_ _3653_/A _3653_/B vssd1 vssd1 vccd1 vccd1 _3675_/B sky130_fd_sc_hd__and2_1
X_6371_ _6378_/A _6370_/Y depth_mport_o[44] _6441_/B vssd1 vssd1 vccd1 vccd1 _6822_/D
+ sky130_fd_sc_hd__o2bb2a_1
XFILLER_0_70_356 vssd1 vssd1 vccd1 vccd1 sky130_fd_sc_hd__fill_2
X_3583_ _3587_/B _3583_/B vssd1 vssd1 vccd1 vccd1 _3585_/B sky130_fd_sc_hd__nand2_1
XFILLER_0_70_389 vssd1 vssd1 vccd1 vccd1 sky130_ef_sc_hd__decap_12
X_5322_ _5051_/A _6688_/Q _3482_/A _3480_/B vssd1 vssd1 vccd1 vccd1 _5330_/A sky130_fd_sc_hd__a31o_1
XFILLER_0_2_133 vssd1 vssd1 vccd1 vccd1 sky130_fd_sc_hd__decap_4
X_5253_ _5254_/A _5254_/B vssd1 vssd1 vccd1 vccd1 _5340_/A sky130_fd_sc_hd__or2_1
X_4204_ _4203_/A _4203_/B _4203_/C vssd1 vssd1 vccd1 vccd1 _4205_/C sky130_fd_sc_hd__a21o_1
X_5184_ _5177_/A _5177_/C _5177_/B vssd1 vssd1 vccd1 vccd1 _5184_/X sky130_fd_sc_hd__o21a_1
X_4135_ _4135_/A _4135_/B vssd1 vssd1 vccd1 vccd1 _4230_/A sky130_fd_sc_hd__xor2_1
X_4066_ _4794_/B _4736_/B _4789_/C _4816_/A vssd1 vssd1 vccd1 vccd1 _4068_/A sky130_fd_sc_hd__a22oi_1
XFILLER_0_38_309 vssd1 vssd1 vccd1 vccd1 sky130_fd_sc_hd__fill_2
X_4968_ _4966_/X _4968_/B vssd1 vssd1 vccd1 vccd1 _4969_/B sky130_fd_sc_hd__and2b_1
X_6707_ _6827_/CLK hold68/X vssd1 vssd1 vccd1 vccd1 hold67/A sky130_fd_sc_hd__dfxtp_1
X_4899_ _4898_/A _4898_/B _4898_/C vssd1 vssd1 vccd1 vccd1 _4900_/C sky130_fd_sc_hd__a21o_1
X_3919_ _3919_/A _3919_/B _3918_/X vssd1 vssd1 vccd1 vccd1 _3923_/A sky130_fd_sc_hd__nor3b_2
XFILLER_0_73_194 vssd1 vssd1 vccd1 vccd1 sky130_fd_sc_hd__fill_1
X_6638_ _6745_/CLK _6638_/D fanout140/X vssd1 vssd1 vccd1 vccd1 _6638_/Q sky130_fd_sc_hd__dfstp_1
XFILLER_0_116_296 vssd1 vssd1 vccd1 vccd1 sky130_fd_sc_hd__fill_2
XFILLER_0_21_209 vssd1 vssd1 vccd1 vccd1 sky130_fd_sc_hd__decap_4
XFILLER_0_61_378 vssd1 vssd1 vccd1 vccd1 sky130_ef_sc_hd__decap_12
X_6569_ _6862_/CLK _6569_/D _6320_/C vssd1 vssd1 vccd1 vccd1 depth_mport_o[13] sky130_fd_sc_hd__dfrtp_4
Xfanout130 tex_width_i[11] vssd1 vssd1 vccd1 vccd1 _5754_/A sky130_fd_sc_hd__buf_4
Xfanout152 fanout153/X vssd1 vssd1 vccd1 vccd1 fanout152/X sky130_fd_sc_hd__clkbuf_8
XANTENNA__3510__A1 _5273_/A vssd1 vssd1 vccd1 vccd1 sky130_fd_sc_hd__diode_2
Xfanout141 nrst_i vssd1 vssd1 vccd1 vccd1 _5937_/A sky130_fd_sc_hd__clkbuf_8
XFILLER_0_88_209 vssd1 vssd1 vccd1 vccd1 sky130_fd_sc_hd__fill_2
XANTENNA__4066__A2 _4736_/B vssd1 vssd1 vccd1 vccd1 sky130_fd_sc_hd__diode_2
XTAP_1132 vssd1 vccd1 sky130_fd_sc_hd__tapvpwrvgnd_1
XTAP_1121 vssd1 vccd1 sky130_fd_sc_hd__tapvpwrvgnd_1
XTAP_1110 vssd1 vccd1 sky130_fd_sc_hd__tapvpwrvgnd_1
XFILLER_0_96_242 vssd1 vssd1 vccd1 vccd1 sky130_fd_sc_hd__decap_3
XTAP_1165 vssd1 vccd1 sky130_fd_sc_hd__tapvpwrvgnd_1
XTAP_1154 vssd1 vccd1 sky130_fd_sc_hd__tapvpwrvgnd_1
XTAP_1143 vssd1 vccd1 sky130_fd_sc_hd__tapvpwrvgnd_1
XTAP_1198 vssd1 vccd1 sky130_fd_sc_hd__tapvpwrvgnd_1
XTAP_1187 vssd1 vccd1 sky130_fd_sc_hd__tapvpwrvgnd_1
XTAP_1176 vssd1 vccd1 sky130_fd_sc_hd__tapvpwrvgnd_1
XFILLER_0_64_161 vssd1 vssd1 vccd1 vccd1 sky130_fd_sc_hd__fill_2
XFILLER_0_52_334 vssd1 vssd1 vccd1 vccd1 sky130_fd_sc_hd__fill_2
XFILLER_0_107_285 vssd1 vssd1 vccd1 vccd1 sky130_fd_sc_hd__fill_2
XFILLER_0_110_406 vssd1 vssd1 vccd1 vccd1 sky130_fd_sc_hd__fill_1
XFILLER_0_122_266 vssd1 vssd1 vccd1 vccd1 sky130_fd_sc_hd__fill_2
XTAP_916 vssd1 vccd1 sky130_fd_sc_hd__tapvpwrvgnd_1
XTAP_905 vssd1 vccd1 sky130_fd_sc_hd__tapvpwrvgnd_1
XFILLER_0_20_253 vssd1 vssd1 vccd1 vccd1 sky130_fd_sc_hd__fill_2
XANTENNA__3961__B _5083_/B vssd1 vssd1 vccd1 vccd1 sky130_fd_sc_hd__diode_2
XANTENNA__4829__A1 _4842_/A vssd1 vssd1 vccd1 vccd1 sky130_fd_sc_hd__diode_2
XTAP_949 vssd1 vccd1 sky130_fd_sc_hd__tapvpwrvgnd_1
XTAP_938 vssd1 vccd1 sky130_fd_sc_hd__tapvpwrvgnd_1
XTAP_927 vssd1 vccd1 sky130_fd_sc_hd__tapvpwrvgnd_1
XANTENNA__4829__B2 _5787_/A vssd1 vssd1 vccd1 vccd1 sky130_fd_sc_hd__diode_2
XFILLER_0_18_76 vssd1 vssd1 vccd1 vccd1 sky130_fd_sc_hd__fill_2
XFILLER_0_87_220 vssd1 vssd1 vccd1 vccd1 sky130_fd_sc_hd__decap_4
X_5940_ _5944_/A tex_height_i[11] _3283_/Y tex_height_i[10] vssd1 vssd1 vccd1 vccd1
+ _5962_/A sky130_fd_sc_hd__a22o_1
X_5871_ _5867_/A _5867_/B _5599_/A vssd1 vssd1 vccd1 vccd1 _5871_/X sky130_fd_sc_hd__a21o_1
X_4822_ _5115_/C _4822_/B vssd1 vssd1 vccd1 vccd1 _4826_/A sky130_fd_sc_hd__nand2_1
XANTENNA__3568__B2 _5081_/B vssd1 vssd1 vccd1 vccd1 sky130_fd_sc_hd__diode_2
XFILLER_0_7_247 vssd1 vssd1 vccd1 vccd1 sky130_fd_sc_hd__fill_2
XFILLER_0_7_236 vssd1 vssd1 vccd1 vccd1 sky130_fd_sc_hd__fill_2
XFILLER_0_7_225 vssd1 vssd1 vccd1 vccd1 sky130_fd_sc_hd__fill_2
XANTENNA__3568__A1 _5081_/A vssd1 vssd1 vccd1 vccd1 sky130_fd_sc_hd__diode_2
X_4753_ _4752_/B _4752_/C _4752_/A vssd1 vssd1 vccd1 vccd1 _4754_/C sky130_fd_sc_hd__a21o_1
XFILLER_0_70_120 vssd1 vssd1 vccd1 vccd1 sky130_fd_sc_hd__fill_1
X_3704_ _3678_/A _3678_/B _3687_/B _3678_/D vssd1 vssd1 vccd1 vccd1 _3704_/X sky130_fd_sc_hd__a22o_1
XFILLER_0_43_334 vssd1 vssd1 vccd1 vccd1 sky130_fd_sc_hd__fill_2
XFILLER_0_50_85 vssd1 vssd1 vccd1 vccd1 sky130_fd_sc_hd__fill_2
X_6423_ _6543_/Q hold70/A _6408_/B _6412_/X vssd1 vssd1 vccd1 vccd1 _6425_/B sky130_fd_sc_hd__a31oi_1
XFILLER_0_113_222 vssd1 vssd1 vccd1 vccd1 sky130_fd_sc_hd__fill_2
X_4684_ _5376_/A _5375_/A vssd1 vssd1 vccd1 vccd1 _4684_/Y sky130_fd_sc_hd__nor2_1
XANTENNA__4517__B1 _4518_/D vssd1 vssd1 vccd1 vccd1 sky130_fd_sc_hd__diode_2
XFILLER_0_50_96 vssd1 vssd1 vccd1 vccd1 sky130_fd_sc_hd__decap_4
XANTENNA__4032__B _5718_/B vssd1 vssd1 vccd1 vccd1 sky130_fd_sc_hd__diode_2
XFILLER_0_70_197 vssd1 vssd1 vccd1 vccd1 sky130_fd_sc_hd__fill_1
X_3635_ _3959_/B _5273_/A _5272_/A _3961_/A vssd1 vssd1 vccd1 vccd1 _3637_/A sky130_fd_sc_hd__a22o_1
XANTENNA__5843__S _5922_/S vssd1 vssd1 vccd1 vccd1 sky130_fd_sc_hd__diode_2
X_6354_ hold60/A _6539_/Q vssd1 vssd1 vccd1 vccd1 _6355_/C sky130_fd_sc_hd__or2_1
X_3566_ _3566_/A _3566_/B vssd1 vssd1 vccd1 vccd1 _3573_/A sky130_fd_sc_hd__xnor2_1
X_6285_ _3294_/Y _6863_/Q _3302_/Y depth_mport_i[24] _6284_/X vssd1 vssd1 vccd1 vccd1
+ _6289_/C sky130_fd_sc_hd__a221o_1
X_5305_ _3455_/A _3455_/B _3456_/Y vssd1 vssd1 vccd1 vccd1 _5307_/A sky130_fd_sc_hd__o21a_1
X_3497_ _5286_/A _5273_/B vssd1 vssd1 vccd1 vccd1 _3537_/B sky130_fd_sc_hd__nand2_1
XANTENNA__3740__A1 _5049_/A vssd1 vssd1 vccd1 vccd1 sky130_fd_sc_hd__diode_2
XANTENNA__3740__B2 _5049_/B vssd1 vssd1 vccd1 vccd1 sky130_fd_sc_hd__diode_2
X_5236_ _5237_/A _5237_/B vssd1 vssd1 vccd1 vccd1 _5416_/B sky130_fd_sc_hd__or2_1
XFILLER_0_52_3 vssd1 vssd1 vccd1 vccd1 sky130_fd_sc_hd__decap_3
X_5167_ _5156_/A _5156_/C _5156_/B vssd1 vssd1 vccd1 vccd1 _5167_/X sky130_fd_sc_hd__o21a_1
XANTENNA__6442__A0 hold206/X vssd1 vssd1 vccd1 vccd1 sky130_fd_sc_hd__diode_2
X_4118_ _4117_/A _4117_/B _4117_/C vssd1 vssd1 vccd1 vccd1 _4119_/C sky130_fd_sc_hd__a21o_1
X_5098_ _5098_/A _5098_/B _5098_/C vssd1 vssd1 vccd1 vccd1 _5100_/B sky130_fd_sc_hd__nand3_1
X_4049_ _5701_/A _5687_/A _4518_/D _4476_/D vssd1 vssd1 vccd1 vccd1 _4052_/A sky130_fd_sc_hd__nand4_1
XFILLER_0_78_253 vssd1 vssd1 vccd1 vccd1 sky130_fd_sc_hd__fill_2
XPHY_215 vssd1 vssd1 vccd1 vccd1 sky130_fd_sc_hd__decap_3
XPHY_204 vssd1 vssd1 vccd1 vccd1 sky130_fd_sc_hd__decap_3
XFILLER_0_38_117 vssd1 vssd1 vccd1 vccd1 sky130_fd_sc_hd__decap_3
XFILLER_0_136_314 vssd1 vssd1 vccd1 vccd1 sky130_fd_sc_hd__fill_2
XPHY_259 vssd1 vssd1 vccd1 vccd1 sky130_fd_sc_hd__decap_3
XPHY_248 vssd1 vssd1 vccd1 vccd1 sky130_fd_sc_hd__decap_3
XPHY_237 vssd1 vssd1 vccd1 vccd1 sky130_fd_sc_hd__decap_3
XPHY_226 vssd1 vssd1 vccd1 vccd1 sky130_fd_sc_hd__decap_3
XFILLER_0_93_245 vssd1 vssd1 vccd1 vccd1 sky130_fd_sc_hd__fill_2
XFILLER_0_53_109 vssd1 vssd1 vccd1 vccd1 sky130_fd_sc_hd__decap_3
XANTENNA_fanout19_A _6315_/S vssd1 vssd1 vccd1 vccd1 sky130_fd_sc_hd__diode_2
XFILLER_0_46_194 vssd1 vssd1 vccd1 vccd1 sky130_fd_sc_hd__fill_2
XFILLER_0_104_277 vssd1 vssd1 vccd1 vccd1 sky130_fd_sc_hd__fill_2
XANTENNA__6632__SET_B fanout144/X vssd1 vssd1 vccd1 vccd1 sky130_fd_sc_hd__diode_2
Xhold8 hold8/A vssd1 vssd1 vccd1 vccd1 hold8/X sky130_fd_sc_hd__dlygate4sd3_1
XANTENNA__4039__A2 _4736_/B vssd1 vssd1 vccd1 vccd1 sky130_fd_sc_hd__diode_2
XANTENNA__3302__A _6857_/Q vssd1 vssd1 vccd1 vccd1 sky130_fd_sc_hd__diode_2
XANTENNA__5928__S _5932_/S vssd1 vssd1 vccd1 vccd1 sky130_fd_sc_hd__diode_2
XFILLER_0_84_212 vssd1 vssd1 vccd1 vccd1 sky130_fd_sc_hd__fill_2
XFILLER_0_84_201 vssd1 vssd1 vccd1 vccd1 sky130_fd_sc_hd__fill_2
XFILLER_0_69_275 vssd1 vssd1 vccd1 vccd1 sky130_fd_sc_hd__fill_2
XANTENNA__3659__D _5272_/B vssd1 vssd1 vccd1 vccd1 sky130_fd_sc_hd__diode_2
XFILLER_0_29_106 vssd1 vssd1 vccd1 vccd1 sky130_fd_sc_hd__fill_2
XFILLER_0_29_117 vssd1 vssd1 vccd1 vccd1 sky130_fd_sc_hd__fill_2
XFILLER_0_84_289 vssd1 vssd1 vccd1 vccd1 sky130_fd_sc_hd__fill_1
XANTENNA__4747__B1 _4776_/A vssd1 vssd1 vccd1 vccd1 sky130_fd_sc_hd__diode_2
XFILLER_0_20_33 vssd1 vssd1 vccd1 vccd1 sky130_fd_sc_hd__fill_1
XFILLER_0_52_131 vssd1 vssd1 vccd1 vccd1 sky130_fd_sc_hd__decap_3
XFILLER_0_135_391 vssd1 vssd1 vccd1 vccd1 sky130_fd_sc_hd__fill_1
XFILLER_0_111_79 vssd1 vssd1 vccd1 vccd1 sky130_fd_sc_hd__fill_2
XFILLER_0_20_44 vssd1 vssd1 vccd1 vccd1 sky130_fd_sc_hd__fill_2
XFILLER_0_40_326 vssd1 vssd1 vccd1 vccd1 sky130_fd_sc_hd__fill_1
X_3420_ _5296_/A _5276_/A _5273_/B _5272_/B vssd1 vssd1 vccd1 vccd1 _3470_/A sky130_fd_sc_hd__and4_1
XFILLER_0_52_197 vssd1 vssd1 vccd1 vccd1 sky130_fd_sc_hd__fill_2
X_3351_ _3352_/A _3351_/B _5320_/A _5273_/B vssd1 vssd1 vccd1 vccd1 _3649_/A sky130_fd_sc_hd__and4b_1
XTAP_724 vssd1 vccd1 sky130_fd_sc_hd__tapvpwrvgnd_1
XFILLER_0_29_31 vssd1 vssd1 vccd1 vccd1 sky130_fd_sc_hd__fill_2
XTAP_702 vssd1 vccd1 sky130_fd_sc_hd__tapvpwrvgnd_1
XTAP_713 vssd1 vccd1 sky130_fd_sc_hd__tapvpwrvgnd_1
X_6070_ hold34/X _6553_/Q _6072_/S vssd1 vssd1 vccd1 vccd1 hold35/A sky130_fd_sc_hd__mux2_1
XTAP_768 vssd1 vccd1 sky130_fd_sc_hd__tapvpwrvgnd_1
XTAP_757 vssd1 vccd1 sky130_fd_sc_hd__tapvpwrvgnd_1
XTAP_746 vssd1 vccd1 sky130_fd_sc_hd__tapvpwrvgnd_1
XTAP_735 vssd1 vccd1 sky130_fd_sc_hd__tapvpwrvgnd_1
X_3282_ _6876_/Q vssd1 vssd1 vccd1 vccd1 _5944_/A sky130_fd_sc_hd__inv_2
XTAP_779 vssd1 vccd1 sky130_fd_sc_hd__tapvpwrvgnd_1
X_5021_ _4919_/Y _5004_/X _5007_/Y _5017_/X vssd1 vssd1 vccd1 vccd1 _5021_/X sky130_fd_sc_hd__a211o_1
XFILLER_0_31_8 vssd1 vssd1 vccd1 vccd1 sky130_fd_sc_hd__decap_4
X_6972_ vssd1 vssd1 vccd1 vccd1 _6972_/HI tex_mport_o[25] sky130_fd_sc_hd__conb_1
X_5923_ hold186/X _5922_/X _5923_/S vssd1 vssd1 vccd1 vccd1 _6652_/D sky130_fd_sc_hd__mux2_1
XFILLER_0_75_223 vssd1 vssd1 vccd1 vccd1 sky130_fd_sc_hd__fill_1
X_5854_ _5863_/C _5851_/X _5852_/Y _5599_/A vssd1 vssd1 vccd1 vccd1 _5854_/X sky130_fd_sc_hd__a31o_1
XFILLER_0_118_336 vssd1 vssd1 vccd1 vccd1 sky130_fd_sc_hd__fill_2
X_4805_ _4804_/B _4804_/C _4804_/A vssd1 vssd1 vccd1 vccd1 _4805_/X sky130_fd_sc_hd__o21a_1
XFILLER_0_61_84 vssd1 vssd1 vccd1 vccd1 sky130_fd_sc_hd__fill_1
XFILLER_0_118_369 vssd1 vssd1 vccd1 vccd1 sky130_ef_sc_hd__decap_12
X_5785_ hold236/X _5784_/X _5844_/S vssd1 vssd1 vccd1 vccd1 _6634_/D sky130_fd_sc_hd__mux2_1
XFILLER_0_133_328 vssd1 vssd1 vccd1 vccd1 sky130_fd_sc_hd__fill_1
XFILLER_0_28_194 vssd1 vssd1 vccd1 vccd1 sky130_fd_sc_hd__fill_2
XFILLER_0_43_120 vssd1 vssd1 vccd1 vccd1 sky130_fd_sc_hd__fill_2
X_4736_ _5071_/A _4736_/B _5051_/B _4736_/D vssd1 vssd1 vccd1 vccd1 _4737_/B sky130_fd_sc_hd__and4_1
X_4667_ _4667_/A _4667_/B _4667_/C vssd1 vssd1 vccd1 vccd1 _4668_/B sky130_fd_sc_hd__nor3_1
XFILLER_0_43_164 vssd1 vssd1 vccd1 vccd1 sky130_fd_sc_hd__fill_2
X_6406_ depth_mport_o[47] _6440_/B _6415_/A _6405_/Y vssd1 vssd1 vccd1 vccd1 _6825_/D
+ sky130_fd_sc_hd__a22o_1
XFILLER_0_101_203 vssd1 vssd1 vccd1 vccd1 sky130_fd_sc_hd__fill_1
X_3618_ _3619_/B _3620_/A vssd1 vssd1 vccd1 vccd1 _3621_/A sky130_fd_sc_hd__nand2b_1
XFILLER_0_31_337 vssd1 vssd1 vccd1 vccd1 sky130_fd_sc_hd__fill_2
X_6337_ depth_mport_o[40] _6440_/B _6335_/X _6336_/Y vssd1 vssd1 vccd1 vccd1 _6818_/D
+ sky130_fd_sc_hd__a22o_1
XFILLER_0_101_236 vssd1 vssd1 vccd1 vccd1 sky130_fd_sc_hd__fill_2
X_4598_ _4612_/A _4598_/B vssd1 vssd1 vccd1 vccd1 _4600_/B sky130_fd_sc_hd__xnor2_1
X_3549_ _3961_/A _5300_/A vssd1 vssd1 vccd1 vccd1 _3566_/B sky130_fd_sc_hd__nand2_1
X_6268_ _6268_/A _6268_/B vssd1 vssd1 vccd1 vccd1 _6268_/Y sky130_fd_sc_hd__nor2_1
XFILLER_0_86_81 vssd1 vssd1 vccd1 vccd1 sky130_fd_sc_hd__decap_3
X_6199_ _6791_/Q hold49/A vssd1 vssd1 vccd1 vccd1 _6202_/A sky130_fd_sc_hd__xnor2_1
X_5219_ _5111_/X _5113_/Y _5252_/A _5218_/Y vssd1 vssd1 vccd1 vccd1 _5252_/B sky130_fd_sc_hd__a211oi_2
XFILLER_0_66_212 vssd1 vssd1 vccd1 vccd1 sky130_fd_sc_hd__fill_1
XANTENNA__6433__A _6546_/Q vssd1 vssd1 vccd1 vccd1 sky130_fd_sc_hd__diode_2
XANTENNA__5049__A _5049_/A vssd1 vssd1 vccd1 vccd1 sky130_fd_sc_hd__diode_2
XFILLER_0_22_304 vssd1 vssd1 vccd1 vccd1 sky130_fd_sc_hd__fill_2
XFILLER_0_34_164 vssd1 vssd1 vccd1 vccd1 sky130_fd_sc_hd__fill_1
XFILLER_0_132_361 vssd1 vssd1 vccd1 vccd1 sky130_fd_sc_hd__decap_3
XFILLER_0_89_304 vssd1 vssd1 vccd1 vccd1 sky130_fd_sc_hd__fill_2
XFILLER_0_15_55 vssd1 vssd1 vccd1 vccd1 sky130_fd_sc_hd__fill_1
XFILLER_0_57_201 vssd1 vssd1 vccd1 vccd1 sky130_fd_sc_hd__fill_2
XFILLER_0_127_111 vssd1 vssd1 vccd1 vccd1 sky130_fd_sc_hd__fill_1
XFILLER_0_57_256 vssd1 vssd1 vccd1 vccd1 sky130_fd_sc_hd__fill_1
XFILLER_0_31_43 vssd1 vssd1 vccd1 vccd1 sky130_fd_sc_hd__fill_1
XFILLER_0_110_3 vssd1 vssd1 vccd1 vccd1 sky130_fd_sc_hd__decap_8
X_5570_ _5384_/B tex_mport_o[38] _5576_/S vssd1 vssd1 vccd1 vccd1 _6595_/D sky130_fd_sc_hd__mux2_1
X_4521_ _4515_/A _4515_/B _4563_/A vssd1 vssd1 vccd1 vccd1 _4522_/C sky130_fd_sc_hd__a21o_1
XFILLER_0_80_270 vssd1 vssd1 vccd1 vccd1 sky130_fd_sc_hd__fill_2
Xhold205 _6297_/X vssd1 vssd1 vccd1 vccd1 _6782_/D sky130_fd_sc_hd__dlygate4sd3_1
XFILLER_0_123_361 vssd1 vssd1 vccd1 vccd1 sky130_fd_sc_hd__decap_3
XFILLER_0_123_350 vssd1 vssd1 vccd1 vccd1 sky130_fd_sc_hd__fill_1
X_4452_ _4452_/A _4452_/B vssd1 vssd1 vccd1 vccd1 _4454_/B sky130_fd_sc_hd__xnor2_1
XFILLER_0_25_197 vssd1 vssd1 vccd1 vccd1 sky130_fd_sc_hd__fill_2
Xhold216 _6876_/Q vssd1 vssd1 vccd1 vccd1 hold216/X sky130_fd_sc_hd__dlygate4sd3_1
Xhold249 _6096_/X vssd1 vssd1 vccd1 vccd1 _6734_/D sky130_fd_sc_hd__dlygate4sd3_1
X_3403_ _3409_/B _3409_/A vssd1 vssd1 vccd1 vccd1 _3411_/A sky130_fd_sc_hd__and2b_1
Xhold227 _6112_/X vssd1 vssd1 vccd1 vccd1 _6750_/D sky130_fd_sc_hd__dlygate4sd3_1
Xhold238 _6748_/Q vssd1 vssd1 vccd1 vccd1 hold238/X sky130_fd_sc_hd__dlygate4sd3_1
X_4383_ _4383_/A _4383_/B vssd1 vssd1 vccd1 vccd1 _4385_/B sky130_fd_sc_hd__xor2_1
XFILLER_0_0_231 vssd1 vssd1 vccd1 vccd1 sky130_fd_sc_hd__fill_2
XFILLER_0_0_264 vssd1 vssd1 vccd1 vccd1 sky130_fd_sc_hd__fill_2
XFILLER_0_21_381 vssd1 vssd1 vccd1 vccd1 sky130_fd_sc_hd__decap_8
X_6122_ hold57/X pix_mport_o[6] _6223_/B vssd1 vssd1 vccd1 vccd1 _6758_/D sky130_fd_sc_hd__mux2_1
X_3334_ _6783_/Q _6782_/Q vssd1 vssd1 vccd1 vccd1 _3335_/B sky130_fd_sc_hd__nor2_1
XTAP_510 vssd1 vccd1 sky130_fd_sc_hd__tapvpwrvgnd_1
XTAP_521 vssd1 vccd1 sky130_fd_sc_hd__tapvpwrvgnd_1
XTAP_532 vssd1 vccd1 sky130_fd_sc_hd__tapvpwrvgnd_1
XTAP_543 vssd1 vccd1 sky130_fd_sc_hd__tapvpwrvgnd_1
X_3265_ depth_mport_i[32] vssd1 vssd1 vccd1 vccd1 _3265_/Y sky130_fd_sc_hd__inv_2
X_6053_ hold132/X _6038_/B _6054_/B1 vssd1 vssd1 vccd1 vccd1 _6692_/D sky130_fd_sc_hd__a21o_1
XTAP_554 vssd1 vccd1 sky130_fd_sc_hd__tapvpwrvgnd_1
XTAP_565 vssd1 vccd1 sky130_fd_sc_hd__tapvpwrvgnd_1
XTAP_576 vssd1 vccd1 sky130_fd_sc_hd__tapvpwrvgnd_1
X_5004_ _4919_/A _4919_/C _4919_/B vssd1 vssd1 vccd1 vccd1 _5004_/X sky130_fd_sc_hd__a21o_1
XTAP_587 vssd1 vccd1 sky130_fd_sc_hd__tapvpwrvgnd_1
XTAP_598 vssd1 vccd1 sky130_fd_sc_hd__tapvpwrvgnd_1
XFILLER_0_15_3 vssd1 vssd1 vccd1 vccd1 sky130_ef_sc_hd__decap_12
X_6955_ vssd1 vssd1 vccd1 vccd1 _6955_/HI tex_mport_o[8] sky130_fd_sc_hd__conb_1
XANTENNA__4959__B1 _4814_/D vssd1 vssd1 vccd1 vccd1 sky130_fd_sc_hd__diode_2
X_5906_ tex_addr_i[29] _5913_/B vssd1 vssd1 vccd1 vccd1 _5907_/B sky130_fd_sc_hd__nand2_1
XFILLER_0_48_223 vssd1 vssd1 vccd1 vccd1 sky130_fd_sc_hd__fill_2
X_6886_ _6892_/CLK _6886_/D vssd1 vssd1 vccd1 vccd1 hold90/A sky130_fd_sc_hd__dfxtp_1
XFILLER_0_118_133 vssd1 vssd1 vccd1 vccd1 sky130_fd_sc_hd__decap_4
XFILLER_0_8_331 vssd1 vssd1 vccd1 vccd1 sky130_fd_sc_hd__decap_4
X_5837_ _5837_/A _5837_/B _5837_/C vssd1 vssd1 vccd1 vccd1 _5837_/Y sky130_fd_sc_hd__nor3_1
X_5768_ _5767_/Y _6518_/Q _5768_/S vssd1 vssd1 vccd1 vccd1 _5770_/B sky130_fd_sc_hd__mux2_1
X_4719_ _4716_/X _4719_/B vssd1 vssd1 vccd1 vccd1 _4758_/B sky130_fd_sc_hd__and2b_1
XFILLER_0_121_309 vssd1 vssd1 vccd1 vccd1 sky130_fd_sc_hd__fill_2
XFILLER_0_114_361 vssd1 vssd1 vccd1 vccd1 sky130_fd_sc_hd__decap_3
X_5699_ _5683_/A _5683_/B _5695_/D _5695_/A vssd1 vssd1 vccd1 vccd1 _5699_/X sky130_fd_sc_hd__a211o_1
XFILLER_0_71_281 vssd1 vssd1 vccd1 vccd1 sky130_fd_sc_hd__fill_1
XFILLER_0_12_381 vssd1 vssd1 vccd1 vccd1 sky130_ef_sc_hd__decap_12
XANTENNA_fanout86_A _4814_/D vssd1 vssd1 vccd1 vccd1 sky130_fd_sc_hd__diode_2
XANTENNA__3528__A2_N _5300_/A vssd1 vssd1 vccd1 vccd1 sky130_fd_sc_hd__diode_2
XANTENNA__5051__B _5051_/B vssd1 vssd1 vccd1 vccd1 sky130_fd_sc_hd__diode_2
XFILLER_0_86_307 vssd1 vssd1 vccd1 vccd1 sky130_fd_sc_hd__fill_1
XANTENNA__3787__A _5300_/A vssd1 vssd1 vccd1 vccd1 sky130_fd_sc_hd__diode_2
XFILLER_0_39_223 vssd1 vssd1 vccd1 vccd1 sky130_fd_sc_hd__fill_1
XFILLER_0_94_362 vssd1 vssd1 vccd1 vccd1 sky130_fd_sc_hd__fill_2
XFILLER_0_39_245 vssd1 vssd1 vccd1 vccd1 sky130_fd_sc_hd__fill_1
XFILLER_0_54_248 vssd1 vssd1 vccd1 vccd1 sky130_fd_sc_hd__decap_4
XFILLER_0_112_309 vssd1 vssd1 vccd1 vccd1 sky130_fd_sc_hd__fill_1
XFILLER_0_22_145 vssd1 vssd1 vccd1 vccd1 sky130_fd_sc_hd__fill_1
XANTENNA__6338__A _6539_/Q vssd1 vssd1 vccd1 vccd1 sky130_fd_sc_hd__diode_2
XFILLER_0_117_78 vssd1 vssd1 vccd1 vccd1 sky130_fd_sc_hd__fill_2
XANTENNA__3668__A1_N _5299_/A vssd1 vssd1 vccd1 vccd1 sky130_fd_sc_hd__diode_2
XANTENNA__3861__B1 _5118_/B vssd1 vssd1 vccd1 vccd1 sky130_fd_sc_hd__diode_2
XFILLER_0_77_318 vssd1 vssd1 vccd1 vccd1 sky130_fd_sc_hd__decap_6
X_6740_ _6745_/CLK _6740_/D fanout140/X vssd1 vssd1 vccd1 vccd1 _6740_/Q sky130_fd_sc_hd__dfstp_1
X_3952_ _3950_/X _3952_/B vssd1 vssd1 vccd1 vccd1 _3954_/A sky130_fd_sc_hd__and2b_1
X_6671_ _6880_/CLK _6671_/D vssd1 vssd1 vccd1 vccd1 _6671_/Q sky130_fd_sc_hd__dfxtp_1
X_3883_ _5327_/A _6684_/Q _5276_/B _5091_/A vssd1 vssd1 vccd1 vccd1 _3887_/D sky130_fd_sc_hd__a22o_1
XFILLER_0_42_75 vssd1 vssd1 vccd1 vccd1 sky130_fd_sc_hd__fill_1
X_5622_ _5732_/A _3271_/Y _5623_/B _5718_/A vssd1 vssd1 vccd1 vccd1 _5626_/A sky130_fd_sc_hd__a22o_1
XFILLER_0_5_301 vssd1 vssd1 vccd1 vccd1 sky130_fd_sc_hd__fill_2
X_5553_ depth_mport_o[28] hold191/X _5556_/S vssd1 vssd1 vccd1 vccd1 _6584_/D sky130_fd_sc_hd__mux2_1
XFILLER_0_5_334 vssd1 vssd1 vccd1 vccd1 sky130_fd_sc_hd__fill_2
X_4504_ _4500_/Y _4509_/A _4503_/X _4460_/Y vssd1 vssd1 vccd1 vccd1 _4507_/A sky130_fd_sc_hd__a211oi_1
X_5484_ hold166/X sstream_i[75] _6450_/S vssd1 vssd1 vccd1 vccd1 _6517_/D sky130_fd_sc_hd__mux2_1
XFILLER_0_13_156 vssd1 vssd1 vccd1 vccd1 sky130_fd_sc_hd__fill_1
X_4435_ _4433_/X _4435_/B vssd1 vssd1 vccd1 vccd1 _4436_/B sky130_fd_sc_hd__and2b_1
XANTENNA__4040__B _5083_/A vssd1 vssd1 vccd1 vccd1 sky130_fd_sc_hd__diode_2
XFILLER_0_13_178 vssd1 vssd1 vccd1 vccd1 sky130_fd_sc_hd__fill_2
XFILLER_0_111_364 vssd1 vssd1 vccd1 vccd1 sky130_fd_sc_hd__fill_2
X_4366_ _4366_/A _4370_/A vssd1 vssd1 vccd1 vccd1 _4712_/B sky130_fd_sc_hd__or2_2
XFILLER_0_6_53 vssd1 vssd1 vccd1 vccd1 sky130_ef_sc_hd__decap_12
X_3317_ depth_mport_i[11] vssd1 vssd1 vccd1 vccd1 _6252_/A sky130_fd_sc_hd__inv_2
XTAP_351 vssd1 vccd1 sky130_fd_sc_hd__tapvpwrvgnd_1
XTAP_340 vssd1 vccd1 sky130_fd_sc_hd__tapvpwrvgnd_1
XFILLER_0_6_97 vssd1 vssd1 vccd1 vccd1 sky130_ef_sc_hd__decap_12
X_6105_ _6644_/Q hold242/X _6113_/S vssd1 vssd1 vccd1 vccd1 _6105_/X sky130_fd_sc_hd__mux2_1
X_4297_ _4297_/A _4297_/B vssd1 vssd1 vccd1 vccd1 _4298_/B sky130_fd_sc_hd__nand2_1
XTAP_384 vssd1 vccd1 sky130_fd_sc_hd__tapvpwrvgnd_1
XTAP_373 vssd1 vccd1 sky130_fd_sc_hd__tapvpwrvgnd_1
XTAP_362 vssd1 vccd1 sky130_fd_sc_hd__tapvpwrvgnd_1
XTAP_395 vssd1 vccd1 sky130_fd_sc_hd__tapvpwrvgnd_1
X_6036_ _6035_/Y hold217/X _6038_/C vssd1 vssd1 vccd1 vccd1 _6036_/X sky130_fd_sc_hd__mux2_1
XPHY_13 vssd1 vssd1 vccd1 vccd1 sky130_fd_sc_hd__decap_3
XPHY_24 vssd1 vssd1 vccd1 vccd1 sky130_fd_sc_hd__decap_3
XPHY_35 vssd1 vssd1 vccd1 vccd1 sky130_fd_sc_hd__decap_3
XPHY_46 vssd1 vssd1 vccd1 vccd1 sky130_fd_sc_hd__decap_3
X_6938_ vssd1 vssd1 vccd1 vccd1 _6938_/HI pix_mport_o[58] sky130_fd_sc_hd__conb_1
XPHY_57 vssd1 vssd1 vccd1 vccd1 sky130_fd_sc_hd__decap_3
XPHY_68 vssd1 vssd1 vccd1 vccd1 sky130_fd_sc_hd__decap_3
XPHY_79 vssd1 vssd1 vccd1 vccd1 sky130_fd_sc_hd__decap_3
XFILLER_0_91_310 vssd1 vssd1 vccd1 vccd1 sky130_fd_sc_hd__fill_2
X_6869_ _6880_/CLK _6869_/D vssd1 vssd1 vccd1 vccd1 _6869_/Q sky130_fd_sc_hd__dfxtp_1
XFILLER_0_134_401 vssd1 vssd1 vccd1 vccd1 sky130_fd_sc_hd__decap_6
XFILLER_0_8_194 vssd1 vssd1 vccd1 vccd1 sky130_fd_sc_hd__fill_2
XFILLER_0_121_106 vssd1 vssd1 vccd1 vccd1 sky130_fd_sc_hd__fill_2
XANTENNA__5327__A _5327_/A vssd1 vssd1 vccd1 vccd1 sky130_fd_sc_hd__diode_2
XANTENNA__3383__A2 _5296_/B vssd1 vssd1 vccd1 vccd1 sky130_fd_sc_hd__diode_2
XANTENNA__4332__A1 _4736_/D vssd1 vssd1 vccd1 vccd1 sky130_fd_sc_hd__diode_2
XANTENNA__4332__B2 _4736_/B vssd1 vssd1 vccd1 vccd1 sky130_fd_sc_hd__diode_2
XFILLER_0_4_3 vssd1 vssd1 vccd1 vccd1 sky130_ef_sc_hd__decap_12
XANTENNA__5596__A0 _5434_/X vssd1 vssd1 vccd1 vccd1 sky130_fd_sc_hd__diode_2
XFILLER_0_137_8 vssd1 vssd1 vccd1 vccd1 sky130_fd_sc_hd__fill_2
XFILLER_0_82_332 vssd1 vssd1 vccd1 vccd1 sky130_fd_sc_hd__fill_2
XFILLER_0_6_109 vssd1 vssd1 vccd1 vccd1 sky130_ef_sc_hd__decap_12
XFILLER_0_82_365 vssd1 vssd1 vccd1 vccd1 sky130_ef_sc_hd__decap_12
XFILLER_0_35_281 vssd1 vssd1 vccd1 vccd1 sky130_fd_sc_hd__decap_4
XFILLER_0_112_139 vssd1 vssd1 vccd1 vccd1 sky130_fd_sc_hd__fill_1
XANTENNA__4141__A _4551_/D vssd1 vssd1 vccd1 vccd1 sky130_fd_sc_hd__diode_2
X_4220_ _4104_/A _4104_/C _4104_/B vssd1 vssd1 vccd1 vccd1 _4222_/B sky130_fd_sc_hd__a21o_1
XFILLER_0_10_159 vssd1 vssd1 vccd1 vccd1 sky130_fd_sc_hd__decap_4
XFILLER_0_128_33 vssd1 vssd1 vccd1 vccd1 sky130_fd_sc_hd__fill_2
X_4151_ _4736_/B _4736_/D _4944_/B _5049_/D vssd1 vssd1 vccd1 vccd1 _4152_/B sky130_fd_sc_hd__and4_1
X_4082_ _4089_/A _4089_/B vssd1 vssd1 vccd1 vccd1 _4082_/X sky130_fd_sc_hd__or2_1
XANTENNA__5700__A _5701_/A vssd1 vssd1 vccd1 vccd1 sky130_fd_sc_hd__diode_2
XFILLER_0_53_52 vssd1 vssd1 vccd1 vccd1 sky130_fd_sc_hd__fill_2
X_4984_ _4984_/A _4984_/B _4984_/C vssd1 vssd1 vccd1 vccd1 _4984_/Y sky130_fd_sc_hd__nand3_2
XFILLER_0_53_74 vssd1 vssd1 vccd1 vccd1 sky130_fd_sc_hd__fill_2
X_6723_ _6841_/CLK _6723_/D fanout145/X vssd1 vssd1 vccd1 vccd1 _6723_/Q sky130_fd_sc_hd__dfstp_1
XFILLER_0_18_204 vssd1 vssd1 vccd1 vccd1 sky130_ef_sc_hd__decap_12
X_3935_ _3854_/X _3904_/Y _3932_/A _3931_/Y vssd1 vssd1 vccd1 vccd1 _3936_/C sky130_fd_sc_hd__a211oi_1
X_6654_ _6864_/CLK _6654_/D vssd1 vssd1 vccd1 vccd1 _6654_/Q sky130_fd_sc_hd__dfxtp_1
XFILLER_0_85_181 vssd1 vssd1 vccd1 vccd1 sky130_fd_sc_hd__fill_2
XFILLER_0_73_343 vssd1 vssd1 vccd1 vccd1 sky130_fd_sc_hd__fill_1
XFILLER_0_73_332 vssd1 vssd1 vccd1 vccd1 sky130_fd_sc_hd__fill_2
XFILLER_0_18_259 vssd1 vssd1 vccd1 vccd1 sky130_fd_sc_hd__fill_2
XANTENNA_fanout136_A _4789_/B vssd1 vssd1 vccd1 vccd1 sky130_fd_sc_hd__diode_2
X_5605_ _6510_/Q _3249_/Y _5687_/A _3275_/Y vssd1 vssd1 vccd1 vccd1 _5612_/B sky130_fd_sc_hd__a2bb2o_1
XFILLER_0_73_376 vssd1 vssd1 vccd1 vccd1 sky130_fd_sc_hd__fill_2
X_3866_ _5051_/B _5083_/B _3805_/C _3805_/D vssd1 vssd1 vccd1 vccd1 _3867_/C sky130_fd_sc_hd__a22o_1
X_6585_ _6827_/CLK _6585_/D fanout151/X vssd1 vssd1 vccd1 vccd1 depth_mport_o[29]
+ sky130_fd_sc_hd__dfrtp_4
XFILLER_0_82_3 vssd1 vssd1 vccd1 vccd1 sky130_fd_sc_hd__decap_3
XFILLER_0_5_142 vssd1 vssd1 vccd1 vccd1 sky130_fd_sc_hd__fill_2
X_3797_ _3797_/A _3797_/B vssd1 vssd1 vccd1 vccd1 _3798_/C sky130_fd_sc_hd__xor2_1
X_5536_ depth_mport_o[11] hold123/X _5541_/S vssd1 vssd1 vccd1 vccd1 _6567_/D sky130_fd_sc_hd__mux2_1
XANTENNA__4562__B2 _5687_/B vssd1 vssd1 vccd1 vccd1 sky130_fd_sc_hd__diode_2
XANTENNA__4562__A1 _5687_/A vssd1 vssd1 vccd1 vccd1 sky130_fd_sc_hd__diode_2
X_5467_ _6803_/Q _6807_/Q vssd1 vssd1 vccd1 vccd1 filt_depth_fly_o sky130_fd_sc_hd__and2_4
XFILLER_0_78_60 vssd1 vssd1 vccd1 vccd1 sky130_fd_sc_hd__fill_1
X_4418_ _4418_/A _4418_/B _4418_/C vssd1 vssd1 vccd1 vccd1 _4709_/A sky130_fd_sc_hd__and3_1
XANTENNA__5581__S _5601_/S vssd1 vssd1 vccd1 vccd1 sky130_fd_sc_hd__diode_2
XFILLER_0_1_370 vssd1 vssd1 vccd1 vccd1 sky130_fd_sc_hd__fill_2
X_5398_ _6734_/Q _5398_/B vssd1 vssd1 vccd1 vccd1 _5402_/C sky130_fd_sc_hd__nand2_1
XANTENNA__6067__A1 _6550_/Q vssd1 vssd1 vccd1 vccd1 sky130_fd_sc_hd__diode_2
X_4349_ _4350_/B _4350_/A vssd1 vssd1 vccd1 vccd1 _4352_/A sky130_fd_sc_hd__nand2b_1
X_6019_ _5081_/A _6018_/X _6037_/S vssd1 vssd1 vccd1 vccd1 _6673_/D sky130_fd_sc_hd__mux2_1
XFILLER_0_68_137 vssd1 vssd1 vccd1 vccd1 sky130_fd_sc_hd__decap_3
XFILLER_0_68_115 vssd1 vssd1 vccd1 vccd1 sky130_fd_sc_hd__fill_2
XANTENNA_fanout49_A _5049_/D vssd1 vssd1 vccd1 vccd1 sky130_fd_sc_hd__diode_2
XFILLER_0_64_321 vssd1 vssd1 vccd1 vccd1 sky130_fd_sc_hd__fill_2
XFILLER_0_91_184 vssd1 vssd1 vccd1 vccd1 sky130_fd_sc_hd__decap_4
XFILLER_0_17_281 vssd1 vssd1 vccd1 vccd1 sky130_fd_sc_hd__fill_2
XFILLER_0_24_229 vssd1 vssd1 vccd1 vccd1 sky130_fd_sc_hd__decap_3
XANTENNA__4553__B2 _4789_/B vssd1 vssd1 vccd1 vccd1 sky130_fd_sc_hd__diode_2
XANTENNA__5750__B1 _5796_/A vssd1 vssd1 vccd1 vccd1 sky130_fd_sc_hd__diode_2
XANTENNA__3761__C1 _5276_/B vssd1 vssd1 vccd1 vccd1 sky130_fd_sc_hd__diode_2
XFILLER_0_102_150 vssd1 vssd1 vccd1 vccd1 sky130_fd_sc_hd__fill_2
XANTENNA__3950__D _5118_/B vssd1 vssd1 vccd1 vccd1 sky130_fd_sc_hd__diode_2
XFILLER_0_114_24 vssd1 vssd1 vccd1 vccd1 sky130_fd_sc_hd__fill_1
XANTENNA__4136__A _4966_/A vssd1 vssd1 vccd1 vccd1 sky130_fd_sc_hd__diode_2
XFILLER_0_23_44 vssd1 vssd1 vccd1 vccd1 sky130_fd_sc_hd__fill_2
X_3720_ _3721_/B _3721_/C _3721_/A vssd1 vssd1 vccd1 vccd1 _3735_/A sky130_fd_sc_hd__o21a_1
XFILLER_0_99_37 vssd1 vssd1 vccd1 vccd1 sky130_fd_sc_hd__fill_2
XFILLER_0_55_354 vssd1 vssd1 vccd1 vccd1 sky130_fd_sc_hd__fill_1
XFILLER_0_130_45 vssd1 vssd1 vccd1 vccd1 sky130_fd_sc_hd__fill_2
XFILLER_0_82_195 vssd1 vssd1 vccd1 vccd1 sky130_fd_sc_hd__fill_1
X_3651_ _3651_/A _3651_/B vssd1 vssd1 vccd1 vccd1 _3653_/B sky130_fd_sc_hd__xnor2_1
X_6370_ _6369_/A _6381_/B _6440_/B vssd1 vssd1 vccd1 vccd1 _6370_/Y sky130_fd_sc_hd__a21oi_1
XFILLER_0_125_297 vssd1 vssd1 vccd1 vccd1 sky130_fd_sc_hd__decap_8
XFILLER_0_125_286 vssd1 vssd1 vccd1 vccd1 sky130_fd_sc_hd__fill_2
X_3582_ _3560_/B _3564_/X _3577_/Y _3580_/X vssd1 vssd1 vccd1 vccd1 _3583_/B sky130_fd_sc_hd__o211ai_1
X_5321_ _5321_/A _5321_/B vssd1 vssd1 vccd1 vccd1 _5331_/A sky130_fd_sc_hd__xor2_1
XANTENNA__6581__RESET_B fanout149/X vssd1 vssd1 vccd1 vccd1 sky130_fd_sc_hd__diode_2
X_5252_ _5252_/A _5252_/B vssd1 vssd1 vccd1 vccd1 _5254_/B sky130_fd_sc_hd__nor2_1
XFILLER_0_48_52 vssd1 vssd1 vccd1 vccd1 sky130_fd_sc_hd__decap_3
X_4203_ _4203_/A _4203_/B _4203_/C vssd1 vssd1 vccd1 vccd1 _4205_/B sky130_fd_sc_hd__nand3_4
XANTENNA__3860__D _5118_/B vssd1 vssd1 vccd1 vccd1 sky130_fd_sc_hd__diode_2
X_5183_ _5183_/A _5183_/B vssd1 vssd1 vccd1 vccd1 _5203_/A sky130_fd_sc_hd__and2_1
XFILLER_0_48_63 vssd1 vssd1 vccd1 vccd1 sky130_fd_sc_hd__fill_1
XFILLER_0_48_85 vssd1 vssd1 vccd1 vccd1 sky130_fd_sc_hd__fill_1
X_4134_ _4135_/B _4135_/A vssd1 vssd1 vccd1 vccd1 _4134_/X sky130_fd_sc_hd__and2b_1
X_4065_ _4065_/A _4065_/B _4065_/C vssd1 vssd1 vccd1 vccd1 _4072_/A sky130_fd_sc_hd__nand3_2
XFILLER_0_93_405 vssd1 vssd1 vccd1 vccd1 sky130_fd_sc_hd__fill_2
XANTENNA__3885__A _5290_/A vssd1 vssd1 vccd1 vccd1 sky130_fd_sc_hd__diode_2
X_4967_ _4966_/A _4966_/B _4966_/C _5115_/C vssd1 vssd1 vccd1 vccd1 _4968_/B sky130_fd_sc_hd__a22o_1
XFILLER_0_58_192 vssd1 vssd1 vccd1 vccd1 sky130_fd_sc_hd__fill_2
X_6706_ _6827_/CLK hold96/X vssd1 vssd1 vccd1 vccd1 hold95/A sky130_fd_sc_hd__dfxtp_1
XFILLER_0_104_90 vssd1 vssd1 vccd1 vccd1 sky130_fd_sc_hd__decap_3
X_4898_ _4898_/A _4898_/B _4898_/C vssd1 vssd1 vccd1 vccd1 _4912_/A sky130_fd_sc_hd__nand3_1
X_3918_ _3917_/B _3917_/C _3917_/A vssd1 vssd1 vccd1 vccd1 _3918_/X sky130_fd_sc_hd__a21bo_1
XANTENNA__5980__A0 _4841_/D vssd1 vssd1 vccd1 vccd1 sky130_fd_sc_hd__diode_2
XFILLER_0_46_376 vssd1 vssd1 vccd1 vccd1 sky130_ef_sc_hd__decap_12
X_6637_ _6751_/CLK _6637_/D fanout140/X vssd1 vssd1 vccd1 vccd1 _6637_/Q sky130_fd_sc_hd__dfstp_1
X_3849_ _3846_/A _3846_/B _3850_/B vssd1 vssd1 vccd1 vccd1 _3849_/X sky130_fd_sc_hd__a21o_1
XFILLER_0_61_313 vssd1 vssd1 vccd1 vccd1 sky130_fd_sc_hd__decap_4
XFILLER_0_61_335 vssd1 vssd1 vccd1 vccd1 sky130_fd_sc_hd__fill_1
X_6568_ _6862_/CLK _6568_/D _6320_/C vssd1 vssd1 vccd1 vccd1 depth_mport_o[12] sky130_fd_sc_hd__dfrtp_4
X_5519_ hold200/X sstream_i[110] _6473_/S vssd1 vssd1 vccd1 vccd1 _6552_/D sky130_fd_sc_hd__mux2_1
XFILLER_0_14_251 vssd1 vssd1 vccd1 vccd1 sky130_fd_sc_hd__fill_1
X_6499_ hold36/X sstream_i[57] _6501_/S vssd1 vssd1 vccd1 vccd1 _6890_/D sky130_fd_sc_hd__mux2_1
XFILLER_0_14_284 vssd1 vssd1 vccd1 vccd1 sky130_fd_sc_hd__fill_2
Xclkbuf_leaf_0_clk_i clkbuf_leaf_1_clk_i/A vssd1 vssd1 vccd1 vccd1 _6892_/CLK sky130_fd_sc_hd__clkbuf_16
XANTENNA__3422__A1_N _5320_/A vssd1 vssd1 vccd1 vccd1 sky130_fd_sc_hd__diode_2
Xfanout131 _5754_/B vssd1 vssd1 vccd1 vccd1 _5286_/A sky130_fd_sc_hd__buf_4
Xfanout120 _4832_/C vssd1 vssd1 vccd1 vccd1 _5787_/A sky130_fd_sc_hd__buf_4
Xfanout153 nrst_i vssd1 vssd1 vccd1 vccd1 fanout153/X sky130_fd_sc_hd__buf_6
Xfanout142 fanout144/X vssd1 vssd1 vccd1 vccd1 fanout142/X sky130_fd_sc_hd__clkbuf_8
XFILLER_0_96_221 vssd1 vssd1 vccd1 vccd1 sky130_fd_sc_hd__decap_8
XFILLER_0_96_210 vssd1 vssd1 vccd1 vccd1 sky130_fd_sc_hd__fill_1
XTAP_1122 vssd1 vccd1 sky130_fd_sc_hd__tapvpwrvgnd_1
XTAP_1111 vssd1 vccd1 sky130_fd_sc_hd__tapvpwrvgnd_1
XTAP_1100 vssd1 vccd1 sky130_fd_sc_hd__tapvpwrvgnd_1
XFILLER_0_84_405 vssd1 vssd1 vccd1 vccd1 sky130_fd_sc_hd__fill_2
XTAP_1155 vssd1 vccd1 sky130_fd_sc_hd__tapvpwrvgnd_1
XTAP_1144 vssd1 vccd1 sky130_fd_sc_hd__tapvpwrvgnd_1
XTAP_1133 vssd1 vccd1 sky130_fd_sc_hd__tapvpwrvgnd_1
XFILLER_0_56_129 vssd1 vssd1 vccd1 vccd1 sky130_fd_sc_hd__fill_2
XTAP_1199 vssd1 vccd1 sky130_fd_sc_hd__tapvpwrvgnd_1
XTAP_1188 vssd1 vccd1 sky130_fd_sc_hd__tapvpwrvgnd_1
XTAP_1177 vssd1 vccd1 sky130_fd_sc_hd__tapvpwrvgnd_1
XTAP_1166 vssd1 vccd1 sky130_fd_sc_hd__tapvpwrvgnd_1
XFILLER_0_122_234 vssd1 vssd1 vccd1 vccd1 sky130_fd_sc_hd__fill_2
XFILLER_0_20_210 vssd1 vssd1 vccd1 vccd1 sky130_fd_sc_hd__fill_2
XTAP_917 vssd1 vccd1 sky130_fd_sc_hd__tapvpwrvgnd_1
XTAP_906 vssd1 vccd1 sky130_fd_sc_hd__tapvpwrvgnd_1
XFILLER_0_20_265 vssd1 vssd1 vccd1 vccd1 sky130_fd_sc_hd__fill_2
XTAP_939 vssd1 vccd1 sky130_fd_sc_hd__tapvpwrvgnd_1
XTAP_928 vssd1 vccd1 sky130_fd_sc_hd__tapvpwrvgnd_1
XFILLER_0_20_287 vssd1 vssd1 vccd1 vccd1 sky130_fd_sc_hd__fill_2
XFILLER_0_18_66 vssd1 vssd1 vccd1 vccd1 sky130_fd_sc_hd__fill_2
XANTENNA__6346__A _6555_/Q vssd1 vssd1 vccd1 vccd1 sky130_fd_sc_hd__diode_2
X_5870_ _5807_/B _5812_/X _5837_/Y _5864_/Y _5804_/A vssd1 vssd1 vccd1 vccd1 _5870_/Y
+ sky130_fd_sc_hd__o2111ai_2
XFILLER_0_75_405 vssd1 vssd1 vccd1 vccd1 sky130_fd_sc_hd__fill_2
X_4821_ _4821_/A _4821_/B vssd1 vssd1 vccd1 vccd1 _4855_/A sky130_fd_sc_hd__xor2_2
XFILLER_0_28_365 vssd1 vssd1 vccd1 vccd1 sky130_fd_sc_hd__fill_1
X_4752_ _4752_/A _4752_/B _4752_/C vssd1 vssd1 vccd1 vccd1 _4754_/B sky130_fd_sc_hd__nand3_2
X_4683_ _4689_/A vssd1 vssd1 vccd1 vccd1 _5375_/A sky130_fd_sc_hd__inv_2
X_3703_ _3703_/A _3703_/B vssd1 vssd1 vccd1 vccd1 _3774_/A sky130_fd_sc_hd__nand2_1
XFILLER_0_28_387 vssd1 vssd1 vccd1 vccd1 sky130_ef_sc_hd__decap_12
X_6422_ _6422_/A _6422_/B vssd1 vssd1 vccd1 vccd1 _6425_/A sky130_fd_sc_hd__or2_1
XANTENNA__4517__B2 _4789_/B vssd1 vssd1 vccd1 vccd1 sky130_fd_sc_hd__diode_2
XANTENNA__4517__A1 _4789_/C vssd1 vssd1 vccd1 vccd1 sky130_fd_sc_hd__diode_2
X_3634_ _3634_/A _3634_/B vssd1 vssd1 vccd1 vccd1 _3706_/A sky130_fd_sc_hd__xor2_1
XFILLER_0_113_234 vssd1 vssd1 vccd1 vccd1 sky130_fd_sc_hd__fill_1
X_6353_ hold60/A _6539_/Q vssd1 vssd1 vccd1 vccd1 _6365_/A sky130_fd_sc_hd__nand2_2
X_3565_ _3565_/A _3565_/B vssd1 vssd1 vccd1 vccd1 _3578_/A sky130_fd_sc_hd__xor2_1
X_6284_ _6864_/Q depth_mport_i[31] vssd1 vssd1 vccd1 vccd1 _6284_/X sky130_fd_sc_hd__xor2_1
X_5304_ _5304_/A _5304_/B vssd1 vssd1 vccd1 vccd1 _5318_/A sky130_fd_sc_hd__xnor2_1
X_3496_ _3494_/X _3496_/B vssd1 vssd1 vccd1 vccd1 _3537_/A sky130_fd_sc_hd__nand2b_1
X_5235_ _5235_/A _5235_/B vssd1 vssd1 vccd1 vccd1 _5237_/B sky130_fd_sc_hd__nor2_1
XFILLER_0_45_3 vssd1 vssd1 vccd1 vccd1 sky130_fd_sc_hd__decap_3
X_5166_ _5160_/A _5160_/C _5160_/D _5160_/B vssd1 vssd1 vccd1 vccd1 _5166_/X sky130_fd_sc_hd__a22o_1
X_4117_ _4117_/A _4117_/B _4117_/C vssd1 vssd1 vccd1 vccd1 _4119_/B sky130_fd_sc_hd__nand3_2
X_5097_ _3979_/X _5095_/Y _5054_/A _5051_/C vssd1 vssd1 vccd1 vccd1 _5098_/C sky130_fd_sc_hd__o211ai_1
X_4048_ _4047_/B _4047_/C _4047_/A vssd1 vssd1 vccd1 vccd1 _4054_/B sky130_fd_sc_hd__a21o_1
XFILLER_0_78_243 vssd1 vssd1 vccd1 vccd1 sky130_fd_sc_hd__fill_1
XPHY_216 vssd1 vssd1 vccd1 vccd1 sky130_fd_sc_hd__decap_3
XPHY_205 vssd1 vssd1 vccd1 vccd1 sky130_fd_sc_hd__decap_3
XFILLER_0_78_265 vssd1 vssd1 vccd1 vccd1 sky130_fd_sc_hd__fill_1
XPHY_249 vssd1 vssd1 vccd1 vccd1 sky130_fd_sc_hd__decap_3
XPHY_238 vssd1 vssd1 vccd1 vccd1 sky130_fd_sc_hd__decap_3
XPHY_227 vssd1 vssd1 vccd1 vccd1 sky130_fd_sc_hd__decap_3
X_5999_ tex_height_i[7] _6002_/C vssd1 vssd1 vccd1 vccd1 _5999_/Y sky130_fd_sc_hd__xnor2_1
XFILLER_0_61_176 vssd1 vssd1 vccd1 vccd1 sky130_fd_sc_hd__decap_3
Xhold9 hold9/A vssd1 vssd1 vccd1 vccd1 hold9/X sky130_fd_sc_hd__dlygate4sd3_1
XFILLER_0_57_405 vssd1 vssd1 vccd1 vccd1 sky130_fd_sc_hd__fill_2
XFILLER_0_127_315 vssd1 vssd1 vccd1 vccd1 sky130_fd_sc_hd__decap_4
XFILLER_0_84_246 vssd1 vssd1 vccd1 vccd1 sky130_fd_sc_hd__fill_2
XFILLER_0_127_337 vssd1 vssd1 vccd1 vccd1 sky130_fd_sc_hd__decap_8
XFILLER_0_84_257 vssd1 vssd1 vccd1 vccd1 sky130_fd_sc_hd__fill_1
XANTENNA__4747__A1 _4816_/A vssd1 vssd1 vccd1 vccd1 sky130_fd_sc_hd__diode_2
XANTENNA__4747__B2 _4942_/A vssd1 vssd1 vccd1 vccd1 sky130_fd_sc_hd__diode_2
XFILLER_0_25_324 vssd1 vssd1 vccd1 vccd1 sky130_fd_sc_hd__fill_1
XFILLER_0_96_27 vssd1 vssd1 vccd1 vccd1 sky130_fd_sc_hd__fill_1
X_3350_ _3351_/B vssd1 vssd1 vccd1 vccd1 _3350_/Y sky130_fd_sc_hd__inv_2
XTAP_725 vssd1 vccd1 sky130_fd_sc_hd__tapvpwrvgnd_1
XFILLER_0_29_43 vssd1 vssd1 vccd1 vccd1 sky130_fd_sc_hd__fill_2
XTAP_703 vssd1 vccd1 sky130_fd_sc_hd__tapvpwrvgnd_1
XTAP_714 vssd1 vccd1 sky130_fd_sc_hd__tapvpwrvgnd_1
XTAP_758 vssd1 vccd1 sky130_fd_sc_hd__tapvpwrvgnd_1
XTAP_747 vssd1 vccd1 sky130_fd_sc_hd__tapvpwrvgnd_1
XTAP_736 vssd1 vccd1 sky130_fd_sc_hd__tapvpwrvgnd_1
X_3281_ _6877_/Q vssd1 vssd1 vccd1 vccd1 _5945_/B sky130_fd_sc_hd__inv_2
XFILLER_0_29_87 vssd1 vssd1 vccd1 vccd1 sky130_fd_sc_hd__fill_1
X_5020_ _5020_/A vssd1 vssd1 vccd1 vccd1 _5020_/Y sky130_fd_sc_hd__inv_2
XTAP_769 vssd1 vccd1 sky130_fd_sc_hd__tapvpwrvgnd_1
X_6971_ vssd1 vssd1 vccd1 vccd1 _6971_/HI tex_mport_o[24] sky130_fd_sc_hd__conb_1
X_5922_ _5457_/B _5921_/Y _5922_/S vssd1 vssd1 vccd1 vccd1 _5922_/X sky130_fd_sc_hd__mux2_1
XFILLER_0_118_304 vssd1 vssd1 vccd1 vccd1 sky130_fd_sc_hd__fill_2
X_5853_ _5851_/X _5852_/Y _5863_/C vssd1 vssd1 vccd1 vccd1 _5853_/Y sky130_fd_sc_hd__a21oi_1
XFILLER_0_118_315 vssd1 vssd1 vccd1 vccd1 sky130_fd_sc_hd__fill_2
X_5784_ _5401_/B _5783_/Y _5784_/S vssd1 vssd1 vccd1 vccd1 _5784_/X sky130_fd_sc_hd__mux2_1
X_4804_ _4804_/A _4804_/B _4804_/C vssd1 vssd1 vccd1 vccd1 _4804_/Y sky130_fd_sc_hd__nor3_1
X_4735_ _5071_/A _4736_/B _5051_/B _4789_/C vssd1 vssd1 vccd1 vccd1 _4737_/A sky130_fd_sc_hd__a22oi_1
XFILLER_0_126_370 vssd1 vssd1 vccd1 vccd1 sky130_ef_sc_hd__decap_12
X_4666_ _4666_/A _4672_/B vssd1 vssd1 vccd1 vccd1 _4670_/B sky130_fd_sc_hd__nor2_1
X_6405_ _6404_/A _6404_/B _6440_/B vssd1 vssd1 vccd1 vccd1 _6405_/Y sky130_fd_sc_hd__a21oi_1
X_4597_ _4612_/A _4598_/B vssd1 vssd1 vccd1 vccd1 _4597_/X sky130_fd_sc_hd__or2_1
X_3617_ _3620_/B _3620_/C vssd1 vssd1 vccd1 vccd1 _3619_/B sky130_fd_sc_hd__nor2_1
XFILLER_0_43_187 vssd1 vssd1 vccd1 vccd1 sky130_fd_sc_hd__fill_1
XFILLER_0_43_198 vssd1 vssd1 vccd1 vccd1 sky130_fd_sc_hd__fill_2
X_6336_ hold75/X _6335_/B _6440_/B vssd1 vssd1 vccd1 vccd1 _6336_/Y sky130_fd_sc_hd__a21oi_1
X_3548_ _3546_/X _3548_/B vssd1 vssd1 vccd1 vccd1 _3566_/A sky130_fd_sc_hd__nand2b_1
X_6267_ depth_mport_i[7] _3321_/Y _6266_/X vssd1 vssd1 vccd1 vccd1 _6267_/Y sky130_fd_sc_hd__o21ai_1
XFILLER_0_86_60 vssd1 vssd1 vccd1 vccd1 sky130_fd_sc_hd__fill_2
X_3479_ _5049_/A _5292_/A _6686_/Q _6687_/Q vssd1 vssd1 vccd1 vccd1 _3480_/B sky130_fd_sc_hd__and4_1
X_6198_ _6185_/X _6193_/A _6194_/Y vssd1 vssd1 vccd1 vccd1 _6204_/A sky130_fd_sc_hd__a21o_1
XFILLER_0_86_93 vssd1 vssd1 vccd1 vccd1 sky130_fd_sc_hd__decap_4
X_5218_ _5215_/X _5216_/Y _5164_/B _5163_/Y vssd1 vssd1 vccd1 vccd1 _5218_/Y sky130_fd_sc_hd__a211oi_1
XFILLER_0_98_305 vssd1 vssd1 vccd1 vccd1 sky130_fd_sc_hd__decap_3
X_5149_ _5148_/A _5148_/B _5131_/X vssd1 vssd1 vccd1 vccd1 _5149_/X sky130_fd_sc_hd__o21ba_1
XFILLER_0_39_405 vssd1 vssd1 vccd1 vccd1 sky130_fd_sc_hd__fill_2
XANTENNA_fanout31_A _6095_/S vssd1 vssd1 vccd1 vccd1 sky130_fd_sc_hd__diode_2
XFILLER_0_66_235 vssd1 vssd1 vccd1 vccd1 sky130_fd_sc_hd__fill_2
XFILLER_0_81_205 vssd1 vssd1 vccd1 vccd1 sky130_fd_sc_hd__fill_2
XANTENNA__4729__A1 _4774_/B vssd1 vssd1 vccd1 vccd1 sky130_fd_sc_hd__diode_2
XFILLER_0_19_173 vssd1 vssd1 vccd1 vccd1 sky130_fd_sc_hd__decap_4
XANTENNA__5049__B _5049_/B vssd1 vssd1 vccd1 vccd1 sky130_fd_sc_hd__diode_2
XFILLER_0_136_189 vssd1 vssd1 vccd1 vccd1 sky130_fd_sc_hd__fill_1
XFILLER_0_136_178 vssd1 vssd1 vccd1 vccd1 sky130_fd_sc_hd__fill_2
XFILLER_0_124_307 vssd1 vssd1 vccd1 vccd1 sky130_fd_sc_hd__fill_1
XANTENNA__5764__S _5844_/S vssd1 vssd1 vccd1 vccd1 sky130_fd_sc_hd__diode_2
XFILLER_0_19_195 vssd1 vssd1 vccd1 vccd1 sky130_fd_sc_hd__decap_4
XFILLER_0_132_373 vssd1 vssd1 vccd1 vccd1 sky130_ef_sc_hd__decap_12
XFILLER_0_89_327 vssd1 vssd1 vccd1 vccd1 sky130_fd_sc_hd__fill_1
XFILLER_0_82_29 vssd1 vssd1 vccd1 vccd1 sky130_fd_sc_hd__fill_2
XANTENNA__5090__B1 _5286_/B vssd1 vssd1 vccd1 vccd1 sky130_fd_sc_hd__diode_2
XFILLER_0_97_393 vssd1 vssd1 vccd1 vccd1 sky130_ef_sc_hd__decap_12
XFILLER_0_15_78 vssd1 vssd1 vccd1 vccd1 sky130_fd_sc_hd__fill_2
XFILLER_0_57_235 vssd1 vssd1 vccd1 vccd1 sky130_fd_sc_hd__fill_2
XANTENNA__5917__B1 _5599_/X vssd1 vssd1 vccd1 vccd1 sky130_fd_sc_hd__diode_2
XFILLER_0_127_167 vssd1 vssd1 vccd1 vccd1 sky130_fd_sc_hd__fill_1
XFILLER_0_115_307 vssd1 vssd1 vccd1 vccd1 sky130_fd_sc_hd__fill_2
XANTENNA__5674__S _5784_/S vssd1 vssd1 vccd1 vccd1 sky130_fd_sc_hd__diode_2
XFILLER_0_25_110 vssd1 vssd1 vccd1 vccd1 sky130_fd_sc_hd__fill_2
XFILLER_0_25_132 vssd1 vssd1 vccd1 vccd1 sky130_fd_sc_hd__fill_2
XANTENNA__3983__A _5091_/A vssd1 vssd1 vccd1 vccd1 sky130_fd_sc_hd__diode_2
XFILLER_0_31_66 vssd1 vssd1 vccd1 vccd1 sky130_fd_sc_hd__fill_2
X_4520_ _4520_/A _4520_/B vssd1 vssd1 vccd1 vccd1 _4522_/B sky130_fd_sc_hd__xnor2_1
XFILLER_0_40_102 vssd1 vssd1 vccd1 vccd1 sky130_fd_sc_hd__fill_2
Xhold206 _6833_/Q vssd1 vssd1 vccd1 vccd1 hold206/X sky130_fd_sc_hd__dlygate4sd3_1
XFILLER_0_103_3 vssd1 vssd1 vccd1 vccd1 sky130_fd_sc_hd__fill_1
X_4451_ _4451_/A _4452_/A _4451_/C vssd1 vssd1 vccd1 vccd1 _4451_/Y sky130_fd_sc_hd__nand3_2
Xhold217 _6880_/Q vssd1 vssd1 vccd1 vccd1 hold217/X sky130_fd_sc_hd__dlygate4sd3_1
Xhold228 _6784_/Q vssd1 vssd1 vccd1 vccd1 hold228/X sky130_fd_sc_hd__dlygate4sd3_1
X_3402_ _3402_/A _3402_/B vssd1 vssd1 vccd1 vccd1 _3409_/B sky130_fd_sc_hd__or2_1
Xhold239 _6110_/X vssd1 vssd1 vccd1 vccd1 _6748_/D sky130_fd_sc_hd__dlygate4sd3_1
X_6121_ hold84/X pix_mport_o[5] _6223_/B vssd1 vssd1 vccd1 vccd1 _6757_/D sky130_fd_sc_hd__mux2_1
X_4382_ _4774_/B _4381_/X _4380_/X vssd1 vssd1 vccd1 vccd1 _4383_/B sky130_fd_sc_hd__a21bo_1
XTAP_500 vssd1 vccd1 sky130_fd_sc_hd__tapvpwrvgnd_1
X_3333_ _3263_/Y _6807_/Q _6073_/C _3262_/A vssd1 vssd1 vccd1 vccd1 _3333_/X sky130_fd_sc_hd__a22o_1
XFILLER_0_21_393 vssd1 vssd1 vccd1 vccd1 sky130_ef_sc_hd__decap_12
XTAP_511 vssd1 vccd1 sky130_fd_sc_hd__tapvpwrvgnd_1
XTAP_522 vssd1 vccd1 sky130_fd_sc_hd__tapvpwrvgnd_1
XTAP_533 vssd1 vccd1 sky130_fd_sc_hd__tapvpwrvgnd_1
X_3264_ sstream_i[114] vssd1 vssd1 vccd1 vccd1 _3264_/Y sky130_fd_sc_hd__inv_2
X_6052_ hold159/X _6038_/B _6054_/B1 vssd1 vssd1 vccd1 vccd1 _6691_/D sky130_fd_sc_hd__a21o_1
XTAP_544 vssd1 vccd1 sky130_fd_sc_hd__tapvpwrvgnd_1
XTAP_555 vssd1 vccd1 sky130_fd_sc_hd__tapvpwrvgnd_1
XTAP_566 vssd1 vccd1 sky130_fd_sc_hd__tapvpwrvgnd_1
XTAP_577 vssd1 vccd1 sky130_fd_sc_hd__tapvpwrvgnd_1
XTAP_588 vssd1 vccd1 sky130_fd_sc_hd__tapvpwrvgnd_1
XTAP_599 vssd1 vccd1 sky130_fd_sc_hd__tapvpwrvgnd_1
XFILLER_0_56_74 vssd1 vssd1 vccd1 vccd1 sky130_fd_sc_hd__fill_2
X_5003_ _4924_/A _4924_/C _4924_/B vssd1 vssd1 vccd1 vccd1 _5003_/Y sky130_fd_sc_hd__o21ai_1
XFILLER_0_56_85 vssd1 vssd1 vccd1 vccd1 sky130_fd_sc_hd__fill_2
XANTENNA__5849__S _5923_/S vssd1 vssd1 vccd1 vccd1 sky130_fd_sc_hd__diode_2
X_6954_ vssd1 vssd1 vccd1 vccd1 _6954_/HI tex_mport_o[7] sky130_fd_sc_hd__conb_1
XFILLER_0_88_360 vssd1 vssd1 vccd1 vccd1 sky130_fd_sc_hd__decap_4
XANTENNA__4959__A1 _4958_/B vssd1 vssd1 vccd1 vccd1 sky130_fd_sc_hd__diode_2
XANTENNA__4959__B2 _4816_/A vssd1 vssd1 vccd1 vccd1 sky130_fd_sc_hd__diode_2
XFILLER_0_48_202 vssd1 vssd1 vccd1 vccd1 sky130_fd_sc_hd__fill_2
X_5905_ tex_addr_i[29] _5913_/B vssd1 vssd1 vccd1 vccd1 _5907_/A sky130_fd_sc_hd__or2_1
XFILLER_0_8_321 vssd1 vssd1 vccd1 vccd1 sky130_fd_sc_hd__decap_3
XFILLER_0_48_268 vssd1 vssd1 vccd1 vccd1 sky130_fd_sc_hd__fill_2
X_6885_ _6892_/CLK _6885_/D vssd1 vssd1 vccd1 vccd1 _6885_/Q sky130_fd_sc_hd__dfxtp_1
XFILLER_0_63_205 vssd1 vssd1 vccd1 vccd1 sky130_fd_sc_hd__fill_2
X_5836_ tex_addr_i[20] _5919_/B vssd1 vssd1 vccd1 vccd1 _5863_/A sky130_fd_sc_hd__xnor2_1
XFILLER_0_48_279 vssd1 vssd1 vccd1 vccd1 sky130_fd_sc_hd__fill_2
X_5767_ _5767_/A _5787_/C vssd1 vssd1 vccd1 vccd1 _5767_/Y sky130_fd_sc_hd__nand2_1
XFILLER_0_8_365 vssd1 vssd1 vccd1 vccd1 sky130_ef_sc_hd__decap_12
XFILLER_0_56_290 vssd1 vssd1 vccd1 vccd1 sky130_fd_sc_hd__fill_1
X_5698_ hold290/X _5697_/X _5844_/S vssd1 vssd1 vccd1 vccd1 _6626_/D sky130_fd_sc_hd__mux2_1
XFILLER_0_16_154 vssd1 vssd1 vccd1 vccd1 sky130_fd_sc_hd__decap_4
XFILLER_0_16_176 vssd1 vssd1 vccd1 vccd1 sky130_fd_sc_hd__fill_2
X_4718_ _4736_/B _5051_/B _4736_/D _4944_/B vssd1 vssd1 vccd1 vccd1 _4719_/B sky130_fd_sc_hd__a22o_1
XANTENNA__6333__A0 hold185/X vssd1 vssd1 vccd1 vccd1 sky130_fd_sc_hd__diode_2
XFILLER_0_114_340 vssd1 vssd1 vccd1 vccd1 sky130_fd_sc_hd__fill_2
X_4649_ _4649_/A vssd1 vssd1 vccd1 vccd1 _4664_/A sky130_fd_sc_hd__inv_2
XFILLER_0_31_113 vssd1 vssd1 vccd1 vccd1 sky130_fd_sc_hd__fill_1
XFILLER_0_114_373 vssd1 vssd1 vccd1 vccd1 sky130_ef_sc_hd__decap_12
X_6319_ hold69/X hold40/X _6319_/S vssd1 vssd1 vccd1 vccd1 _6802_/D sky130_fd_sc_hd__mux2_1
XFILLER_0_12_393 vssd1 vssd1 vccd1 vccd1 sky130_ef_sc_hd__decap_12
XFILLER_0_98_157 vssd1 vssd1 vccd1 vccd1 sky130_fd_sc_hd__decap_3
XFILLER_0_98_124 vssd1 vssd1 vccd1 vccd1 sky130_fd_sc_hd__decap_8
XFILLER_0_98_179 vssd1 vssd1 vccd1 vccd1 sky130_fd_sc_hd__fill_2
XFILLER_0_39_202 vssd1 vssd1 vccd1 vccd1 sky130_fd_sc_hd__fill_1
XFILLER_0_79_393 vssd1 vssd1 vccd1 vccd1 sky130_ef_sc_hd__decap_12
XANTENNA__3787__B _5115_/D vssd1 vssd1 vccd1 vccd1 sky130_fd_sc_hd__diode_2
XFILLER_0_39_268 vssd1 vssd1 vccd1 vccd1 sky130_fd_sc_hd__fill_2
XFILLER_0_54_205 vssd1 vssd1 vccd1 vccd1 sky130_fd_sc_hd__fill_1
XFILLER_0_62_260 vssd1 vssd1 vccd1 vccd1 sky130_fd_sc_hd__fill_2
XANTENNA__6324__B1 _6224_/B vssd1 vssd1 vccd1 vccd1 sky130_fd_sc_hd__diode_2
XFILLER_0_105_351 vssd1 vssd1 vccd1 vccd1 sky130_fd_sc_hd__fill_1
XFILLER_0_22_135 vssd1 vssd1 vccd1 vccd1 sky130_fd_sc_hd__fill_2
XFILLER_0_22_168 vssd1 vssd1 vccd1 vccd1 sky130_fd_sc_hd__fill_2
XFILLER_0_10_319 vssd1 vssd1 vccd1 vccd1 sky130_fd_sc_hd__fill_2
XANTENNA_hold7_A hold7/A vssd1 vssd1 vccd1 vccd1 sky130_fd_sc_hd__diode_2
XFILLER_0_26_33 vssd1 vssd1 vccd1 vccd1 sky130_fd_sc_hd__fill_1
XFILLER_0_117_57 vssd1 vssd1 vccd1 vccd1 sky130_fd_sc_hd__fill_1
XFILLER_0_26_44 vssd1 vssd1 vccd1 vccd1 sky130_fd_sc_hd__fill_2
XANTENNA__3861__A1 _5081_/A vssd1 vssd1 vccd1 vccd1 sky130_fd_sc_hd__diode_2
XANTENNA__6354__A hold60/A vssd1 vssd1 vccd1 vccd1 sky130_fd_sc_hd__diode_2
XANTENNA__3861__B2 _5766_/A vssd1 vssd1 vccd1 vccd1 sky130_fd_sc_hd__diode_2
XFILLER_0_133_23 vssd1 vssd1 vccd1 vccd1 sky130_fd_sc_hd__fill_1
X_3951_ _5766_/A _5115_/D _5118_/B _5115_/B vssd1 vssd1 vccd1 vccd1 _3952_/B sky130_fd_sc_hd__a22o_1
XFILLER_0_133_67 vssd1 vssd1 vccd1 vccd1 sky130_fd_sc_hd__fill_2
X_6670_ _6880_/CLK _6670_/D vssd1 vssd1 vccd1 vccd1 _6670_/Q sky130_fd_sc_hd__dfxtp_1
X_3882_ _3889_/A _3889_/B vssd1 vssd1 vccd1 vccd1 _3882_/Y sky130_fd_sc_hd__nand2b_1
X_5621_ _5621_/A _5621_/B _5621_/C _5621_/D vssd1 vssd1 vccd1 vccd1 _5621_/X sky130_fd_sc_hd__or4_2
XFILLER_0_45_249 vssd1 vssd1 vccd1 vccd1 sky130_fd_sc_hd__decap_3
X_5552_ depth_mport_o[27] hold174/X _5556_/S vssd1 vssd1 vccd1 vccd1 _6583_/D sky130_fd_sc_hd__mux2_1
XFILLER_0_115_126 vssd1 vssd1 vccd1 vccd1 sky130_fd_sc_hd__fill_2
X_4503_ _4458_/Y _4459_/X _4451_/Y _4455_/A vssd1 vssd1 vccd1 vccd1 _4503_/X sky130_fd_sc_hd__o211a_1
XFILLER_0_13_113 vssd1 vssd1 vccd1 vccd1 sky130_fd_sc_hd__decap_4
XFILLER_0_5_357 vssd1 vssd1 vccd1 vccd1 sky130_fd_sc_hd__fill_2
X_5483_ hold170/X sstream_i[74] _6450_/S vssd1 vssd1 vccd1 vccd1 _6516_/D sky130_fd_sc_hd__mux2_1
XFILLER_0_13_146 vssd1 vssd1 vccd1 vccd1 sky130_fd_sc_hd__fill_1
X_4434_ _4789_/C _4476_/D _4433_/D _4789_/B vssd1 vssd1 vccd1 vccd1 _4435_/B sky130_fd_sc_hd__a22o_1
XANTENNA__4040__C _4736_/B vssd1 vssd1 vccd1 vccd1 sky130_fd_sc_hd__diode_2
X_4365_ _4356_/Y _4358_/Y _4366_/A _4364_/Y vssd1 vssd1 vccd1 vccd1 _4370_/A sky130_fd_sc_hd__a211oi_1
XFILLER_0_6_65 vssd1 vssd1 vccd1 vccd1 sky130_ef_sc_hd__decap_12
X_3316_ depth_mport_i[12] vssd1 vssd1 vccd1 vccd1 _6249_/B sky130_fd_sc_hd__inv_2
XTAP_341 vssd1 vccd1 sky130_fd_sc_hd__tapvpwrvgnd_1
XTAP_330 vssd1 vccd1 sky130_fd_sc_hd__tapvpwrvgnd_1
X_6104_ hold177/X _6742_/Q _6113_/S vssd1 vssd1 vccd1 vccd1 _6104_/X sky130_fd_sc_hd__mux2_1
X_4296_ _6634_/Q _4296_/B vssd1 vssd1 vccd1 vccd1 _4297_/B sky130_fd_sc_hd__or2_1
XTAP_385 vssd1 vccd1 sky130_fd_sc_hd__tapvpwrvgnd_1
X_6035_ tex_height_i[15] _6038_/D vssd1 vssd1 vccd1 vccd1 _6035_/Y sky130_fd_sc_hd__xnor2_1
XTAP_374 vssd1 vccd1 sky130_fd_sc_hd__tapvpwrvgnd_1
XTAP_363 vssd1 vccd1 sky130_fd_sc_hd__tapvpwrvgnd_1
XTAP_352 vssd1 vccd1 sky130_fd_sc_hd__tapvpwrvgnd_1
XANTENNA__4049__A _5701_/A vssd1 vssd1 vccd1 vccd1 sky130_fd_sc_hd__diode_2
XTAP_396 vssd1 vccd1 sky130_fd_sc_hd__tapvpwrvgnd_1
XFILLER_0_83_50 vssd1 vssd1 vccd1 vccd1 sky130_fd_sc_hd__decap_4
XFILLER_0_95_105 vssd1 vssd1 vccd1 vccd1 sky130_fd_sc_hd__decap_4
XPHY_25 vssd1 vssd1 vccd1 vccd1 sky130_fd_sc_hd__decap_3
XPHY_14 vssd1 vssd1 vccd1 vccd1 sky130_fd_sc_hd__decap_3
XPHY_36 vssd1 vssd1 vccd1 vccd1 sky130_fd_sc_hd__decap_3
XPHY_47 vssd1 vssd1 vccd1 vccd1 sky130_fd_sc_hd__decap_3
X_6937_ vssd1 vssd1 vccd1 vccd1 _6937_/HI pix_mport_o[57] sky130_fd_sc_hd__conb_1
XPHY_58 vssd1 vssd1 vccd1 vccd1 sky130_fd_sc_hd__decap_3
XPHY_69 vssd1 vssd1 vccd1 vccd1 sky130_fd_sc_hd__decap_3
XFILLER_0_76_374 vssd1 vssd1 vccd1 vccd1 sky130_fd_sc_hd__fill_2
XFILLER_0_36_205 vssd1 vssd1 vccd1 vccd1 sky130_fd_sc_hd__decap_3
X_6868_ _6892_/CLK _6868_/D vssd1 vssd1 vccd1 vccd1 _6868_/Q sky130_fd_sc_hd__dfxtp_1
X_5819_ tex_addr_i[16] _5919_/B _5824_/A _5825_/A vssd1 vssd1 vccd1 vccd1 _5820_/B
+ sky130_fd_sc_hd__o2bb2a_1
X_6799_ _6827_/CLK _6799_/D vssd1 vssd1 vccd1 vccd1 hold73/A sky130_fd_sc_hd__dfxtp_1
XFILLER_0_44_282 vssd1 vssd1 vccd1 vccd1 sky130_fd_sc_hd__decap_3
XFILLER_0_121_129 vssd1 vssd1 vccd1 vccd1 sky130_fd_sc_hd__fill_2
XFILLER_0_4_390 vssd1 vssd1 vccd1 vccd1 sky130_ef_sc_hd__decap_12
XFILLER_0_102_365 vssd1 vssd1 vccd1 vccd1 sky130_ef_sc_hd__decap_12
XANTENNA__4332__A2 _4774_/B vssd1 vssd1 vccd1 vccd1 sky130_fd_sc_hd__diode_2
XANTENNA__4096__A1 _5754_/B vssd1 vssd1 vccd1 vccd1 sky130_fd_sc_hd__diode_2
XANTENNA__5832__A2 _5919_/B vssd1 vssd1 vccd1 vccd1 sky130_fd_sc_hd__diode_2
XANTENNA__5045__B1 _6682_/Q vssd1 vssd1 vccd1 vccd1 sky130_fd_sc_hd__diode_2
XFILLER_0_137_262 vssd1 vssd1 vccd1 vccd1 sky130_fd_sc_hd__fill_2
XFILLER_0_94_193 vssd1 vssd1 vccd1 vccd1 sky130_fd_sc_hd__decap_3
XFILLER_0_82_344 vssd1 vssd1 vccd1 vccd1 sky130_fd_sc_hd__decap_4
XFILLER_0_27_238 vssd1 vssd1 vccd1 vccd1 sky130_fd_sc_hd__fill_2
XFILLER_0_82_377 vssd1 vssd1 vccd1 vccd1 sky130_ef_sc_hd__decap_12
XFILLER_0_35_271 vssd1 vssd1 vccd1 vccd1 sky130_fd_sc_hd__decap_8
XFILLER_0_35_293 vssd1 vssd1 vccd1 vccd1 sky130_fd_sc_hd__fill_2
XANTENNA__4141__B _4518_/D vssd1 vssd1 vccd1 vccd1 sky130_fd_sc_hd__diode_2
XFILLER_0_50_241 vssd1 vssd1 vccd1 vccd1 sky130_fd_sc_hd__fill_1
XFILLER_0_105_181 vssd1 vssd1 vccd1 vccd1 sky130_fd_sc_hd__fill_2
XFILLER_0_120_195 vssd1 vssd1 vccd1 vccd1 sky130_fd_sc_hd__fill_1
X_4150_ _4736_/B _4944_/B _5049_/D _4736_/D vssd1 vssd1 vccd1 vccd1 _4152_/A sky130_fd_sc_hd__a22oi_1
XFILLER_0_37_32 vssd1 vssd1 vccd1 vccd1 sky130_fd_sc_hd__decap_4
X_4081_ _4081_/A _4081_/B vssd1 vssd1 vccd1 vccd1 _4089_/B sky130_fd_sc_hd__or2_1
XFILLER_0_77_138 vssd1 vssd1 vccd1 vccd1 sky130_fd_sc_hd__fill_2
XFILLER_0_77_127 vssd1 vssd1 vccd1 vccd1 sky130_fd_sc_hd__fill_2
XANTENNA__3501__A _5296_/A vssd1 vssd1 vccd1 vccd1 sky130_fd_sc_hd__diode_2
X_4983_ _4984_/A _4984_/B _4984_/C vssd1 vssd1 vccd1 vccd1 _4983_/X sky130_fd_sc_hd__and3_1
X_6722_ _6855_/CLK _6722_/D _6073_/A vssd1 vssd1 vccd1 vccd1 _6722_/Q sky130_fd_sc_hd__dfstp_1
X_3934_ _3932_/A _3931_/Y _3854_/X _3904_/Y vssd1 vssd1 vccd1 vccd1 _3934_/Y sky130_fd_sc_hd__o211ai_2
X_6653_ _6864_/CLK _6653_/D vssd1 vssd1 vccd1 vccd1 _6653_/Q sky130_fd_sc_hd__dfxtp_1
XFILLER_0_128_262 vssd1 vssd1 vccd1 vccd1 sky130_fd_sc_hd__fill_2
XFILLER_0_128_251 vssd1 vssd1 vccd1 vccd1 sky130_fd_sc_hd__fill_1
X_3865_ _5051_/B _5083_/B _3805_/C _3805_/D vssd1 vssd1 vccd1 vccd1 _3865_/Y sky130_fd_sc_hd__a22oi_1
X_5604_ _5718_/B _5603_/B _3274_/Y _4942_/A vssd1 vssd1 vccd1 vccd1 _5612_/A sky130_fd_sc_hd__a22o_1
XFILLER_0_131_405 vssd1 vssd1 vccd1 vccd1 sky130_fd_sc_hd__fill_2
X_6584_ _6818_/CLK _6584_/D fanout151/X vssd1 vssd1 vccd1 vccd1 depth_mport_o[28]
+ sky130_fd_sc_hd__dfrtp_4
X_3796_ _3959_/B _5754_/B vssd1 vssd1 vccd1 vccd1 _3797_/B sky130_fd_sc_hd__nand2_1
XANTENNA_fanout129_A _5754_/A vssd1 vssd1 vccd1 vccd1 sky130_fd_sc_hd__diode_2
X_5535_ depth_mport_o[10] hold120/X _5541_/S vssd1 vssd1 vccd1 vccd1 _6566_/D sky130_fd_sc_hd__mux2_1
XFILLER_0_5_187 vssd1 vssd1 vccd1 vccd1 sky130_fd_sc_hd__decap_4
XFILLER_0_5_176 vssd1 vssd1 vccd1 vccd1 sky130_fd_sc_hd__fill_2
X_5466_ hold71/X _3266_/A tex_mport_i[32] vssd1 vssd1 vccd1 vccd1 _6811_/D sky130_fd_sc_hd__o21a_1
XFILLER_0_75_3 vssd1 vssd1 vccd1 vccd1 sky130_fd_sc_hd__decap_4
X_4417_ _4409_/X _4411_/X _4418_/B _4416_/X vssd1 vssd1 vccd1 vccd1 _4418_/C sky130_fd_sc_hd__o211ai_2
XFILLER_0_78_72 vssd1 vssd1 vccd1 vccd1 sky130_fd_sc_hd__fill_1
XFILLER_0_111_173 vssd1 vssd1 vccd1 vccd1 sky130_fd_sc_hd__fill_2
X_5397_ _6734_/Q _5398_/B vssd1 vssd1 vccd1 vccd1 _5402_/B sky130_fd_sc_hd__or2_1
XANTENNA__3522__B1 _5277_/B vssd1 vssd1 vccd1 vccd1 sky130_fd_sc_hd__diode_2
XFILLER_0_1_393 vssd1 vssd1 vccd1 vccd1 sky130_ef_sc_hd__decap_12
X_4348_ _4488_/A _4433_/D vssd1 vssd1 vccd1 vccd1 _4350_/B sky130_fd_sc_hd__nand2_1
X_4279_ _4279_/A _4340_/A vssd1 vssd1 vccd1 vccd1 _4283_/A sky130_fd_sc_hd__nand2_1
X_6018_ _6017_/Y _6876_/Q _6038_/C vssd1 vssd1 vccd1 vccd1 _6018_/X sky130_fd_sc_hd__mux2_1
XANTENNA__3825__B2 _5290_/A vssd1 vssd1 vccd1 vccd1 sky130_fd_sc_hd__diode_2
XANTENNA__3825__A1 _5327_/A vssd1 vssd1 vccd1 vccd1 sky130_fd_sc_hd__diode_2
XFILLER_0_68_149 vssd1 vssd1 vccd1 vccd1 sky130_fd_sc_hd__decap_6
XFILLER_0_49_330 vssd1 vssd1 vccd1 vccd1 sky130_fd_sc_hd__decap_6
XFILLER_0_91_130 vssd1 vssd1 vccd1 vccd1 sky130_fd_sc_hd__fill_1
XFILLER_0_76_171 vssd1 vssd1 vccd1 vccd1 sky130_fd_sc_hd__fill_1
XFILLER_0_119_284 vssd1 vssd1 vccd1 vccd1 sky130_fd_sc_hd__fill_2
XFILLER_0_91_141 vssd1 vssd1 vccd1 vccd1 sky130_fd_sc_hd__decap_3
XFILLER_0_64_377 vssd1 vssd1 vccd1 vccd1 sky130_fd_sc_hd__decap_3
XFILLER_0_64_355 vssd1 vssd1 vccd1 vccd1 sky130_fd_sc_hd__fill_2
XFILLER_0_134_265 vssd1 vssd1 vccd1 vccd1 sky130_fd_sc_hd__fill_1
XFILLER_0_122_405 vssd1 vssd1 vccd1 vccd1 sky130_fd_sc_hd__fill_2
XFILLER_0_64_388 vssd1 vssd1 vccd1 vccd1 sky130_ef_sc_hd__decap_12
XFILLER_0_134_298 vssd1 vssd1 vccd1 vccd1 sky130_fd_sc_hd__decap_3
XANTENNA__3761__B1 _3999_/A vssd1 vssd1 vccd1 vccd1 sky130_fd_sc_hd__diode_2
XFILLER_0_102_162 vssd1 vssd1 vccd1 vccd1 sky130_fd_sc_hd__fill_2
XFILLER_0_32_296 vssd1 vssd1 vccd1 vccd1 sky130_fd_sc_hd__fill_2
XANTENNA__5801__A _5801_/A vssd1 vssd1 vccd1 vccd1 sky130_fd_sc_hd__diode_2
XFILLER_0_59_116 vssd1 vssd1 vccd1 vccd1 sky130_fd_sc_hd__fill_1
XFILLER_0_90_29 vssd1 vssd1 vccd1 vccd1 sky130_fd_sc_hd__decap_4
XANTENNA__4136__B _4966_/C vssd1 vssd1 vccd1 vccd1 sky130_fd_sc_hd__diode_2
XFILLER_0_67_193 vssd1 vssd1 vccd1 vccd1 sky130_fd_sc_hd__fill_1
XFILLER_0_55_333 vssd1 vssd1 vccd1 vccd1 sky130_fd_sc_hd__decap_3
XFILLER_0_125_221 vssd1 vssd1 vccd1 vccd1 sky130_fd_sc_hd__decap_3
XFILLER_0_15_208 vssd1 vssd1 vccd1 vccd1 sky130_fd_sc_hd__fill_2
XFILLER_0_113_405 vssd1 vssd1 vccd1 vccd1 sky130_fd_sc_hd__fill_2
X_3650_ _3651_/B _3651_/A vssd1 vssd1 vccd1 vccd1 _3675_/A sky130_fd_sc_hd__and2b_1
X_3581_ _3577_/Y _3580_/X _3560_/B _3564_/X vssd1 vssd1 vccd1 vccd1 _3587_/B sky130_fd_sc_hd__a211o_1
X_5320_ _5320_/A _6686_/Q vssd1 vssd1 vccd1 vccd1 _5321_/B sky130_fd_sc_hd__nand2_1
XFILLER_0_23_285 vssd1 vssd1 vccd1 vccd1 sky130_fd_sc_hd__fill_2
X_5251_ _5251_/A _5251_/B vssd1 vssd1 vccd1 vccd1 _5254_/A sky130_fd_sc_hd__xor2_1
X_4202_ _4207_/A _4207_/B vssd1 vssd1 vccd1 vccd1 _4203_/C sky130_fd_sc_hd__and2_1
X_5182_ _5181_/B _5181_/C _5181_/A vssd1 vssd1 vccd1 vccd1 _5183_/B sky130_fd_sc_hd__o21ai_1
X_4133_ _4133_/A _4133_/B vssd1 vssd1 vccd1 vccd1 _4135_/B sky130_fd_sc_hd__xnor2_1
XANTENNA__6049__A2 _6038_/B vssd1 vssd1 vccd1 vccd1 sky130_fd_sc_hd__diode_2
X_4064_ _4063_/B _4063_/C _4063_/A vssd1 vssd1 vccd1 vccd1 _4065_/C sky130_fd_sc_hd__a21bo_1
XFILLER_0_3_55 vssd1 vssd1 vccd1 vccd1 sky130_fd_sc_hd__fill_1
XFILLER_0_64_74 vssd1 vssd1 vccd1 vccd1 sky130_fd_sc_hd__decap_4
XANTENNA__6018__S _6038_/C vssd1 vssd1 vccd1 vccd1 sky130_fd_sc_hd__diode_2
X_6705_ _6818_/CLK hold52/X vssd1 vssd1 vccd1 vccd1 hold51/A sky130_fd_sc_hd__dfxtp_1
XFILLER_0_80_73 vssd1 vssd1 vccd1 vccd1 sky130_fd_sc_hd__fill_2
XANTENNA__3885__B _5091_/B vssd1 vssd1 vccd1 vccd1 sky130_fd_sc_hd__diode_2
X_4966_ _4966_/A _4966_/B _4966_/C _5115_/C vssd1 vssd1 vccd1 vccd1 _4966_/X sky130_fd_sc_hd__and4_1
XFILLER_0_73_141 vssd1 vssd1 vccd1 vccd1 sky130_fd_sc_hd__fill_2
X_4897_ _4181_/A _4180_/B _4178_/X vssd1 vssd1 vccd1 vccd1 _4898_/C sky130_fd_sc_hd__a21o_1
X_3917_ _3917_/A _3917_/B _3917_/C vssd1 vssd1 vccd1 vccd1 _3958_/A sky130_fd_sc_hd__nand3_1
X_6636_ _6751_/CLK _6636_/D fanout140/X vssd1 vssd1 vccd1 vccd1 _6636_/Q sky130_fd_sc_hd__dfstp_1
X_3848_ _3848_/A _3848_/B vssd1 vssd1 vccd1 vccd1 _3850_/B sky130_fd_sc_hd__nand2_1
XFILLER_0_46_388 vssd1 vssd1 vccd1 vccd1 sky130_ef_sc_hd__decap_12
XFILLER_0_131_213 vssd1 vssd1 vccd1 vccd1 sky130_fd_sc_hd__fill_2
X_6567_ _6853_/CLK _6567_/D _5468_/A vssd1 vssd1 vccd1 vccd1 depth_mport_o[11] sky130_fd_sc_hd__dfrtp_4
X_3779_ _3779_/A _3779_/B vssd1 vssd1 vccd1 vccd1 _5266_/A sky130_fd_sc_hd__xnor2_1
X_5518_ hold185/X sstream_i[109] _6473_/S vssd1 vssd1 vccd1 vccd1 _6551_/D sky130_fd_sc_hd__mux2_1
XFILLER_0_14_274 vssd1 vssd1 vccd1 vccd1 sky130_fd_sc_hd__fill_1
X_6498_ hold85/X sstream_i[56] _6501_/S vssd1 vssd1 vccd1 vccd1 _6889_/D sky130_fd_sc_hd__mux2_1
X_5449_ _6743_/Q _5449_/B _5449_/C vssd1 vssd1 vccd1 vccd1 _5449_/X sky130_fd_sc_hd__and3_1
Xfanout121 tex_width_i[14] vssd1 vssd1 vccd1 vccd1 _4832_/C sky130_fd_sc_hd__buf_4
Xfanout110 _4638_/A vssd1 vssd1 vccd1 vccd1 _4432_/A sky130_fd_sc_hd__buf_4
Xfanout143 fanout144/X vssd1 vssd1 vccd1 vccd1 fanout143/X sky130_fd_sc_hd__clkbuf_4
Xfanout132 _5754_/B vssd1 vssd1 vccd1 vccd1 _4822_/B sky130_fd_sc_hd__buf_4
XANTENNA_fanout61_A _6670_/Q vssd1 vssd1 vccd1 vccd1 sky130_fd_sc_hd__diode_2
XTAP_1123 vssd1 vccd1 sky130_fd_sc_hd__tapvpwrvgnd_1
XTAP_1112 vssd1 vccd1 sky130_fd_sc_hd__tapvpwrvgnd_1
XTAP_1101 vssd1 vccd1 sky130_fd_sc_hd__tapvpwrvgnd_1
XTAP_1156 vssd1 vccd1 sky130_fd_sc_hd__tapvpwrvgnd_1
XTAP_1145 vssd1 vccd1 sky130_fd_sc_hd__tapvpwrvgnd_1
XTAP_1134 vssd1 vccd1 sky130_fd_sc_hd__tapvpwrvgnd_1
XTAP_1189 vssd1 vccd1 sky130_fd_sc_hd__tapvpwrvgnd_1
XTAP_1178 vssd1 vccd1 sky130_fd_sc_hd__tapvpwrvgnd_1
XTAP_1167 vssd1 vccd1 sky130_fd_sc_hd__tapvpwrvgnd_1
XFILLER_0_64_141 vssd1 vssd1 vccd1 vccd1 sky130_fd_sc_hd__decap_4
XFILLER_0_9_290 vssd1 vssd1 vccd1 vccd1 sky130_fd_sc_hd__fill_2
XANTENNA__3982__B1 _5296_/B vssd1 vssd1 vccd1 vccd1 sky130_fd_sc_hd__diode_2
XFILLER_0_100_38 vssd1 vssd1 vccd1 vccd1 sky130_fd_sc_hd__decap_3
XTAP_907 vssd1 vccd1 sky130_fd_sc_hd__tapvpwrvgnd_1
XFILLER_0_109_14 vssd1 vssd1 vccd1 vccd1 sky130_fd_sc_hd__fill_2
XTAP_929 vssd1 vccd1 sky130_fd_sc_hd__tapvpwrvgnd_1
XTAP_918 vssd1 vccd1 sky130_fd_sc_hd__tapvpwrvgnd_1
XFILLER_0_18_45 vssd1 vssd1 vccd1 vccd1 sky130_fd_sc_hd__decap_4
XFILLER_0_34_11 vssd1 vssd1 vccd1 vccd1 sky130_fd_sc_hd__fill_2
XFILLER_0_125_46 vssd1 vssd1 vccd1 vccd1 sky130_fd_sc_hd__fill_1
XFILLER_0_34_33 vssd1 vssd1 vccd1 vccd1 sky130_fd_sc_hd__decap_3
XANTENNA__6362__A hold98/A vssd1 vssd1 vccd1 vccd1 sky130_fd_sc_hd__diode_2
XFILLER_0_87_288 vssd1 vssd1 vccd1 vccd1 sky130_fd_sc_hd__fill_2
XFILLER_0_28_300 vssd1 vssd1 vccd1 vccd1 sky130_fd_sc_hd__decap_8
X_4820_ _4818_/X _4820_/B vssd1 vssd1 vccd1 vccd1 _4821_/B sky130_fd_sc_hd__and2b_1
XFILLER_0_87_299 vssd1 vssd1 vccd1 vccd1 sky130_fd_sc_hd__fill_1
XFILLER_0_7_205 vssd1 vssd1 vccd1 vccd1 sky130_fd_sc_hd__fill_2
XFILLER_0_34_99 vssd1 vssd1 vccd1 vccd1 sky130_fd_sc_hd__fill_2
X_4751_ _4750_/A _4750_/B _4750_/C vssd1 vssd1 vccd1 vccd1 _4752_/C sky130_fd_sc_hd__a21o_1
X_4682_ _6622_/Q _4682_/B _4682_/C vssd1 vssd1 vccd1 vccd1 _4689_/A sky130_fd_sc_hd__and3_1
XFILLER_0_70_100 vssd1 vssd1 vccd1 vccd1 sky130_fd_sc_hd__fill_2
X_3702_ _3694_/A _3694_/B _3694_/C vssd1 vssd1 vccd1 vccd1 _3703_/B sky130_fd_sc_hd__o21ai_1
XFILLER_0_28_399 vssd1 vssd1 vccd1 vccd1 sky130_fd_sc_hd__decap_8
X_6421_ hold7/A _6546_/Q hold70/A vssd1 vssd1 vccd1 vccd1 _6422_/B sky130_fd_sc_hd__a21oi_1
XANTENNA__4517__A2 _4551_/D vssd1 vssd1 vccd1 vccd1 sky130_fd_sc_hd__diode_2
X_3633_ _3634_/A _3634_/B vssd1 vssd1 vccd1 vccd1 _3642_/B sky130_fd_sc_hd__and2b_1
X_6352_ depth_mport_o[42] _6441_/B _6351_/Y vssd1 vssd1 vccd1 vccd1 _6820_/D sky130_fd_sc_hd__o21a_1
XFILLER_0_11_233 vssd1 vssd1 vccd1 vccd1 sky130_fd_sc_hd__fill_1
XFILLER_0_11_222 vssd1 vssd1 vccd1 vccd1 sky130_fd_sc_hd__fill_2
XFILLER_0_11_211 vssd1 vssd1 vccd1 vccd1 sky130_fd_sc_hd__fill_1
X_3564_ _3560_/A _3559_/B _3559_/C vssd1 vssd1 vccd1 vccd1 _3564_/X sky130_fd_sc_hd__o21a_1
XFILLER_0_51_391 vssd1 vssd1 vccd1 vccd1 sky130_fd_sc_hd__fill_1
X_6283_ _6283_/A _6283_/B _6283_/C _6282_/X vssd1 vssd1 vccd1 vccd1 _6289_/B sky130_fd_sc_hd__or4b_1
XFILLER_0_11_244 vssd1 vssd1 vccd1 vccd1 sky130_fd_sc_hd__fill_2
X_5303_ _3589_/A _3588_/B _3588_/A vssd1 vssd1 vccd1 vccd1 _5304_/B sky130_fd_sc_hd__o21ba_1
X_3495_ _5277_/A _5273_/A _5272_/A _5300_/B vssd1 vssd1 vccd1 vccd1 _3496_/B sky130_fd_sc_hd__a22o_1
XFILLER_0_59_85 vssd1 vssd1 vccd1 vccd1 sky130_fd_sc_hd__fill_1
X_5234_ _5234_/A _5234_/B vssd1 vssd1 vccd1 vccd1 _5237_/A sky130_fd_sc_hd__nand2_1
X_5165_ _5164_/B _5164_/C _5164_/A vssd1 vssd1 vccd1 vccd1 _5165_/Y sky130_fd_sc_hd__o21ai_2
XANTENNA__4150__B1 _5049_/D vssd1 vssd1 vccd1 vccd1 sky130_fd_sc_hd__diode_2
XFILLER_0_75_73 vssd1 vssd1 vccd1 vccd1 sky130_fd_sc_hd__fill_1
X_4116_ _4047_/A _4047_/C _4047_/B vssd1 vssd1 vccd1 vccd1 _4117_/C sky130_fd_sc_hd__a21bo_1
XFILLER_0_38_3 vssd1 vssd1 vccd1 vccd1 sky130_fd_sc_hd__fill_2
X_5096_ _5051_/C _5054_/A _5095_/Y _3979_/X vssd1 vssd1 vccd1 vccd1 _5098_/B sky130_fd_sc_hd__a211o_1
X_4047_ _4047_/A _4047_/B _4047_/C vssd1 vssd1 vccd1 vccd1 _4054_/A sky130_fd_sc_hd__nand3_1
XFILLER_0_78_233 vssd1 vssd1 vccd1 vccd1 sky130_fd_sc_hd__fill_1
XPHY_206 vssd1 vssd1 vccd1 vccd1 sky130_fd_sc_hd__decap_3
XFILLER_0_91_94 vssd1 vssd1 vccd1 vccd1 sky130_fd_sc_hd__fill_2
XFILLER_0_91_83 vssd1 vssd1 vccd1 vccd1 sky130_fd_sc_hd__decap_4
XANTENNA__5587__S _5601_/S vssd1 vssd1 vccd1 vccd1 sky130_fd_sc_hd__diode_2
XFILLER_0_38_108 vssd1 vssd1 vccd1 vccd1 sky130_fd_sc_hd__decap_3
XPHY_239 vssd1 vssd1 vccd1 vccd1 sky130_fd_sc_hd__decap_3
XPHY_228 vssd1 vssd1 vccd1 vccd1 sky130_fd_sc_hd__decap_3
XPHY_217 vssd1 vssd1 vccd1 vccd1 sky130_fd_sc_hd__decap_3
XFILLER_0_93_225 vssd1 vssd1 vccd1 vccd1 sky130_fd_sc_hd__fill_2
XFILLER_0_19_300 vssd1 vssd1 vccd1 vccd1 sky130_fd_sc_hd__decap_6
XFILLER_0_19_322 vssd1 vssd1 vccd1 vccd1 sky130_fd_sc_hd__fill_1
X_5998_ _4970_/B _5997_/X _6037_/S vssd1 vssd1 vccd1 vccd1 _6668_/D sky130_fd_sc_hd__mux2_1
XFILLER_0_19_355 vssd1 vssd1 vccd1 vccd1 sky130_fd_sc_hd__fill_2
XFILLER_0_46_141 vssd1 vssd1 vccd1 vccd1 sky130_fd_sc_hd__fill_2
X_4949_ _4949_/A _4949_/B _4941_/X vssd1 vssd1 vccd1 vccd1 _5059_/B sky130_fd_sc_hd__or3b_2
XFILLER_0_61_100 vssd1 vssd1 vccd1 vccd1 sky130_fd_sc_hd__fill_1
XANTENNA_hold206_A _6833_/Q vssd1 vssd1 vccd1 vccd1 sky130_fd_sc_hd__diode_2
X_6619_ _6732_/CLK _6619_/D fanout143/X vssd1 vssd1 vccd1 vccd1 tex_mport_o[62] sky130_fd_sc_hd__dfrtp_4
XFILLER_0_61_122 vssd1 vssd1 vccd1 vccd1 sky130_fd_sc_hd__fill_2
XFILLER_0_61_144 vssd1 vssd1 vccd1 vccd1 sky130_fd_sc_hd__fill_2
XFILLER_0_61_166 vssd1 vssd1 vccd1 vccd1 sky130_fd_sc_hd__fill_2
XANTENNA__3495__A2 _5273_/A vssd1 vssd1 vccd1 vccd1 sky130_fd_sc_hd__diode_2
XANTENNA__4444__A1 _4432_/A vssd1 vssd1 vccd1 vccd1 sky130_fd_sc_hd__diode_2
XFILLER_0_69_200 vssd1 vssd1 vccd1 vccd1 sky130_fd_sc_hd__decap_3
XANTENNA__5641__B1 _5784_/S vssd1 vssd1 vccd1 vccd1 sky130_fd_sc_hd__diode_2
XFILLER_0_69_266 vssd1 vssd1 vccd1 vccd1 sky130_fd_sc_hd__fill_2
XFILLER_0_84_225 vssd1 vssd1 vccd1 vccd1 sky130_fd_sc_hd__fill_2
XFILLER_0_84_269 vssd1 vssd1 vccd1 vccd1 sky130_fd_sc_hd__fill_2
XANTENNA__4747__A2 _4942_/B vssd1 vssd1 vccd1 vccd1 sky130_fd_sc_hd__diode_2
XFILLER_0_111_15 vssd1 vssd1 vccd1 vccd1 sky130_fd_sc_hd__fill_2
XFILLER_0_135_393 vssd1 vssd1 vccd1 vccd1 sky130_ef_sc_hd__decap_12
XANTENNA__6121__S _6223_/B vssd1 vssd1 vccd1 vccd1 sky130_fd_sc_hd__diode_2
XFILLER_0_110_205 vssd1 vssd1 vccd1 vccd1 sky130_fd_sc_hd__decap_3
XFILLER_0_52_188 vssd1 vssd1 vccd1 vccd1 sky130_fd_sc_hd__fill_2
XANTENNA__4380__B1 _4774_/B vssd1 vssd1 vccd1 vccd1 sky130_fd_sc_hd__diode_2
X_3280_ _6878_/Q vssd1 vssd1 vccd1 vccd1 _5947_/A sky130_fd_sc_hd__inv_2
XTAP_704 vssd1 vccd1 sky130_fd_sc_hd__tapvpwrvgnd_1
XTAP_715 vssd1 vccd1 sky130_fd_sc_hd__tapvpwrvgnd_1
XTAP_759 vssd1 vccd1 sky130_fd_sc_hd__tapvpwrvgnd_1
XTAP_748 vssd1 vccd1 sky130_fd_sc_hd__tapvpwrvgnd_1
XTAP_737 vssd1 vccd1 sky130_fd_sc_hd__tapvpwrvgnd_1
XTAP_726 vssd1 vccd1 sky130_fd_sc_hd__tapvpwrvgnd_1
X_6970_ vssd1 vssd1 vccd1 vccd1 _6970_/HI tex_mport_o[23] sky130_fd_sc_hd__conb_1
XANTENNA__6734__SET_B fanout144/X vssd1 vssd1 vccd1 vccd1 sky130_fd_sc_hd__diode_2
X_5921_ _5921_/A _5921_/B vssd1 vssd1 vccd1 vccd1 _5921_/Y sky130_fd_sc_hd__xnor2_1
XFILLER_0_48_406 vssd1 vssd1 vccd1 vccd1 sky130_fd_sc_hd__fill_1
XFILLER_0_75_236 vssd1 vssd1 vccd1 vccd1 sky130_fd_sc_hd__fill_2
X_5852_ tex_addr_i[20] tex_addr_i[21] _5882_/B vssd1 vssd1 vccd1 vccd1 _5852_/Y sky130_fd_sc_hd__o21ai_1
XFILLER_0_75_247 vssd1 vssd1 vccd1 vccd1 sky130_fd_sc_hd__fill_1
X_5783_ _5783_/A _5783_/B vssd1 vssd1 vccd1 vccd1 _5783_/Y sky130_fd_sc_hd__xnor2_1
XFILLER_0_28_141 vssd1 vssd1 vccd1 vccd1 sky130_fd_sc_hd__fill_2
X_4803_ _4802_/B _4802_/C _4802_/A vssd1 vssd1 vccd1 vccd1 _4804_/C sky130_fd_sc_hd__a21oi_1
XANTENNA__3946__B1 _4970_/B vssd1 vssd1 vccd1 vccd1 sky130_fd_sc_hd__diode_2
X_4734_ _4877_/A _4733_/B _4730_/X vssd1 vssd1 vccd1 vccd1 _4754_/A sky130_fd_sc_hd__a21o_1
XFILLER_0_28_185 vssd1 vssd1 vccd1 vccd1 sky130_fd_sc_hd__decap_4
XFILLER_0_126_382 vssd1 vssd1 vccd1 vccd1 sky130_ef_sc_hd__decap_12
X_4665_ _4672_/A _4672_/B vssd1 vssd1 vccd1 vccd1 _4670_/A sky130_fd_sc_hd__nor2_1
X_6404_ _6404_/A _6404_/B vssd1 vssd1 vccd1 vccd1 _6415_/A sky130_fd_sc_hd__or2_1
X_4596_ _6627_/Q _4596_/B vssd1 vssd1 vccd1 vccd1 _4598_/B sky130_fd_sc_hd__xnor2_1
X_3616_ _3620_/B _3616_/B _3616_/C vssd1 vssd1 vccd1 vccd1 _3620_/C sky130_fd_sc_hd__nor3_2
XFILLER_0_31_328 vssd1 vssd1 vccd1 vccd1 sky130_fd_sc_hd__fill_2
X_6335_ hold75/X _6335_/B vssd1 vssd1 vccd1 vccd1 _6335_/X sky130_fd_sc_hd__or2_1
X_3547_ _5081_/B _5308_/B _5277_/B _3959_/B vssd1 vssd1 vccd1 vccd1 _3548_/B sky130_fd_sc_hd__a22o_1
X_6266_ depth_mport_i[7] _3321_/Y _6258_/X _6265_/X vssd1 vssd1 vccd1 vccd1 _6266_/X
+ sky130_fd_sc_hd__a22o_1
XFILLER_0_86_72 vssd1 vssd1 vccd1 vccd1 sky130_fd_sc_hd__fill_2
X_3478_ _5306_/A _6686_/Q _6687_/Q _5292_/A vssd1 vssd1 vccd1 vccd1 _3480_/A sky130_fd_sc_hd__a22oi_1
X_6197_ pix_mport_o[45] _6207_/B _6195_/Y _6196_/X vssd1 vssd1 vccd1 vccd1 _6773_/D
+ sky130_fd_sc_hd__a22o_1
X_5217_ _5164_/B _5163_/Y _5215_/X _5216_/Y vssd1 vssd1 vccd1 vccd1 _5252_/A sky130_fd_sc_hd__o211a_1
X_5148_ _5148_/A _5148_/B _5131_/X vssd1 vssd1 vccd1 vccd1 _5148_/Y sky130_fd_sc_hd__nor3b_4
XANTENNA__5871__B1 _5599_/A vssd1 vssd1 vccd1 vccd1 sky130_fd_sc_hd__diode_2
X_5079_ _5106_/A _5064_/B _5065_/A _5068_/A vssd1 vssd1 vccd1 vccd1 _5114_/A sky130_fd_sc_hd__a31o_1
XANTENNA_fanout24_A _6223_/B vssd1 vssd1 vccd1 vccd1 sky130_fd_sc_hd__diode_2
XFILLER_0_66_247 vssd1 vssd1 vccd1 vccd1 sky130_fd_sc_hd__fill_1
XANTENNA__4729__A2 _4816_/B vssd1 vssd1 vccd1 vccd1 sky130_fd_sc_hd__diode_2
XFILLER_0_74_291 vssd1 vssd1 vccd1 vccd1 sky130_fd_sc_hd__fill_1
XFILLER_0_74_280 vssd1 vssd1 vccd1 vccd1 sky130_fd_sc_hd__fill_1
XFILLER_0_117_393 vssd1 vssd1 vccd1 vccd1 sky130_ef_sc_hd__decap_12
XFILLER_0_15_380 vssd1 vssd1 vccd1 vccd1 sky130_ef_sc_hd__decap_12
XFILLER_0_132_385 vssd1 vssd1 vccd1 vccd1 sky130_ef_sc_hd__decap_12
XANTENNA__5081__A _5081_/A vssd1 vssd1 vccd1 vccd1 sky130_fd_sc_hd__diode_2
XANTENNA__6406__A2 _6440_/B vssd1 vssd1 vccd1 vccd1 sky130_fd_sc_hd__diode_2
XFILLER_0_15_57 vssd1 vssd1 vccd1 vccd1 sky130_fd_sc_hd__decap_4
XANTENNA__5090__A1 _5091_/B vssd1 vssd1 vccd1 vccd1 sky130_fd_sc_hd__diode_2
XANTENNA__6116__S _6223_/B vssd1 vssd1 vccd1 vccd1 sky130_fd_sc_hd__diode_2
XANTENNA__5090__B2 _5091_/A vssd1 vssd1 vccd1 vccd1 sky130_fd_sc_hd__diode_2
XFILLER_0_57_225 vssd1 vssd1 vccd1 vccd1 sky130_fd_sc_hd__decap_3
XFILLER_0_127_102 vssd1 vssd1 vccd1 vccd1 sky130_fd_sc_hd__fill_1
XANTENNA__5917__A1 _5922_/S vssd1 vssd1 vccd1 vccd1 sky130_fd_sc_hd__diode_2
XFILLER_0_72_206 vssd1 vssd1 vccd1 vccd1 sky130_fd_sc_hd__fill_1
XFILLER_0_31_12 vssd1 vssd1 vccd1 vccd1 sky130_fd_sc_hd__fill_1
XFILLER_0_31_23 vssd1 vssd1 vccd1 vccd1 sky130_fd_sc_hd__fill_2
XFILLER_0_72_239 vssd1 vssd1 vccd1 vccd1 sky130_fd_sc_hd__fill_1
XFILLER_0_25_122 vssd1 vssd1 vccd1 vccd1 sky130_fd_sc_hd__fill_2
XANTENNA__3983__B _5091_/B vssd1 vssd1 vccd1 vccd1 sky130_fd_sc_hd__diode_2
Xhold207 _6805_/Q vssd1 vssd1 vccd1 vccd1 _6323_/A sky130_fd_sc_hd__dlygate4sd3_1
X_4450_ _4451_/A _4451_/C vssd1 vssd1 vccd1 vccd1 _4452_/B sky130_fd_sc_hd__nand2_1
XFILLER_0_40_125 vssd1 vssd1 vccd1 vccd1 sky130_fd_sc_hd__fill_2
Xhold229 _6852_/Q vssd1 vssd1 vccd1 vccd1 hold229/X sky130_fd_sc_hd__dlygate4sd3_1
X_4381_ _4789_/B _4789_/C _4433_/D vssd1 vssd1 vccd1 vccd1 _4381_/X sky130_fd_sc_hd__and3_1
X_3401_ _6650_/Q _3401_/B vssd1 vssd1 vccd1 vccd1 _3402_/B sky130_fd_sc_hd__nor2_1
Xhold218 _6877_/Q vssd1 vssd1 vccd1 vccd1 hold218/X sky130_fd_sc_hd__dlygate4sd3_1
X_6120_ hold79/X pix_mport_o[4] _6223_/B vssd1 vssd1 vccd1 vccd1 _6756_/D sky130_fd_sc_hd__mux2_1
X_3332_ hold39/X _6323_/A vssd1 vssd1 vccd1 vccd1 _6073_/C sky130_fd_sc_hd__nor2_4
XFILLER_0_0_222 vssd1 vssd1 vccd1 vccd1 sky130_fd_sc_hd__fill_2
XFILLER_0_21_361 vssd1 vssd1 vccd1 vccd1 sky130_fd_sc_hd__fill_2
XFILLER_0_0_277 vssd1 vssd1 vccd1 vccd1 sky130_fd_sc_hd__decap_3
XTAP_501 vssd1 vccd1 sky130_fd_sc_hd__tapvpwrvgnd_1
XTAP_512 vssd1 vccd1 sky130_fd_sc_hd__tapvpwrvgnd_1
XTAP_523 vssd1 vccd1 sky130_fd_sc_hd__tapvpwrvgnd_1
XTAP_534 vssd1 vccd1 sky130_fd_sc_hd__tapvpwrvgnd_1
X_3263_ _6803_/Q vssd1 vssd1 vccd1 vccd1 _3263_/Y sky130_fd_sc_hd__inv_2
X_6051_ hold157/X _6038_/B _6054_/B1 vssd1 vssd1 vccd1 vccd1 _6690_/D sky130_fd_sc_hd__a21o_1
XTAP_545 vssd1 vccd1 sky130_fd_sc_hd__tapvpwrvgnd_1
XTAP_556 vssd1 vccd1 sky130_fd_sc_hd__tapvpwrvgnd_1
XTAP_567 vssd1 vccd1 sky130_fd_sc_hd__tapvpwrvgnd_1
XTAP_578 vssd1 vccd1 sky130_fd_sc_hd__tapvpwrvgnd_1
XTAP_589 vssd1 vccd1 sky130_fd_sc_hd__tapvpwrvgnd_1
X_5002_ _5000_/A _5042_/B vssd1 vssd1 vccd1 vccd1 _5354_/A sky130_fd_sc_hd__nand2b_1
XANTENNA__5605__B1 _5687_/A vssd1 vssd1 vccd1 vccd1 sky130_fd_sc_hd__diode_2
X_6953_ vssd1 vssd1 vccd1 vccd1 _6953_/HI tex_mport_o[6] sky130_fd_sc_hd__conb_1
XANTENNA__4959__A2 _5118_/B vssd1 vssd1 vccd1 vccd1 sky130_fd_sc_hd__diode_2
XFILLER_0_72_85 vssd1 vssd1 vccd1 vccd1 sky130_fd_sc_hd__decap_4
X_5904_ hold286/X _5903_/X _5923_/S vssd1 vssd1 vccd1 vccd1 _6649_/D sky130_fd_sc_hd__mux2_1
XFILLER_0_48_214 vssd1 vssd1 vccd1 vccd1 sky130_fd_sc_hd__fill_1
X_6884_ _6884_/CLK _6884_/D vssd1 vssd1 vccd1 vccd1 hold20/A sky130_fd_sc_hd__dfxtp_1
X_5835_ hold294/X _5834_/X _5923_/S vssd1 vssd1 vccd1 vccd1 _6640_/D sky130_fd_sc_hd__mux2_1
XFILLER_0_16_100 vssd1 vssd1 vccd1 vccd1 sky130_fd_sc_hd__fill_1
XFILLER_0_118_157 vssd1 vssd1 vccd1 vccd1 sky130_fd_sc_hd__fill_2
X_5766_ _5766_/A _5766_/B vssd1 vssd1 vccd1 vccd1 _5787_/C sky130_fd_sc_hd__or2_2
XFILLER_0_8_377 vssd1 vssd1 vccd1 vccd1 sky130_ef_sc_hd__decap_12
X_5697_ _5382_/B _5696_/Y _5784_/S vssd1 vssd1 vccd1 vccd1 _5697_/X sky130_fd_sc_hd__mux2_1
X_4717_ _5656_/A _5049_/D vssd1 vssd1 vccd1 vccd1 _4758_/A sky130_fd_sc_hd__nand2_1
X_4648_ _4648_/A _4648_/B vssd1 vssd1 vccd1 vccd1 _4649_/A sky130_fd_sc_hd__and2_1
XFILLER_0_114_385 vssd1 vssd1 vccd1 vccd1 sky130_ef_sc_hd__decap_12
Xfanout1 _5601_/S vssd1 vssd1 vccd1 vccd1 _5576_/S sky130_fd_sc_hd__buf_4
XFILLER_0_31_169 vssd1 vssd1 vccd1 vccd1 sky130_fd_sc_hd__fill_1
X_4579_ _4575_/A _4576_/X _4571_/B _4571_/Y vssd1 vssd1 vccd1 vccd1 _4580_/B sky130_fd_sc_hd__o211ai_2
XFILLER_0_12_372 vssd1 vssd1 vccd1 vccd1 sky130_fd_sc_hd__decap_6
XFILLER_0_12_350 vssd1 vssd1 vccd1 vccd1 sky130_fd_sc_hd__fill_1
X_6318_ _6801_/Q hold1/X _6319_/S vssd1 vssd1 vccd1 vccd1 hold2/A sky130_fd_sc_hd__mux2_1
X_6249_ _6845_/Q _6249_/B vssd1 vssd1 vccd1 vccd1 _6249_/X sky130_fd_sc_hd__or2_1
XFILLER_0_39_214 vssd1 vssd1 vccd1 vccd1 sky130_fd_sc_hd__fill_1
XFILLER_0_109_113 vssd1 vssd1 vccd1 vccd1 sky130_fd_sc_hd__decap_4
XFILLER_0_109_135 vssd1 vssd1 vccd1 vccd1 sky130_fd_sc_hd__decap_4
XANTENNA__5775__S _5784_/S vssd1 vssd1 vccd1 vccd1 sky130_fd_sc_hd__diode_2
XFILLER_0_109_157 vssd1 vssd1 vccd1 vccd1 sky130_fd_sc_hd__decap_3
XFILLER_0_54_239 vssd1 vssd1 vccd1 vccd1 sky130_fd_sc_hd__decap_4
XFILLER_0_105_341 vssd1 vssd1 vccd1 vccd1 sky130_fd_sc_hd__fill_2
XFILLER_0_105_330 vssd1 vssd1 vccd1 vccd1 sky130_fd_sc_hd__fill_2
XFILLER_0_62_272 vssd1 vssd1 vccd1 vccd1 sky130_fd_sc_hd__decap_4
XFILLER_0_22_114 vssd1 vssd1 vccd1 vccd1 sky130_fd_sc_hd__fill_1
XFILLER_0_132_193 vssd1 vssd1 vccd1 vccd1 sky130_fd_sc_hd__decap_3
XFILLER_0_120_355 vssd1 vssd1 vccd1 vccd1 sky130_fd_sc_hd__fill_1
XFILLER_0_10_309 vssd1 vssd1 vccd1 vccd1 sky130_fd_sc_hd__fill_2
XFILLER_0_120_388 vssd1 vssd1 vccd1 vccd1 sky130_ef_sc_hd__decap_12
XFILLER_0_26_23 vssd1 vssd1 vccd1 vccd1 sky130_fd_sc_hd__decap_3
Xhold90 hold90/A vssd1 vssd1 vccd1 vccd1 hold90/X sky130_fd_sc_hd__dlygate4sd3_1
XANTENNA__6354__B _6539_/Q vssd1 vssd1 vccd1 vccd1 sky130_fd_sc_hd__diode_2
XFILLER_0_89_169 vssd1 vssd1 vccd1 vccd1 sky130_fd_sc_hd__decap_8
XFILLER_0_77_309 vssd1 vssd1 vccd1 vccd1 sky130_fd_sc_hd__fill_2
XANTENNA__5063__A1 _5093_/A vssd1 vssd1 vccd1 vccd1 sky130_fd_sc_hd__diode_2
XANTENNA__4155__A _4816_/A vssd1 vssd1 vccd1 vccd1 sky130_fd_sc_hd__diode_2
X_3950_ _5766_/A _5115_/B _5115_/D _5118_/B vssd1 vssd1 vccd1 vccd1 _3950_/X sky130_fd_sc_hd__and4_1
XANTENNA__5063__B2 _6682_/Q vssd1 vssd1 vccd1 vccd1 sky130_fd_sc_hd__diode_2
XFILLER_0_133_57 vssd1 vssd1 vccd1 vccd1 sky130_fd_sc_hd__decap_4
X_3881_ _3881_/A _3881_/B vssd1 vssd1 vccd1 vccd1 _3889_/B sky130_fd_sc_hd__nand2_1
X_5620_ _6518_/Q _3255_/Y _5787_/B _3269_/Y vssd1 vssd1 vccd1 vccd1 _5621_/D sky130_fd_sc_hd__a2bb2o_1
X_5551_ depth_mport_o[26] hold189/X _5556_/S vssd1 vssd1 vccd1 vccd1 _6582_/D sky130_fd_sc_hd__mux2_1
XANTENNA__3377__A1 _5051_/A vssd1 vssd1 vccd1 vccd1 sky130_fd_sc_hd__diode_2
XFILLER_0_53_250 vssd1 vssd1 vccd1 vccd1 sky130_fd_sc_hd__fill_2
X_4502_ _4493_/X _4495_/X _4500_/A _4501_/Y vssd1 vssd1 vccd1 vccd1 _4509_/A sky130_fd_sc_hd__a211o_1
XFILLER_0_13_125 vssd1 vssd1 vccd1 vccd1 sky130_fd_sc_hd__fill_2
XFILLER_0_13_103 vssd1 vssd1 vccd1 vccd1 sky130_fd_sc_hd__fill_1
X_5482_ hold148/X sstream_i[73] _6450_/S vssd1 vssd1 vccd1 vccd1 _6515_/D sky130_fd_sc_hd__mux2_1
X_4433_ _4789_/B _4789_/C _4476_/D _4433_/D vssd1 vssd1 vccd1 vccd1 _4433_/X sky130_fd_sc_hd__and4_1
XANTENNA__4040__D _4736_/D vssd1 vssd1 vccd1 vccd1 sky130_fd_sc_hd__diode_2
XFILLER_0_13_169 vssd1 vssd1 vccd1 vccd1 sky130_fd_sc_hd__fill_2
X_4364_ _4302_/B _4310_/Y _4362_/A _4361_/Y vssd1 vssd1 vccd1 vccd1 _4364_/Y sky130_fd_sc_hd__a211oi_1
X_3315_ depth_mport_i[13] vssd1 vssd1 vccd1 vccd1 _3315_/Y sky130_fd_sc_hd__inv_2
X_4295_ _4283_/A _4283_/C _4283_/B vssd1 vssd1 vccd1 vccd1 _4298_/A sky130_fd_sc_hd__a21bo_1
XTAP_342 vssd1 vccd1 sky130_fd_sc_hd__tapvpwrvgnd_1
XTAP_331 vssd1 vccd1 sky130_fd_sc_hd__tapvpwrvgnd_1
XFILLER_0_6_77 vssd1 vssd1 vccd1 vccd1 sky130_fd_sc_hd__decap_6
XTAP_320 vssd1 vccd1 sky130_fd_sc_hd__tapvpwrvgnd_1
X_6103_ _6642_/Q hold252/X _6113_/S vssd1 vssd1 vccd1 vccd1 _6103_/X sky130_fd_sc_hd__mux2_1
X_6034_ _3961_/A _6033_/Y _6037_/S vssd1 vssd1 vccd1 vccd1 _6676_/D sky130_fd_sc_hd__mux2_1
XTAP_375 vssd1 vccd1 sky130_fd_sc_hd__tapvpwrvgnd_1
XTAP_364 vssd1 vccd1 sky130_fd_sc_hd__tapvpwrvgnd_1
XTAP_353 vssd1 vccd1 sky130_fd_sc_hd__tapvpwrvgnd_1
XANTENNA__5826__B1 _5882_/B vssd1 vssd1 vccd1 vccd1 sky130_fd_sc_hd__diode_2
XANTENNA__4049__B _5687_/A vssd1 vssd1 vccd1 vccd1 sky130_fd_sc_hd__diode_2
XTAP_397 vssd1 vccd1 sky130_fd_sc_hd__tapvpwrvgnd_1
XTAP_386 vssd1 vccd1 sky130_fd_sc_hd__tapvpwrvgnd_1
XFILLER_0_20_3 vssd1 vssd1 vccd1 vccd1 sky130_ef_sc_hd__decap_12
XFILLER_0_68_309 vssd1 vssd1 vccd1 vccd1 sky130_fd_sc_hd__decap_6
X_6936_ vssd1 vssd1 vccd1 vccd1 _6936_/HI pix_mport_o[56] sky130_fd_sc_hd__conb_1
XFILLER_0_95_128 vssd1 vssd1 vccd1 vccd1 sky130_fd_sc_hd__decap_3
XFILLER_0_95_117 vssd1 vssd1 vccd1 vccd1 sky130_fd_sc_hd__fill_2
XPHY_26 vssd1 vssd1 vccd1 vccd1 sky130_fd_sc_hd__decap_3
XPHY_15 vssd1 vssd1 vccd1 vccd1 sky130_fd_sc_hd__decap_3
XPHY_37 vssd1 vssd1 vccd1 vccd1 sky130_fd_sc_hd__decap_3
XFILLER_0_138_208 vssd1 vssd1 vccd1 vccd1 sky130_fd_sc_hd__fill_2
XFILLER_0_76_353 vssd1 vssd1 vccd1 vccd1 sky130_fd_sc_hd__fill_2
XPHY_48 vssd1 vssd1 vccd1 vccd1 sky130_fd_sc_hd__decap_3
XPHY_59 vssd1 vssd1 vccd1 vccd1 sky130_fd_sc_hd__decap_3
XFILLER_0_36_217 vssd1 vssd1 vccd1 vccd1 sky130_fd_sc_hd__decap_3
X_6867_ _6880_/CLK _6867_/D vssd1 vssd1 vccd1 vccd1 _6867_/Q sky130_fd_sc_hd__dfxtp_1
X_6798_ _6827_/CLK _6798_/D vssd1 vssd1 vccd1 vccd1 hold86/A sky130_fd_sc_hd__dfxtp_1
XFILLER_0_8_163 vssd1 vssd1 vccd1 vccd1 sky130_fd_sc_hd__fill_2
X_5818_ tex_addr_i[17] _5919_/B vssd1 vssd1 vccd1 vccd1 _5824_/B sky130_fd_sc_hd__xnor2_1
X_5749_ _5739_/A _5739_/B _5736_/A _5738_/B _5747_/X vssd1 vssd1 vccd1 vccd1 _5761_/B
+ sky130_fd_sc_hd__a311oi_4
XFILLER_0_51_209 vssd1 vssd1 vccd1 vccd1 sky130_fd_sc_hd__fill_2
XFILLER_0_102_377 vssd1 vssd1 vccd1 vccd1 sky130_ef_sc_hd__decap_12
XFILLER_0_12_191 vssd1 vssd1 vccd1 vccd1 sky130_fd_sc_hd__decap_4
XANTENNA__6439__B _6440_/B vssd1 vssd1 vccd1 vccd1 sky130_fd_sc_hd__diode_2
XANTENNA_clkbuf_2_0__f_clk_i_A clkbuf_0_clk_i/X vssd1 vssd1 vccd1 vccd1 sky130_fd_sc_hd__diode_2
XFILLER_0_86_128 vssd1 vssd1 vccd1 vccd1 sky130_fd_sc_hd__fill_2
XANTENNA__5045__A1 _5091_/B vssd1 vssd1 vccd1 vccd1 sky130_fd_sc_hd__diode_2
XANTENNA__5045__B2 _5091_/A vssd1 vssd1 vccd1 vccd1 sky130_fd_sc_hd__diode_2
XFILLER_0_79_191 vssd1 vssd1 vccd1 vccd1 sky130_fd_sc_hd__fill_1
XFILLER_0_67_320 vssd1 vssd1 vccd1 vccd1 sky130_fd_sc_hd__decap_8
XFILLER_0_94_161 vssd1 vssd1 vccd1 vccd1 sky130_fd_sc_hd__decap_8
XFILLER_0_27_217 vssd1 vssd1 vccd1 vccd1 sky130_fd_sc_hd__fill_2
XFILLER_0_103_49 vssd1 vssd1 vccd1 vccd1 sky130_fd_sc_hd__fill_1
XFILLER_0_82_389 vssd1 vssd1 vccd1 vccd1 sky130_ef_sc_hd__decap_12
XANTENNA__6638__SET_B fanout140/X vssd1 vssd1 vccd1 vccd1 sky130_fd_sc_hd__diode_2
XFILLER_0_112_108 vssd1 vssd1 vccd1 vccd1 sky130_fd_sc_hd__fill_2
XFILLER_0_10_128 vssd1 vssd1 vccd1 vccd1 sky130_fd_sc_hd__fill_2
XFILLER_0_128_24 vssd1 vssd1 vccd1 vccd1 sky130_fd_sc_hd__fill_2
X_4080_ _6635_/Q _4080_/B vssd1 vssd1 vccd1 vccd1 _4081_/B sky130_fd_sc_hd__nor2_1
XFILLER_0_37_44 vssd1 vssd1 vccd1 vccd1 sky130_fd_sc_hd__fill_2
XFILLER_0_37_55 vssd1 vssd1 vccd1 vccd1 sky130_fd_sc_hd__fill_1
XFILLER_0_37_66 vssd1 vssd1 vccd1 vccd1 sky130_fd_sc_hd__fill_2
XANTENNA__6756__RESET_B fanout149/X vssd1 vssd1 vccd1 vccd1 sky130_fd_sc_hd__diode_2
XFILLER_0_77_117 vssd1 vssd1 vccd1 vccd1 sky130_fd_sc_hd__fill_1
XFILLER_0_77_106 vssd1 vssd1 vccd1 vccd1 sky130_fd_sc_hd__decap_4
XANTENNA__3501__B _5276_/A vssd1 vssd1 vccd1 vccd1 sky130_fd_sc_hd__diode_2
X_4982_ _4981_/A _4981_/B _4981_/C vssd1 vssd1 vccd1 vccd1 _4984_/C sky130_fd_sc_hd__a21o_1
X_6721_ _6841_/CLK _6721_/D fanout145/X vssd1 vssd1 vccd1 vccd1 _6721_/Q sky130_fd_sc_hd__dfstp_1
X_3933_ _3932_/A _3931_/Y _3854_/X _3904_/Y vssd1 vssd1 vccd1 vccd1 _3936_/B sky130_fd_sc_hd__o211a_1
XFILLER_0_53_98 vssd1 vssd1 vccd1 vccd1 sky130_fd_sc_hd__fill_2
XANTENNA__4795__B1 _4942_/B vssd1 vssd1 vccd1 vccd1 sky130_fd_sc_hd__diode_2
XANTENNA__6304__S _6319_/S vssd1 vssd1 vccd1 vccd1 sky130_fd_sc_hd__diode_2
XANTENNA__5709__A _5718_/B vssd1 vssd1 vccd1 vccd1 sky130_fd_sc_hd__diode_2
XFILLER_0_73_323 vssd1 vssd1 vccd1 vccd1 sky130_fd_sc_hd__decap_4
X_3864_ _5081_/B _5286_/A _3862_/B _3860_/X vssd1 vssd1 vccd1 vccd1 _3867_/B sky130_fd_sc_hd__a31o_1
X_6652_ _6747_/CLK _6652_/D _5937_/A vssd1 vssd1 vccd1 vccd1 _6652_/Q sky130_fd_sc_hd__dfstp_1
X_5603_ _5718_/B _5603_/B vssd1 vssd1 vccd1 vccd1 _5603_/Y sky130_fd_sc_hd__nor2_1
XFILLER_0_5_111 vssd1 vssd1 vccd1 vccd1 sky130_fd_sc_hd__fill_1
X_6583_ _6818_/CLK _6583_/D fanout151/X vssd1 vssd1 vccd1 vccd1 depth_mport_o[27]
+ sky130_fd_sc_hd__dfrtp_4
X_3795_ _5115_/B _3794_/X _3793_/X vssd1 vssd1 vccd1 vccd1 _3797_/A sky130_fd_sc_hd__a21bo_1
XFILLER_0_26_250 vssd1 vssd1 vccd1 vccd1 sky130_fd_sc_hd__fill_2
X_5534_ depth_mport_o[9] hold131/X _5541_/S vssd1 vssd1 vccd1 vccd1 _6565_/D sky130_fd_sc_hd__mux2_1
XFILLER_0_41_220 vssd1 vssd1 vccd1 vccd1 sky130_fd_sc_hd__fill_2
X_5465_ _6073_/C sstream_o vssd1 vssd1 vccd1 vccd1 busy_o sky130_fd_sc_hd__nand2_8
XFILLER_0_111_130 vssd1 vssd1 vccd1 vccd1 sky130_fd_sc_hd__fill_2
X_4416_ _4362_/X _4371_/Y _4414_/A _4414_/Y vssd1 vssd1 vccd1 vccd1 _4416_/X sky130_fd_sc_hd__a211o_1
X_5396_ _5396_/A _5396_/B vssd1 vssd1 vccd1 vccd1 _5398_/B sky130_fd_sc_hd__xnor2_1
XANTENNA__3522__A1 _3961_/A vssd1 vssd1 vccd1 vccd1 sky130_fd_sc_hd__diode_2
X_4347_ _4432_/A _4433_/D _4335_/B _4334_/B vssd1 vssd1 vccd1 vccd1 _4350_/A sky130_fd_sc_hd__a31o_1
X_4278_ _4279_/A _4278_/B _4278_/C vssd1 vssd1 vccd1 vccd1 _4340_/A sky130_fd_sc_hd__nand3_1
XFILLER_0_94_83 vssd1 vssd1 vccd1 vccd1 sky130_fd_sc_hd__fill_1
X_6017_ _6017_/A _6021_/B vssd1 vssd1 vccd1 vccd1 _6017_/Y sky130_fd_sc_hd__nand2_1
XANTENNA__3825__A2 _5276_/B vssd1 vssd1 vccd1 vccd1 sky130_fd_sc_hd__diode_2
XFILLER_0_68_106 vssd1 vssd1 vccd1 vccd1 sky130_fd_sc_hd__fill_1
X_6919_ vssd1 vssd1 vccd1 vccd1 _6919_/HI pix_mport_o[20] sky130_fd_sc_hd__conb_1
XFILLER_0_64_301 vssd1 vssd1 vccd1 vccd1 sky130_fd_sc_hd__decap_4
XFILLER_0_91_120 vssd1 vssd1 vccd1 vccd1 sky130_fd_sc_hd__fill_1
XFILLER_0_91_153 vssd1 vssd1 vccd1 vccd1 sky130_fd_sc_hd__fill_2
XFILLER_0_32_253 vssd1 vssd1 vccd1 vccd1 sky130_fd_sc_hd__decap_6
XFILLER_0_102_130 vssd1 vssd1 vccd1 vccd1 sky130_fd_sc_hd__fill_1
XFILLER_0_99_220 vssd1 vssd1 vccd1 vccd1 sky130_fd_sc_hd__fill_2
XANTENNA__3959__D _5081_/D vssd1 vssd1 vccd1 vccd1 sky130_fd_sc_hd__diode_2
XANTENNA__4136__C _4841_/C vssd1 vssd1 vccd1 vccd1 sky130_fd_sc_hd__diode_2
XFILLER_0_59_139 vssd1 vssd1 vccd1 vccd1 sky130_fd_sc_hd__decap_4
XFILLER_0_114_37 vssd1 vssd1 vccd1 vccd1 sky130_fd_sc_hd__fill_2
XFILLER_0_23_35 vssd1 vssd1 vccd1 vccd1 sky130_fd_sc_hd__decap_3
XANTENNA__6124__S _6224_/B vssd1 vssd1 vccd1 vccd1 sky130_fd_sc_hd__diode_2
XANTENNA__4433__A _4789_/B vssd1 vssd1 vccd1 vccd1 sky130_fd_sc_hd__diode_2
XFILLER_0_67_172 vssd1 vssd1 vccd1 vccd1 sky130_fd_sc_hd__decap_3
XFILLER_0_82_175 vssd1 vssd1 vccd1 vccd1 sky130_fd_sc_hd__fill_1
XFILLER_0_82_164 vssd1 vssd1 vccd1 vccd1 sky130_fd_sc_hd__fill_2
XFILLER_0_82_197 vssd1 vssd1 vccd1 vccd1 sky130_fd_sc_hd__fill_1
X_3580_ _3580_/A _3580_/B _3580_/C vssd1 vssd1 vccd1 vccd1 _3580_/X sky130_fd_sc_hd__or3_2
XFILLER_0_23_253 vssd1 vssd1 vccd1 vccd1 sky130_fd_sc_hd__decap_4
X_5250_ _5251_/A _5250_/B _5250_/C vssd1 vssd1 vccd1 vccd1 _5250_/X sky130_fd_sc_hd__or3_1
X_4201_ _4201_/A _4201_/B vssd1 vssd1 vccd1 vccd1 _4207_/B sky130_fd_sc_hd__nor2_1
X_5181_ _5181_/A _5181_/B _5181_/C vssd1 vssd1 vccd1 vccd1 _5183_/A sky130_fd_sc_hd__or3_1
X_4132_ _4133_/A _4133_/B vssd1 vssd1 vccd1 vccd1 _4132_/Y sky130_fd_sc_hd__nor2_1
XFILLER_0_48_98 vssd1 vssd1 vccd1 vccd1 sky130_fd_sc_hd__fill_1
X_4063_ _4063_/A _4063_/B _4063_/C vssd1 vssd1 vccd1 vccd1 _4271_/A sky130_fd_sc_hd__nand3_1
XANTENNA__3807__A2 _5320_/A vssd1 vssd1 vccd1 vccd1 sky130_fd_sc_hd__diode_2
X_4965_ _5286_/A _5115_/D vssd1 vssd1 vccd1 vccd1 _4969_/A sky130_fd_sc_hd__nand2_1
X_6704_ _6863_/CLK hold24/X vssd1 vssd1 vccd1 vccd1 hold23/A sky130_fd_sc_hd__dfxtp_1
XANTENNA__6034__S _6037_/S vssd1 vssd1 vccd1 vccd1 sky130_fd_sc_hd__diode_2
X_3916_ _3914_/A _3914_/B _3914_/C vssd1 vssd1 vccd1 vccd1 _3917_/C sky130_fd_sc_hd__a21o_1
X_4896_ _4760_/A _4760_/C _4760_/B vssd1 vssd1 vccd1 vccd1 _4898_/B sky130_fd_sc_hd__a21o_1
X_6635_ _6734_/CLK _6635_/D fanout144/X vssd1 vssd1 vccd1 vccd1 _6635_/Q sky130_fd_sc_hd__dfstp_1
XFILLER_0_73_186 vssd1 vssd1 vccd1 vccd1 sky130_fd_sc_hd__decap_8
XFILLER_0_73_164 vssd1 vssd1 vccd1 vccd1 sky130_fd_sc_hd__fill_2
XFILLER_0_13_90 vssd1 vssd1 vccd1 vccd1 sky130_fd_sc_hd__fill_2
X_3847_ _6647_/Q _3847_/B vssd1 vssd1 vccd1 vccd1 _3848_/B sky130_fd_sc_hd__or2_1
XANTENNA__5873__S _5923_/S vssd1 vssd1 vccd1 vccd1 sky130_fd_sc_hd__diode_2
X_6566_ _6853_/CLK _6566_/D _5468_/A vssd1 vssd1 vccd1 vccd1 depth_mport_o[10] sky130_fd_sc_hd__dfrtp_4
XFILLER_0_73_197 vssd1 vssd1 vccd1 vccd1 sky130_fd_sc_hd__fill_2
XFILLER_0_14_220 vssd1 vssd1 vccd1 vccd1 sky130_fd_sc_hd__fill_1
X_3778_ _3778_/A vssd1 vssd1 vccd1 vccd1 _5437_/A sky130_fd_sc_hd__inv_2
X_5517_ hold181/X sstream_i[108] _6473_/S vssd1 vssd1 vccd1 vccd1 _6550_/D sky130_fd_sc_hd__mux2_1
XFILLER_0_14_253 vssd1 vssd1 vccd1 vccd1 sky130_fd_sc_hd__fill_2
XANTENNA__3743__A1 _5051_/A vssd1 vssd1 vccd1 vccd1 sky130_fd_sc_hd__diode_2
X_6497_ hold14/X sstream_i[55] _6501_/S vssd1 vssd1 vccd1 vccd1 _6888_/D sky130_fd_sc_hd__mux2_1
X_5448_ _5449_/B _5449_/C _6743_/Q vssd1 vssd1 vccd1 vccd1 _5448_/Y sky130_fd_sc_hd__a21oi_1
X_5379_ _6723_/Q _5565_/B vssd1 vssd1 vccd1 vccd1 _5380_/D sky130_fd_sc_hd__xnor2_1
Xfanout100 _5311_/A vssd1 vssd1 vccd1 vccd1 _5051_/A sky130_fd_sc_hd__clkbuf_8
Xfanout122 _5787_/B vssd1 vssd1 vccd1 vccd1 _5300_/A sky130_fd_sc_hd__buf_4
Xfanout111 tex_width_i[2] vssd1 vssd1 vccd1 vccd1 _4638_/A sky130_fd_sc_hd__clkbuf_4
Xfanout144 fanout145/X vssd1 vssd1 vccd1 vccd1 fanout144/X sky130_fd_sc_hd__clkbuf_4
Xfanout133 tex_width_i[10] vssd1 vssd1 vccd1 vccd1 _5754_/B sky130_fd_sc_hd__buf_4
XANTENNA__6607__RESET_B fanout153/X vssd1 vssd1 vccd1 vccd1 sky130_fd_sc_hd__diode_2
XANTENNA__4518__A _4789_/B vssd1 vssd1 vccd1 vccd1 sky130_fd_sc_hd__diode_2
XTAP_1113 vssd1 vccd1 sky130_fd_sc_hd__tapvpwrvgnd_1
XTAP_1102 vssd1 vccd1 sky130_fd_sc_hd__tapvpwrvgnd_1
XTAP_1146 vssd1 vccd1 sky130_fd_sc_hd__tapvpwrvgnd_1
XTAP_1135 vssd1 vccd1 sky130_fd_sc_hd__tapvpwrvgnd_1
XTAP_1124 vssd1 vccd1 sky130_fd_sc_hd__tapvpwrvgnd_1
XTAP_1179 vssd1 vccd1 sky130_fd_sc_hd__tapvpwrvgnd_1
XTAP_1168 vssd1 vccd1 sky130_fd_sc_hd__tapvpwrvgnd_1
XTAP_1157 vssd1 vccd1 sky130_fd_sc_hd__tapvpwrvgnd_1
XFILLER_0_64_120 vssd1 vssd1 vccd1 vccd1 sky130_fd_sc_hd__decap_3
XANTENNA__3982__B2 _5091_/A vssd1 vssd1 vccd1 vccd1 sky130_fd_sc_hd__diode_2
XANTENNA__3982__A1 _5091_/B vssd1 vssd1 vccd1 vccd1 sky130_fd_sc_hd__diode_2
XFILLER_0_37_389 vssd1 vssd1 vccd1 vccd1 sky130_fd_sc_hd__decap_3
XFILLER_0_64_197 vssd1 vssd1 vccd1 vccd1 sky130_fd_sc_hd__fill_2
XFILLER_0_122_247 vssd1 vssd1 vccd1 vccd1 sky130_fd_sc_hd__fill_2
XFILLER_0_122_258 vssd1 vssd1 vccd1 vccd1 sky130_fd_sc_hd__fill_2
XTAP_908 vssd1 vccd1 sky130_fd_sc_hd__tapvpwrvgnd_1
XTAP_919 vssd1 vccd1 sky130_fd_sc_hd__tapvpwrvgnd_1
XFILLER_0_85_19 vssd1 vssd1 vccd1 vccd1 sky130_fd_sc_hd__fill_1
XFILLER_0_20_278 vssd1 vssd1 vccd1 vccd1 sky130_fd_sc_hd__decap_3
XANTENNA__6119__S _6223_/B vssd1 vssd1 vccd1 vccd1 sky130_fd_sc_hd__diode_2
XFILLER_0_34_56 vssd1 vssd1 vccd1 vccd1 sky130_fd_sc_hd__decap_3
XFILLER_0_34_67 vssd1 vssd1 vccd1 vccd1 sky130_fd_sc_hd__decap_3
XANTENNA__6362__B hold53/A vssd1 vssd1 vccd1 vccd1 sky130_fd_sc_hd__diode_2
XFILLER_0_28_323 vssd1 vssd1 vccd1 vccd1 sky130_ef_sc_hd__decap_12
XFILLER_0_126_3 vssd1 vssd1 vccd1 vccd1 sky130_fd_sc_hd__fill_2
X_4750_ _4750_/A _4750_/B _4750_/C vssd1 vssd1 vccd1 vccd1 _4752_/B sky130_fd_sc_hd__nand3_2
X_4681_ _5645_/B _4688_/C _4658_/D _5645_/A vssd1 vssd1 vccd1 vccd1 _4682_/C sky130_fd_sc_hd__a22o_1
X_3701_ _3698_/A _3696_/X _3690_/X _3692_/Y vssd1 vssd1 vccd1 vccd1 _3701_/X sky130_fd_sc_hd__o211a_1
XFILLER_0_43_326 vssd1 vssd1 vccd1 vccd1 sky130_fd_sc_hd__decap_8
XFILLER_0_50_66 vssd1 vssd1 vccd1 vccd1 sky130_fd_sc_hd__fill_2
XFILLER_0_55_186 vssd1 vssd1 vccd1 vccd1 sky130_fd_sc_hd__decap_4
X_6420_ hold7/A hold70/A _6546_/Q vssd1 vssd1 vccd1 vccd1 _6422_/A sky130_fd_sc_hd__and3_1
X_3632_ _5081_/A _5300_/A _3630_/B _3628_/X vssd1 vssd1 vccd1 vccd1 _3634_/B sky130_fd_sc_hd__a31o_1
XFILLER_0_43_337 vssd1 vssd1 vccd1 vccd1 sky130_fd_sc_hd__decap_4
X_6351_ _6349_/Y _6350_/X _6441_/B vssd1 vssd1 vccd1 vccd1 _6351_/Y sky130_fd_sc_hd__o21ai_1
XFILLER_0_11_201 vssd1 vssd1 vccd1 vccd1 sky130_fd_sc_hd__fill_2
X_3563_ _3563_/A _3563_/B vssd1 vssd1 vccd1 vccd1 _3587_/A sky130_fd_sc_hd__xnor2_1
X_5302_ _5302_/A _5302_/B vssd1 vssd1 vccd1 vccd1 _5304_/A sky130_fd_sc_hd__xnor2_1
X_6282_ _3300_/Y _6859_/Q _3301_/Y _6858_/Q vssd1 vssd1 vccd1 vccd1 _6282_/X sky130_fd_sc_hd__o22a_1
X_3494_ _5277_/A _5273_/A _5272_/A _5300_/B vssd1 vssd1 vccd1 vccd1 _3494_/X sky130_fd_sc_hd__and4_1
XFILLER_0_121_291 vssd1 vssd1 vccd1 vccd1 sky130_fd_sc_hd__decap_3
XFILLER_0_11_289 vssd1 vssd1 vccd1 vccd1 sky130_fd_sc_hd__fill_2
X_5233_ _5229_/A _5229_/C _5229_/B vssd1 vssd1 vccd1 vccd1 _5234_/B sky130_fd_sc_hd__a21o_1
X_5164_ _5164_/A _5164_/B _5164_/C vssd1 vssd1 vccd1 vccd1 _5164_/X sky130_fd_sc_hd__or3_1
XANTENNA__4150__B2 _4736_/D vssd1 vssd1 vccd1 vccd1 sky130_fd_sc_hd__diode_2
XANTENNA__4150__A1 _4736_/B vssd1 vssd1 vccd1 vccd1 sky130_fd_sc_hd__diode_2
XANTENNA__6771__RESET_B fanout153/X vssd1 vssd1 vccd1 vccd1 sky130_fd_sc_hd__diode_2
X_4115_ _4114_/B _4114_/C _4114_/A vssd1 vssd1 vccd1 vccd1 _4117_/B sky130_fd_sc_hd__a21o_1
XANTENNA__6029__S _6037_/S vssd1 vssd1 vccd1 vccd1 sky130_fd_sc_hd__diode_2
X_5095_ _5051_/A _5071_/A _3979_/C _3979_/D vssd1 vssd1 vccd1 vccd1 _5095_/Y sky130_fd_sc_hd__a22oi_2
X_4046_ _5701_/A _4476_/D _4433_/D _4942_/B vssd1 vssd1 vccd1 vccd1 _4047_/C sky130_fd_sc_hd__a22o_1
XPHY_207 vssd1 vssd1 vccd1 vccd1 sky130_fd_sc_hd__decap_3
XFILLER_0_78_278 vssd1 vssd1 vccd1 vccd1 sky130_fd_sc_hd__fill_2
XPHY_229 vssd1 vssd1 vccd1 vccd1 sky130_fd_sc_hd__decap_3
XPHY_218 vssd1 vssd1 vccd1 vccd1 sky130_fd_sc_hd__decap_3
XFILLER_0_93_237 vssd1 vssd1 vccd1 vccd1 sky130_fd_sc_hd__fill_1
X_5997_ _5996_/Y hold116/X _6000_/S vssd1 vssd1 vccd1 vccd1 _5997_/X sky130_fd_sc_hd__mux2_1
X_4948_ _5053_/B _4947_/B _4947_/C vssd1 vssd1 vccd1 vccd1 _4949_/B sky130_fd_sc_hd__a21oi_1
XFILLER_0_129_391 vssd1 vssd1 vccd1 vccd1 sky130_fd_sc_hd__fill_1
X_4879_ _4880_/A _4880_/B _4880_/C vssd1 vssd1 vccd1 vccd1 _4879_/X sky130_fd_sc_hd__and3_1
XANTENNA__3964__A1 _4944_/B vssd1 vssd1 vccd1 vccd1 sky130_fd_sc_hd__diode_2
X_6618_ _6732_/CLK _6618_/D fanout142/X vssd1 vssd1 vccd1 vccd1 tex_mport_o[61] sky130_fd_sc_hd__dfrtp_4
XFILLER_0_6_261 vssd1 vssd1 vccd1 vccd1 sky130_fd_sc_hd__fill_1
X_6549_ _6864_/CLK _6549_/D vssd1 vssd1 vccd1 vccd1 _6549_/Q sky130_fd_sc_hd__dfxtp_1
XANTENNA__6418__B1 _6440_/B vssd1 vssd1 vccd1 vccd1 sky130_fd_sc_hd__diode_2
XANTENNA__4444__A2 _4518_/D vssd1 vssd1 vccd1 vccd1 sky130_fd_sc_hd__diode_2
XFILLER_0_69_256 vssd1 vssd1 vccd1 vccd1 sky130_fd_sc_hd__decap_3
XFILLER_0_84_237 vssd1 vssd1 vccd1 vccd1 sky130_fd_sc_hd__fill_1
XANTENNA__3404__B1 _3999_/A vssd1 vssd1 vccd1 vccd1 sky130_fd_sc_hd__diode_2
XFILLER_0_37_120 vssd1 vssd1 vccd1 vccd1 sky130_fd_sc_hd__fill_2
XFILLER_0_37_164 vssd1 vssd1 vccd1 vccd1 sky130_fd_sc_hd__fill_2
XFILLER_0_111_38 vssd1 vssd1 vccd1 vccd1 sky130_fd_sc_hd__fill_2
XFILLER_0_111_27 vssd1 vssd1 vccd1 vccd1 sky130_fd_sc_hd__fill_2
XFILLER_0_25_337 vssd1 vssd1 vccd1 vccd1 sky130_fd_sc_hd__fill_2
XFILLER_0_52_112 vssd1 vssd1 vccd1 vccd1 sky130_fd_sc_hd__fill_2
XFILLER_0_20_36 vssd1 vssd1 vccd1 vccd1 sky130_fd_sc_hd__fill_2
XFILLER_0_40_307 vssd1 vssd1 vccd1 vccd1 sky130_fd_sc_hd__fill_1
XANTENNA__3327__A _6834_/Q vssd1 vssd1 vccd1 vccd1 sky130_fd_sc_hd__diode_2
XFILLER_0_33_381 vssd1 vssd1 vccd1 vccd1 sky130_fd_sc_hd__decap_8
XANTENNA__4380__B2 _4736_/B vssd1 vssd1 vccd1 vccd1 sky130_fd_sc_hd__diode_2
XANTENNA__4380__A1 _4736_/D vssd1 vssd1 vccd1 vccd1 sky130_fd_sc_hd__diode_2
XFILLER_0_29_12 vssd1 vssd1 vccd1 vccd1 sky130_fd_sc_hd__decap_4
XFILLER_0_29_23 vssd1 vssd1 vccd1 vccd1 sky130_fd_sc_hd__fill_2
XTAP_705 vssd1 vccd1 sky130_fd_sc_hd__tapvpwrvgnd_1
XTAP_716 vssd1 vccd1 sky130_fd_sc_hd__tapvpwrvgnd_1
XTAP_749 vssd1 vccd1 sky130_fd_sc_hd__tapvpwrvgnd_1
XTAP_738 vssd1 vccd1 sky130_fd_sc_hd__tapvpwrvgnd_1
XTAP_727 vssd1 vccd1 sky130_fd_sc_hd__tapvpwrvgnd_1
XFILLER_0_45_55 vssd1 vssd1 vccd1 vccd1 sky130_fd_sc_hd__fill_1
XANTENNA__6373__A hold60/A vssd1 vssd1 vccd1 vccd1 sky130_fd_sc_hd__diode_2
X_5920_ _5916_/A _5916_/C _5916_/B vssd1 vssd1 vccd1 vccd1 _5921_/B sky130_fd_sc_hd__o21ba_1
XFILLER_0_45_66 vssd1 vssd1 vccd1 vccd1 sky130_fd_sc_hd__fill_2
XFILLER_0_45_77 vssd1 vssd1 vccd1 vccd1 sky130_fd_sc_hd__fill_1
XFILLER_0_0_57 vssd1 vssd1 vccd1 vccd1 sky130_ef_sc_hd__decap_12
X_5851_ _5863_/A _5851_/B _5863_/B vssd1 vssd1 vccd1 vccd1 _5851_/X sky130_fd_sc_hd__or3_1
X_5782_ _5782_/A _5782_/B vssd1 vssd1 vccd1 vccd1 _5783_/B sky130_fd_sc_hd__nor2_1
X_4802_ _4802_/A _4802_/B _4802_/C vssd1 vssd1 vccd1 vccd1 _4804_/B sky130_fd_sc_hd__and3_1
XFILLER_0_61_54 vssd1 vssd1 vccd1 vccd1 sky130_fd_sc_hd__fill_2
XANTENNA__3946__B2 _5787_/A vssd1 vssd1 vccd1 vccd1 sky130_fd_sc_hd__diode_2
XFILLER_0_28_153 vssd1 vssd1 vccd1 vccd1 sky130_fd_sc_hd__fill_2
XANTENNA__3946__A1 _5801_/A vssd1 vssd1 vccd1 vccd1 sky130_fd_sc_hd__diode_2
X_4733_ _4730_/X _4733_/B vssd1 vssd1 vccd1 vccd1 _4877_/B sky130_fd_sc_hd__and2b_1
XANTENNA__6312__S _6319_/S vssd1 vssd1 vccd1 vccd1 sky130_fd_sc_hd__diode_2
XFILLER_0_16_348 vssd1 vssd1 vccd1 vccd1 sky130_fd_sc_hd__fill_2
XFILLER_0_126_394 vssd1 vssd1 vccd1 vccd1 sky130_ef_sc_hd__decap_12
X_6403_ _6403_/A _6410_/B vssd1 vssd1 vccd1 vccd1 _6404_/B sky130_fd_sc_hd__xnor2_1
X_4664_ _4664_/A _4664_/B vssd1 vssd1 vccd1 vccd1 _4672_/B sky130_fd_sc_hd__xnor2_2
XFILLER_0_9_55 vssd1 vssd1 vccd1 vccd1 sky130_fd_sc_hd__fill_1
X_4595_ _4595_/A _4595_/B _4648_/A vssd1 vssd1 vccd1 vccd1 _4612_/A sky130_fd_sc_hd__or3_1
X_3615_ _3615_/A _3615_/B vssd1 vssd1 vccd1 vccd1 _3616_/C sky130_fd_sc_hd__xor2_1
X_6334_ hold200/X depth_mport_o[39] _6440_/B vssd1 vssd1 vccd1 vccd1 _6817_/D sky130_fd_sc_hd__mux2_1
X_3546_ _5081_/B _3959_/B _5308_/B _5277_/B vssd1 vssd1 vccd1 vccd1 _3546_/X sky130_fd_sc_hd__and4_1
XANTENNA_fanout104_A _5106_/A vssd1 vssd1 vccd1 vccd1 sky130_fd_sc_hd__diode_2
X_6265_ depth_mport_i[6] _6258_/B depth_mport_i[5] _3323_/Y _6264_/X vssd1 vssd1 vccd1
+ vccd1 _6265_/X sky130_fd_sc_hd__a221o_1
X_3477_ _3477_/A _3477_/B vssd1 vssd1 vccd1 vccd1 _3487_/A sky130_fd_sc_hd__xnor2_1
X_5216_ _5215_/B _5215_/C _5215_/A vssd1 vssd1 vccd1 vccd1 _5216_/Y sky130_fd_sc_hd__o21ai_1
XFILLER_0_50_3 vssd1 vssd1 vccd1 vccd1 sky130_fd_sc_hd__fill_2
X_6196_ _6185_/X _6193_/Y _6194_/Y _6224_/B vssd1 vssd1 vccd1 vccd1 _6196_/X sky130_fd_sc_hd__o31a_1
X_5147_ _3973_/X _5132_/Y _5145_/A _5144_/Y vssd1 vssd1 vccd1 vccd1 _5148_/B sky130_fd_sc_hd__a211oi_2
X_5078_ _5078_/A _5078_/B vssd1 vssd1 vccd1 vccd1 _5181_/A sky130_fd_sc_hd__nor2_1
X_4029_ _4971_/D _4816_/B _4102_/A _4028_/D vssd1 vssd1 vccd1 vccd1 _4030_/C sky130_fd_sc_hd__a22o_1
XFILLER_0_19_131 vssd1 vssd1 vccd1 vccd1 sky130_fd_sc_hd__fill_2
XFILLER_0_81_218 vssd1 vssd1 vccd1 vccd1 sky130_fd_sc_hd__decap_4
XFILLER_0_19_142 vssd1 vssd1 vccd1 vccd1 sky130_fd_sc_hd__fill_2
XFILLER_0_124_309 vssd1 vssd1 vccd1 vccd1 sky130_fd_sc_hd__fill_2
XANTENNA_fanout17_A _5468_/X vssd1 vssd1 vccd1 vccd1 sky130_fd_sc_hd__diode_2
XANTENNA__5049__D _5049_/D vssd1 vssd1 vccd1 vccd1 sky130_fd_sc_hd__diode_2
XFILLER_0_34_134 vssd1 vssd1 vccd1 vccd1 sky130_fd_sc_hd__decap_4
XANTENNA__4531__A _5666_/A vssd1 vssd1 vccd1 vccd1 sky130_fd_sc_hd__diode_2
XFILLER_0_34_156 vssd1 vssd1 vccd1 vccd1 sky130_fd_sc_hd__fill_1
XFILLER_0_132_397 vssd1 vssd1 vccd1 vccd1 sky130_fd_sc_hd__decap_8
XFILLER_0_30_351 vssd1 vssd1 vccd1 vccd1 sky130_fd_sc_hd__decap_4
XANTENNA__6740__SET_B fanout140/X vssd1 vssd1 vccd1 vccd1 sky130_fd_sc_hd__diode_2
XANTENNA__5081__B _5081_/B vssd1 vssd1 vccd1 vccd1 sky130_fd_sc_hd__diode_2
XFILLER_0_106_27 vssd1 vssd1 vccd1 vccd1 sky130_fd_sc_hd__fill_1
XFILLER_0_97_362 vssd1 vssd1 vccd1 vccd1 sky130_ef_sc_hd__decap_12
XANTENNA__5090__A2 _6682_/Q vssd1 vssd1 vccd1 vccd1 sky130_fd_sc_hd__diode_2
XFILLER_0_57_248 vssd1 vssd1 vccd1 vccd1 sky130_fd_sc_hd__decap_8
XFILLER_0_122_26 vssd1 vssd1 vccd1 vccd1 sky130_fd_sc_hd__fill_2
XFILLER_0_31_35 vssd1 vssd1 vccd1 vccd1 sky130_fd_sc_hd__fill_2
XFILLER_0_65_281 vssd1 vssd1 vccd1 vccd1 sky130_ef_sc_hd__decap_12
XFILLER_0_25_101 vssd1 vssd1 vccd1 vccd1 sky130_fd_sc_hd__fill_2
XFILLER_0_25_156 vssd1 vssd1 vccd1 vccd1 sky130_fd_sc_hd__fill_2
XFILLER_0_25_167 vssd1 vssd1 vccd1 vccd1 sky130_fd_sc_hd__fill_1
XANTENNA__3983__C _5286_/B vssd1 vssd1 vccd1 vccd1 sky130_fd_sc_hd__diode_2
XFILLER_0_123_342 vssd1 vssd1 vccd1 vccd1 sky130_fd_sc_hd__fill_1
Xhold208 _6688_/Q vssd1 vssd1 vccd1 vccd1 hold208/X sky130_fd_sc_hd__dlygate4sd3_1
XANTENNA__5971__S _6038_/C vssd1 vssd1 vccd1 vccd1 sky130_fd_sc_hd__diode_2
XFILLER_0_40_115 vssd1 vssd1 vccd1 vccd1 sky130_fd_sc_hd__fill_1
Xhold219 _6853_/Q vssd1 vssd1 vccd1 vccd1 hold219/X sky130_fd_sc_hd__dlygate4sd3_1
X_4380_ _4736_/D _4433_/D _4774_/B _4736_/B vssd1 vssd1 vccd1 vccd1 _4380_/X sky130_fd_sc_hd__a22o_1
X_3400_ _6650_/Q _3401_/B vssd1 vssd1 vccd1 vccd1 _3402_/A sky130_fd_sc_hd__and2_1
X_3331_ _6731_/Q vssd1 vssd1 vccd1 vccd1 _3331_/Y sky130_fd_sc_hd__inv_2
XFILLER_0_0_245 vssd1 vssd1 vccd1 vccd1 sky130_fd_sc_hd__fill_1
XTAP_502 vssd1 vccd1 sky130_fd_sc_hd__tapvpwrvgnd_1
XTAP_513 vssd1 vccd1 sky130_fd_sc_hd__tapvpwrvgnd_1
XTAP_524 vssd1 vccd1 sky130_fd_sc_hd__tapvpwrvgnd_1
X_3262_ _3262_/A vssd1 vssd1 vccd1 vccd1 _3262_/Y sky130_fd_sc_hd__inv_2
X_6050_ hold138/X _6038_/B _6054_/B1 vssd1 vssd1 vccd1 vccd1 _6689_/D sky130_fd_sc_hd__a21o_1
XTAP_535 vssd1 vccd1 sky130_fd_sc_hd__tapvpwrvgnd_1
XTAP_546 vssd1 vccd1 sky130_fd_sc_hd__tapvpwrvgnd_1
XTAP_557 vssd1 vccd1 sky130_fd_sc_hd__tapvpwrvgnd_1
XTAP_568 vssd1 vccd1 sky130_fd_sc_hd__tapvpwrvgnd_1
XTAP_579 vssd1 vccd1 sky130_fd_sc_hd__tapvpwrvgnd_1
X_5001_ _5235_/B _4998_/X _4921_/X _4924_/X vssd1 vssd1 vccd1 vccd1 _5042_/B sky130_fd_sc_hd__o211ai_2
X_6952_ vssd1 vssd1 vccd1 vccd1 _6952_/HI tex_mport_o[5] sky130_fd_sc_hd__conb_1
XANTENNA__6307__S _6319_/S vssd1 vssd1 vccd1 vccd1 sky130_fd_sc_hd__diode_2
XFILLER_0_72_53 vssd1 vssd1 vccd1 vccd1 sky130_fd_sc_hd__fill_1
X_5903_ _5444_/B _5902_/X _5922_/S vssd1 vssd1 vccd1 vccd1 _5903_/X sky130_fd_sc_hd__mux2_1
X_6883_ _6892_/CLK _6883_/D vssd1 vssd1 vccd1 vccd1 hold19/A sky130_fd_sc_hd__dfxtp_1
XFILLER_0_8_301 vssd1 vssd1 vccd1 vccd1 sky130_fd_sc_hd__fill_2
XFILLER_0_48_237 vssd1 vssd1 vccd1 vccd1 sky130_fd_sc_hd__fill_2
X_5834_ _5355_/Y _5833_/Y _5922_/S vssd1 vssd1 vccd1 vccd1 _5834_/X sky130_fd_sc_hd__mux2_1
X_5765_ _5766_/A _5766_/B vssd1 vssd1 vccd1 vccd1 _5767_/A sky130_fd_sc_hd__nand2_1
XFILLER_0_8_356 vssd1 vssd1 vccd1 vccd1 sky130_fd_sc_hd__decap_8
XFILLER_0_56_270 vssd1 vssd1 vccd1 vccd1 sky130_fd_sc_hd__fill_2
XFILLER_0_133_117 vssd1 vssd1 vccd1 vccd1 sky130_fd_sc_hd__fill_1
XFILLER_0_98_3 vssd1 vssd1 vccd1 vccd1 sky130_fd_sc_hd__fill_2
X_5696_ _5694_/X _5696_/B vssd1 vssd1 vccd1 vccd1 _5696_/Y sky130_fd_sc_hd__nand2b_1
XFILLER_0_71_251 vssd1 vssd1 vccd1 vccd1 sky130_fd_sc_hd__decap_3
XFILLER_0_16_134 vssd1 vssd1 vccd1 vccd1 sky130_fd_sc_hd__decap_3
XFILLER_0_8_389 vssd1 vssd1 vccd1 vccd1 sky130_ef_sc_hd__decap_12
XFILLER_0_16_167 vssd1 vssd1 vccd1 vccd1 sky130_fd_sc_hd__fill_2
X_4716_ _4736_/B _5051_/B _4736_/D _4944_/B vssd1 vssd1 vccd1 vccd1 _4716_/X sky130_fd_sc_hd__and4_1
X_4647_ _4594_/A _4594_/C _4594_/B vssd1 vssd1 vccd1 vccd1 _4648_/B sky130_fd_sc_hd__o21ai_1
Xfanout2 _5601_/S vssd1 vssd1 vccd1 vccd1 _5598_/S sky130_fd_sc_hd__buf_4
XFILLER_0_12_340 vssd1 vssd1 vccd1 vccd1 sky130_fd_sc_hd__decap_3
X_6317_ hold61/X hold34/X _6319_/S vssd1 vssd1 vccd1 vccd1 _6800_/D sky130_fd_sc_hd__mux2_1
XFILLER_0_114_397 vssd1 vssd1 vccd1 vccd1 sky130_fd_sc_hd__decap_8
X_4578_ _4545_/B _4548_/X _4575_/Y _4580_/A vssd1 vssd1 vccd1 vccd1 _4578_/X sky130_fd_sc_hd__o211a_1
X_3529_ _3959_/B _3961_/A _5308_/B _5277_/B vssd1 vssd1 vccd1 vccd1 _3531_/A sky130_fd_sc_hd__nand4_1
X_6248_ _3315_/Y _6846_/Q _6845_/Q _6249_/B vssd1 vssd1 vccd1 vccd1 _6268_/A sky130_fd_sc_hd__a22o_1
X_6179_ _6190_/A _6179_/B vssd1 vssd1 vccd1 vccd1 _6182_/A sky130_fd_sc_hd__nand2_1
XFILLER_0_98_148 vssd1 vssd1 vccd1 vccd1 sky130_fd_sc_hd__decap_6
XANTENNA__4526__A _5718_/B vssd1 vssd1 vccd1 vccd1 sky130_fd_sc_hd__diode_2
XANTENNA__3430__A _5290_/A vssd1 vssd1 vccd1 vccd1 sky130_fd_sc_hd__diode_2
XFILLER_0_94_354 vssd1 vssd1 vccd1 vccd1 sky130_fd_sc_hd__decap_8
XFILLER_0_94_365 vssd1 vssd1 vccd1 vccd1 sky130_ef_sc_hd__decap_12
XANTENNA_clkbuf_leaf_9_clk_i_A clkbuf_leaf_9_clk_i/A vssd1 vssd1 vccd1 vccd1 sky130_fd_sc_hd__diode_2
XFILLER_0_62_284 vssd1 vssd1 vccd1 vccd1 sky130_fd_sc_hd__decap_6
XFILLER_0_22_126 vssd1 vssd1 vccd1 vccd1 sky130_fd_sc_hd__fill_2
XFILLER_0_93_19 vssd1 vssd1 vccd1 vccd1 sky130_fd_sc_hd__fill_1
Xhold91 hold91/A vssd1 vssd1 vccd1 vccd1 hold91/X sky130_fd_sc_hd__dlygate4sd3_1
Xhold80 hold80/A vssd1 vssd1 vccd1 vccd1 hold80/X sky130_fd_sc_hd__dlygate4sd3_1
XANTENNA__6127__S _6224_/B vssd1 vssd1 vccd1 vccd1 sky130_fd_sc_hd__diode_2
XANTENNA__4155__B _5687_/B vssd1 vssd1 vccd1 vccd1 sky130_fd_sc_hd__diode_2
XANTENNA__5063__A2 _5064_/B vssd1 vssd1 vccd1 vccd1 sky130_fd_sc_hd__diode_2
XFILLER_0_85_354 vssd1 vssd1 vccd1 vccd1 sky130_ef_sc_hd__decap_12
X_3880_ _5051_/A _5064_/B _3881_/A _3880_/D vssd1 vssd1 vccd1 vccd1 _3881_/B sky130_fd_sc_hd__nand4_4
XFILLER_0_42_67 vssd1 vssd1 vccd1 vccd1 sky130_fd_sc_hd__fill_2
XFILLER_0_45_229 vssd1 vssd1 vccd1 vccd1 sky130_ef_sc_hd__decap_12
X_5550_ depth_mport_o[25] hold180/X _5556_/S vssd1 vssd1 vccd1 vccd1 _6581_/D sky130_fd_sc_hd__mux2_1
XFILLER_0_115_106 vssd1 vssd1 vccd1 vccd1 sky130_fd_sc_hd__fill_2
XANTENNA__3377__A2 _5276_/B vssd1 vssd1 vccd1 vccd1 sky130_fd_sc_hd__diode_2
XFILLER_0_5_337 vssd1 vssd1 vccd1 vccd1 sky130_fd_sc_hd__fill_2
XANTENNA__4171__A _4842_/A vssd1 vssd1 vccd1 vccd1 sky130_fd_sc_hd__diode_2
X_4501_ _4457_/Y _4463_/X _4498_/A _4498_/Y vssd1 vssd1 vccd1 vccd1 _4501_/Y sky130_fd_sc_hd__a211oi_1
X_5481_ hold165/X sstream_i[72] _6450_/S vssd1 vssd1 vccd1 vccd1 _6514_/D sky130_fd_sc_hd__mux2_1
XFILLER_0_53_273 vssd1 vssd1 vccd1 vccd1 sky130_fd_sc_hd__decap_4
XFILLER_0_111_312 vssd1 vssd1 vccd1 vccd1 sky130_fd_sc_hd__fill_2
X_4432_ _4432_/A _4518_/D vssd1 vssd1 vccd1 vccd1 _4436_/A sky130_fd_sc_hd__nand2_1
XFILLER_0_111_323 vssd1 vssd1 vccd1 vccd1 sky130_fd_sc_hd__decap_3
X_4363_ _4362_/A _4361_/Y _4302_/B _4310_/Y vssd1 vssd1 vccd1 vccd1 _4366_/A sky130_fd_sc_hd__o211a_1
X_3314_ _6847_/Q vssd1 vssd1 vccd1 vccd1 _3314_/Y sky130_fd_sc_hd__inv_2
XFILLER_0_111_389 vssd1 vssd1 vccd1 vccd1 sky130_fd_sc_hd__decap_3
X_4294_ _4294_/A _4355_/A vssd1 vssd1 vccd1 vccd1 _4299_/A sky130_fd_sc_hd__nand2_1
XFILLER_0_67_64 vssd1 vssd1 vccd1 vccd1 sky130_fd_sc_hd__fill_2
XFILLER_0_67_53 vssd1 vssd1 vccd1 vccd1 sky130_fd_sc_hd__decap_3
XTAP_332 vssd1 vccd1 sky130_fd_sc_hd__tapvpwrvgnd_1
XTAP_321 vssd1 vccd1 sky130_fd_sc_hd__tapvpwrvgnd_1
XTAP_310 vssd1 vccd1 sky130_fd_sc_hd__tapvpwrvgnd_1
X_6102_ _6641_/Q hold254/X _6113_/S vssd1 vssd1 vccd1 vccd1 _6102_/X sky130_fd_sc_hd__mux2_1
XFILLER_0_67_86 vssd1 vssd1 vccd1 vccd1 sky130_fd_sc_hd__decap_3
X_6033_ _5948_/A _6038_/C _6032_/X vssd1 vssd1 vccd1 vccd1 _6033_/Y sky130_fd_sc_hd__a21oi_1
XTAP_376 vssd1 vccd1 sky130_fd_sc_hd__tapvpwrvgnd_1
XTAP_365 vssd1 vccd1 sky130_fd_sc_hd__tapvpwrvgnd_1
XTAP_354 vssd1 vccd1 sky130_fd_sc_hd__tapvpwrvgnd_1
XTAP_343 vssd1 vccd1 sky130_fd_sc_hd__tapvpwrvgnd_1
XANTENNA__4049__C _4518_/D vssd1 vssd1 vccd1 vccd1 sky130_fd_sc_hd__diode_2
XTAP_398 vssd1 vccd1 sky130_fd_sc_hd__tapvpwrvgnd_1
XTAP_387 vssd1 vccd1 sky130_fd_sc_hd__tapvpwrvgnd_1
XFILLER_0_13_3 vssd1 vssd1 vccd1 vccd1 sky130_ef_sc_hd__decap_12
XANTENNA__6037__S _6037_/S vssd1 vssd1 vccd1 vccd1 sky130_fd_sc_hd__diode_2
X_6935_ vssd1 vssd1 vccd1 vccd1 _6935_/HI pix_mport_o[55] sky130_fd_sc_hd__conb_1
XPHY_27 vssd1 vssd1 vccd1 vccd1 sky130_fd_sc_hd__decap_3
XPHY_16 vssd1 vssd1 vccd1 vccd1 sky130_fd_sc_hd__decap_3
XPHY_38 vssd1 vssd1 vccd1 vccd1 sky130_fd_sc_hd__decap_3
XFILLER_0_88_192 vssd1 vssd1 vccd1 vccd1 sky130_fd_sc_hd__fill_1
XFILLER_0_88_181 vssd1 vssd1 vccd1 vccd1 sky130_fd_sc_hd__fill_1
XFILLER_0_76_321 vssd1 vssd1 vccd1 vccd1 sky130_fd_sc_hd__fill_2
XPHY_49 vssd1 vssd1 vccd1 vccd1 sky130_fd_sc_hd__decap_3
X_6866_ _6880_/CLK _6866_/D vssd1 vssd1 vccd1 vccd1 _6866_/Q sky130_fd_sc_hd__dfxtp_1
X_6797_ _6827_/CLK hold89/X vssd1 vssd1 vccd1 vccd1 hold88/A sky130_fd_sc_hd__dfxtp_1
X_5817_ hold280/X _5816_/X _5923_/S vssd1 vssd1 vccd1 vccd1 _6637_/D sky130_fd_sc_hd__mux2_1
X_5748_ _5739_/A _5739_/B _5736_/A _5738_/B vssd1 vssd1 vccd1 vccd1 _5748_/X sky130_fd_sc_hd__a31o_1
XFILLER_0_8_197 vssd1 vssd1 vccd1 vccd1 sky130_fd_sc_hd__decap_3
X_5679_ tex_addr_i[4] _5680_/B vssd1 vssd1 vccd1 vccd1 _5695_/A sky130_fd_sc_hd__and2_1
XFILLER_0_102_345 vssd1 vssd1 vccd1 vccd1 sky130_fd_sc_hd__fill_2
XFILLER_0_102_356 vssd1 vssd1 vccd1 vccd1 sky130_fd_sc_hd__fill_2
XFILLER_0_12_170 vssd1 vssd1 vccd1 vccd1 sky130_fd_sc_hd__fill_2
XFILLER_0_102_389 vssd1 vssd1 vccd1 vccd1 sky130_ef_sc_hd__decap_12
XANTENNA_fanout84_A _5081_/D vssd1 vssd1 vccd1 vccd1 sky130_fd_sc_hd__diode_2
XANTENNA__4256__A _4842_/A vssd1 vssd1 vccd1 vccd1 sky130_fd_sc_hd__diode_2
XFILLER_0_86_118 vssd1 vssd1 vccd1 vccd1 sky130_fd_sc_hd__decap_4
XFILLER_0_67_332 vssd1 vssd1 vccd1 vccd1 sky130_fd_sc_hd__fill_2
XFILLER_0_103_39 vssd1 vssd1 vccd1 vccd1 sky130_fd_sc_hd__fill_2
XFILLER_0_12_15 vssd1 vssd1 vccd1 vccd1 sky130_ef_sc_hd__decap_12
XFILLER_0_137_275 vssd1 vssd1 vccd1 vccd1 sky130_fd_sc_hd__fill_2
XFILLER_0_82_357 vssd1 vssd1 vccd1 vccd1 sky130_fd_sc_hd__decap_6
XANTENNA__5753__B1 _5754_/A vssd1 vssd1 vccd1 vccd1 sky130_fd_sc_hd__diode_2
XANTENNA__5505__A0 hold75/X vssd1 vssd1 vccd1 vccd1 sky130_fd_sc_hd__diode_2
XFILLER_0_120_197 vssd1 vssd1 vccd1 vccd1 sky130_fd_sc_hd__decap_4
XFILLER_0_120_175 vssd1 vssd1 vccd1 vccd1 sky130_fd_sc_hd__fill_1
XFILLER_0_37_78 vssd1 vssd1 vccd1 vccd1 sky130_fd_sc_hd__fill_2
XANTENNA__3501__C _5286_/B vssd1 vssd1 vccd1 vccd1 sky130_fd_sc_hd__diode_2
X_4981_ _4981_/A _4981_/B _4981_/C vssd1 vssd1 vccd1 vccd1 _4984_/B sky130_fd_sc_hd__nand3_4
XFILLER_0_58_332 vssd1 vssd1 vccd1 vccd1 sky130_fd_sc_hd__decap_3
X_6720_ _6855_/CLK _6720_/D _6073_/A vssd1 vssd1 vccd1 vccd1 _6720_/Q sky130_fd_sc_hd__dfstp_1
X_3932_ _3932_/A _3932_/B _3932_/C vssd1 vssd1 vccd1 vccd1 _3932_/X sky130_fd_sc_hd__or3_1
XANTENNA__4795__A1 _4942_/A vssd1 vssd1 vccd1 vccd1 sky130_fd_sc_hd__diode_2
XANTENNA__4795__B2 _5083_/A vssd1 vssd1 vccd1 vccd1 sky130_fd_sc_hd__diode_2
XFILLER_0_116_404 vssd1 vssd1 vccd1 vccd1 sky130_fd_sc_hd__decap_3
X_3863_ _4794_/B _5286_/A vssd1 vssd1 vccd1 vccd1 _3915_/B sky130_fd_sc_hd__nand2_1
X_6651_ _6747_/CLK _6651_/D _5937_/A vssd1 vssd1 vccd1 vccd1 _6651_/Q sky130_fd_sc_hd__dfstp_1
X_6582_ _6812_/CLK _6582_/D fanout151/X vssd1 vssd1 vccd1 vccd1 depth_mport_o[26]
+ sky130_fd_sc_hd__dfrtp_4
X_5602_ _5796_/A _6803_/Q _6807_/Q vssd1 vssd1 vccd1 vccd1 _5654_/S sky130_fd_sc_hd__mux2_2
X_5533_ depth_mport_o[8] hold152/X _5541_/S vssd1 vssd1 vccd1 vccd1 _6564_/D sky130_fd_sc_hd__mux2_1
X_3794_ _5081_/A _5081_/B _5766_/A vssd1 vssd1 vccd1 vccd1 _3794_/X sky130_fd_sc_hd__and3_1
XFILLER_0_26_295 vssd1 vssd1 vccd1 vccd1 sky130_fd_sc_hd__fill_2
X_5464_ _6661_/Q _6073_/C vssd1 vssd1 vccd1 vccd1 tex_fly_o sky130_fd_sc_hd__and2_4
XFILLER_0_41_276 vssd1 vssd1 vccd1 vccd1 sky130_fd_sc_hd__fill_2
X_4415_ _4414_/A _4414_/Y _4362_/X _4371_/Y vssd1 vssd1 vccd1 vccd1 _4418_/B sky130_fd_sc_hd__o211ai_4
X_5395_ _5396_/A _5396_/B vssd1 vssd1 vccd1 vccd1 _5395_/X sky130_fd_sc_hd__xor2_2
XFILLER_0_1_362 vssd1 vssd1 vccd1 vccd1 sky130_fd_sc_hd__fill_2
XFILLER_0_111_186 vssd1 vssd1 vccd1 vccd1 sky130_fd_sc_hd__fill_2
X_4346_ _4323_/X _4399_/A _4287_/X _4311_/X vssd1 vssd1 vccd1 vccd1 _4362_/A sky130_fd_sc_hd__a211oi_4
X_4277_ _4271_/A _4271_/B _4271_/C vssd1 vssd1 vccd1 vccd1 _4278_/C sky130_fd_sc_hd__a21o_1
X_6016_ tex_height_i[11] tex_height_i[10] _6016_/C vssd1 vssd1 vccd1 vccd1 _6021_/B
+ sky130_fd_sc_hd__or3_1
X_6918_ vssd1 vssd1 vccd1 vccd1 _6918_/HI pix_mport_o[19] sky130_fd_sc_hd__conb_1
X_6849_ _6862_/CLK _6849_/D vssd1 vssd1 vccd1 vccd1 _6849_/Q sky130_fd_sc_hd__dfxtp_1
XFILLER_0_76_195 vssd1 vssd1 vccd1 vccd1 sky130_fd_sc_hd__fill_1
XFILLER_0_119_297 vssd1 vssd1 vccd1 vccd1 sky130_fd_sc_hd__fill_2
XFILLER_0_91_176 vssd1 vssd1 vccd1 vccd1 sky130_fd_sc_hd__fill_2
XFILLER_0_17_262 vssd1 vssd1 vccd1 vccd1 sky130_fd_sc_hd__fill_2
XFILLER_0_91_198 vssd1 vssd1 vccd1 vccd1 sky130_fd_sc_hd__fill_2
XFILLER_0_32_232 vssd1 vssd1 vccd1 vccd1 sky130_fd_sc_hd__decap_8
XFILLER_0_20_405 vssd1 vssd1 vccd1 vccd1 sky130_fd_sc_hd__fill_2
XFILLER_0_2_3 vssd1 vssd1 vccd1 vccd1 sky130_ef_sc_hd__decap_12
XFILLER_0_99_210 vssd1 vssd1 vccd1 vccd1 sky130_fd_sc_hd__decap_4
XFILLER_0_87_405 vssd1 vssd1 vccd1 vccd1 sky130_fd_sc_hd__fill_2
XANTENNA__4136__D _4841_/D vssd1 vssd1 vccd1 vccd1 sky130_fd_sc_hd__diode_2
XFILLER_0_114_27 vssd1 vssd1 vccd1 vccd1 sky130_fd_sc_hd__fill_1
XANTENNA__4777__A1 _4776_/A vssd1 vssd1 vccd1 vccd1 sky130_fd_sc_hd__diode_2
XANTENNA__4433__B _4789_/C vssd1 vssd1 vccd1 vccd1 sky130_fd_sc_hd__diode_2
XFILLER_0_67_184 vssd1 vssd1 vccd1 vccd1 sky130_fd_sc_hd__fill_1
XFILLER_0_55_324 vssd1 vssd1 vccd1 vccd1 sky130_fd_sc_hd__fill_1
XFILLER_0_82_154 vssd1 vssd1 vccd1 vccd1 sky130_fd_sc_hd__decap_4
XFILLER_0_11_405 vssd1 vssd1 vccd1 vccd1 sky130_fd_sc_hd__fill_2
XFILLER_0_23_265 vssd1 vssd1 vccd1 vccd1 sky130_fd_sc_hd__fill_2
X_4200_ _5787_/A _4527_/B _4841_/C _5787_/B vssd1 vssd1 vccd1 vccd1 _4201_/B sky130_fd_sc_hd__a22oi_1
X_5180_ _5164_/X _5165_/Y _5177_/A _5177_/Y vssd1 vssd1 vccd1 vccd1 _5181_/C sky130_fd_sc_hd__a211oi_1
X_4131_ _4131_/A _4131_/B vssd1 vssd1 vccd1 vccd1 _4133_/B sky130_fd_sc_hd__or2_1
XFILLER_0_48_77 vssd1 vssd1 vccd1 vccd1 sky130_fd_sc_hd__decap_4
X_4062_ _5701_/A _4971_/D _4518_/D _5687_/A vssd1 vssd1 vccd1 vccd1 _4063_/C sky130_fd_sc_hd__a22o_1
XANTENNA__4465__B1 _4841_/C vssd1 vssd1 vccd1 vccd1 sky130_fd_sc_hd__diode_2
XFILLER_0_3_57 vssd1 vssd1 vccd1 vccd1 sky130_ef_sc_hd__decap_12
XFILLER_0_78_405 vssd1 vssd1 vccd1 vccd1 sky130_fd_sc_hd__fill_2
XFILLER_0_64_98 vssd1 vssd1 vccd1 vccd1 sky130_fd_sc_hd__fill_2
XANTENNA__6315__S _6315_/S vssd1 vssd1 vccd1 vccd1 sky130_fd_sc_hd__diode_2
X_4964_ _4964_/A _4964_/B vssd1 vssd1 vccd1 vccd1 _4984_/A sky130_fd_sc_hd__xor2_2
XFILLER_0_58_151 vssd1 vssd1 vccd1 vccd1 sky130_fd_sc_hd__fill_1
X_6703_ _6863_/CLK _6703_/D vssd1 vssd1 vccd1 vccd1 hold77/A sky130_fd_sc_hd__dfxtp_1
XFILLER_0_73_110 vssd1 vssd1 vccd1 vccd1 sky130_fd_sc_hd__fill_2
X_3915_ _3915_/A _3915_/B vssd1 vssd1 vccd1 vccd1 _3917_/B sky130_fd_sc_hd__xnor2_1
XFILLER_0_46_302 vssd1 vssd1 vccd1 vccd1 sky130_fd_sc_hd__decap_6
XFILLER_0_46_324 vssd1 vssd1 vccd1 vccd1 sky130_fd_sc_hd__fill_2
XFILLER_0_58_173 vssd1 vssd1 vccd1 vccd1 sky130_fd_sc_hd__decap_3
XFILLER_0_58_184 vssd1 vssd1 vccd1 vccd1 sky130_fd_sc_hd__fill_2
X_4895_ _4895_/A _4895_/B vssd1 vssd1 vccd1 vccd1 _4900_/A sky130_fd_sc_hd__nand2_1
XFILLER_0_46_335 vssd1 vssd1 vccd1 vccd1 sky130_fd_sc_hd__decap_3
X_6634_ _6734_/CLK _6634_/D fanout144/X vssd1 vssd1 vccd1 vccd1 _6634_/Q sky130_fd_sc_hd__dfstp_1
XFILLER_0_13_80 vssd1 vssd1 vccd1 vccd1 sky130_fd_sc_hd__decap_4
XANTENNA_fanout134_A _5091_/A vssd1 vssd1 vccd1 vccd1 sky130_fd_sc_hd__diode_2
X_3846_ _3846_/A _3846_/B vssd1 vssd1 vccd1 vccd1 _3850_/A sky130_fd_sc_hd__nand2_1
X_6565_ _6853_/CLK _6565_/D _5468_/A vssd1 vssd1 vccd1 vccd1 depth_mport_o[9] sky130_fd_sc_hd__dfrtp_4
XFILLER_0_14_210 vssd1 vssd1 vccd1 vccd1 sky130_fd_sc_hd__fill_1
X_3777_ _3698_/B _3701_/X _3773_/X _3776_/X vssd1 vssd1 vccd1 vccd1 _3778_/A sky130_fd_sc_hd__o211ai_2
X_5516_ hold168/X sstream_i[107] _6473_/S vssd1 vssd1 vccd1 vccd1 _6549_/D sky130_fd_sc_hd__mux2_1
XFILLER_0_89_73 vssd1 vssd1 vccd1 vccd1 sky130_fd_sc_hd__fill_2
X_6496_ hold99/X sstream_i[54] _6501_/S vssd1 vssd1 vccd1 vccd1 _6887_/D sky130_fd_sc_hd__mux2_1
XANTENNA__3743__A2 _5272_/B vssd1 vssd1 vccd1 vccd1 sky130_fd_sc_hd__diode_2
X_5447_ _5449_/B _5449_/C vssd1 vssd1 vccd1 vccd1 _5447_/X sky130_fd_sc_hd__and2_1
X_5378_ _5378_/A _5378_/B vssd1 vssd1 vccd1 vccd1 _5565_/B sky130_fd_sc_hd__xor2_2
Xfanout112 _5091_/B vssd1 vssd1 vccd1 vccd1 _5327_/A sky130_fd_sc_hd__buf_4
Xfanout101 _5311_/A vssd1 vssd1 vccd1 vccd1 _5687_/B sky130_fd_sc_hd__buf_4
Xfanout145 nrst_i vssd1 vssd1 vccd1 vccd1 fanout145/X sky130_fd_sc_hd__buf_4
X_4329_ _4328_/B _4328_/C _4328_/A vssd1 vssd1 vccd1 vccd1 _4330_/C sky130_fd_sc_hd__a21bo_1
Xfanout134 _5091_/A vssd1 vssd1 vccd1 vccd1 _5290_/A sky130_fd_sc_hd__buf_4
Xfanout123 tex_width_i[13] vssd1 vssd1 vccd1 vccd1 _5787_/B sky130_fd_sc_hd__clkbuf_8
XANTENNA_hold179_A hold75/A vssd1 vssd1 vccd1 vccd1 sky130_fd_sc_hd__diode_2
XFILLER_0_69_405 vssd1 vssd1 vccd1 vccd1 sky130_fd_sc_hd__fill_2
XTAP_1114 vssd1 vccd1 sky130_fd_sc_hd__tapvpwrvgnd_1
XTAP_1103 vssd1 vccd1 sky130_fd_sc_hd__tapvpwrvgnd_1
XANTENNA_fanout47_A _4944_/B vssd1 vssd1 vccd1 vccd1 sky130_fd_sc_hd__diode_2
XTAP_1147 vssd1 vccd1 sky130_fd_sc_hd__tapvpwrvgnd_1
XTAP_1136 vssd1 vccd1 sky130_fd_sc_hd__tapvpwrvgnd_1
XTAP_1125 vssd1 vccd1 sky130_fd_sc_hd__tapvpwrvgnd_1
XTAP_1169 vssd1 vccd1 sky130_fd_sc_hd__tapvpwrvgnd_1
XTAP_1158 vssd1 vccd1 sky130_fd_sc_hd__tapvpwrvgnd_1
XFILLER_0_64_110 vssd1 vssd1 vccd1 vccd1 sky130_fd_sc_hd__fill_2
XFILLER_0_37_335 vssd1 vssd1 vccd1 vccd1 sky130_fd_sc_hd__fill_1
XFILLER_0_107_223 vssd1 vssd1 vccd1 vccd1 sky130_fd_sc_hd__fill_1
XFILLER_0_64_165 vssd1 vssd1 vccd1 vccd1 sky130_fd_sc_hd__fill_1
XFILLER_0_64_154 vssd1 vssd1 vccd1 vccd1 sky130_fd_sc_hd__fill_1
XFILLER_0_9_281 vssd1 vssd1 vccd1 vccd1 sky130_fd_sc_hd__fill_1
XANTENNA__3982__A2 _6683_/Q vssd1 vssd1 vccd1 vccd1 sky130_fd_sc_hd__diode_2
XFILLER_0_52_316 vssd1 vssd1 vccd1 vccd1 sky130_fd_sc_hd__fill_2
XFILLER_0_52_338 vssd1 vssd1 vccd1 vccd1 sky130_fd_sc_hd__decap_8
XFILLER_0_107_289 vssd1 vssd1 vccd1 vccd1 sky130_fd_sc_hd__decap_3
XFILLER_0_20_257 vssd1 vssd1 vccd1 vccd1 sky130_fd_sc_hd__fill_2
XTAP_909 vssd1 vccd1 sky130_fd_sc_hd__tapvpwrvgnd_1
XANTENNA__3498__A1 _5286_/A vssd1 vssd1 vccd1 vccd1 sky130_fd_sc_hd__diode_2
XFILLER_0_18_58 vssd1 vssd1 vccd1 vccd1 sky130_fd_sc_hd__fill_1
XFILLER_0_34_24 vssd1 vssd1 vccd1 vccd1 sky130_fd_sc_hd__fill_2
XFILLER_0_87_268 vssd1 vssd1 vccd1 vccd1 sky130_fd_sc_hd__decap_4
X_3700_ _3700_/A _3700_/B vssd1 vssd1 vccd1 vccd1 _5454_/A sky130_fd_sc_hd__xnor2_1
XANTENNA__5974__S _6038_/C vssd1 vssd1 vccd1 vccd1 sky130_fd_sc_hd__diode_2
X_4680_ _4680_/A _4680_/B vssd1 vssd1 vccd1 vccd1 _5376_/A sky130_fd_sc_hd__xor2_2
XFILLER_0_28_379 vssd1 vssd1 vccd1 vccd1 sky130_fd_sc_hd__fill_1
XFILLER_0_119_3 vssd1 vssd1 vccd1 vccd1 sky130_fd_sc_hd__fill_2
X_3631_ _5081_/A _5300_/A vssd1 vssd1 vccd1 vccd1 _3707_/B sky130_fd_sc_hd__nand2_1
X_6350_ _6350_/A _6350_/B _6350_/C vssd1 vssd1 vccd1 vccd1 _6350_/X sky130_fd_sc_hd__and3_1
X_3562_ _3563_/A _3563_/B vssd1 vssd1 vccd1 vccd1 _3562_/Y sky130_fd_sc_hd__nand2_1
X_5301_ _5301_/A _5301_/B vssd1 vssd1 vccd1 vccd1 _5302_/B sky130_fd_sc_hd__xnor2_1
X_6281_ _3302_/Y depth_mport_i[24] _3301_/Y _6858_/Q vssd1 vssd1 vccd1 vccd1 _6283_/C
+ sky130_fd_sc_hd__a2bb2o_1
X_3493_ _5320_/A _5296_/B _3466_/C _3465_/A vssd1 vssd1 vccd1 vccd1 _3507_/A sky130_fd_sc_hd__a31o_1
XFILLER_0_51_393 vssd1 vssd1 vccd1 vccd1 sky130_ef_sc_hd__decap_12
XFILLER_0_59_54 vssd1 vssd1 vccd1 vccd1 sky130_fd_sc_hd__fill_2
XFILLER_0_59_65 vssd1 vssd1 vccd1 vccd1 sky130_fd_sc_hd__decap_3
X_5232_ _5230_/X _5232_/B vssd1 vssd1 vccd1 vccd1 _5416_/A sky130_fd_sc_hd__nand2b_1
XANTENNA__4619__A _5666_/A vssd1 vssd1 vccd1 vccd1 sky130_fd_sc_hd__diode_2
X_5163_ _5164_/A _5164_/B _5164_/C vssd1 vssd1 vccd1 vccd1 _5163_/Y sky130_fd_sc_hd__nor3_1
XANTENNA__4150__A2 _4944_/B vssd1 vssd1 vccd1 vccd1 sky130_fd_sc_hd__diode_2
XFILLER_0_75_53 vssd1 vssd1 vccd1 vccd1 sky130_fd_sc_hd__decap_3
X_4114_ _4114_/A _4114_/B _4114_/C vssd1 vssd1 vccd1 vccd1 _4117_/A sky130_fd_sc_hd__nand3_1
X_5094_ _5094_/A _5094_/B vssd1 vssd1 vccd1 vccd1 _5098_/A sky130_fd_sc_hd__xnor2_1
X_4045_ _5701_/A tex_width_i[5] _4476_/D _4433_/D vssd1 vssd1 vccd1 vccd1 _4047_/B
+ sky130_fd_sc_hd__nand4_2
XANTENNA__3648__A2_N _5273_/B vssd1 vssd1 vccd1 vccd1 sky130_fd_sc_hd__diode_2
XPHY_219 vssd1 vssd1 vccd1 vccd1 sky130_fd_sc_hd__decap_3
XPHY_208 vssd1 vssd1 vccd1 vccd1 sky130_fd_sc_hd__decap_3
X_5996_ _6002_/C _5996_/B vssd1 vssd1 vccd1 vccd1 _5996_/Y sky130_fd_sc_hd__nand2_1
XFILLER_0_93_249 vssd1 vssd1 vccd1 vccd1 sky130_fd_sc_hd__decap_4
X_4947_ _5053_/B _4947_/B _4947_/C vssd1 vssd1 vccd1 vccd1 _4949_/A sky130_fd_sc_hd__and3_1
X_4878_ _4876_/A _4876_/B _4876_/C vssd1 vssd1 vccd1 vccd1 _4880_/C sky130_fd_sc_hd__a21o_1
XANTENNA__3964__A2 _5083_/B vssd1 vssd1 vccd1 vccd1 sky130_fd_sc_hd__diode_2
XFILLER_0_34_316 vssd1 vssd1 vccd1 vccd1 sky130_fd_sc_hd__decap_4
X_3829_ _3827_/X _5296_/B _5299_/A _3829_/D vssd1 vssd1 vccd1 vccd1 _3830_/B sky130_fd_sc_hd__and4b_1
X_6617_ _6751_/CLK _6617_/D fanout139/X vssd1 vssd1 vccd1 vccd1 tex_mport_o[60] sky130_fd_sc_hd__dfrtp_4
XFILLER_0_61_113 vssd1 vssd1 vccd1 vccd1 sky130_fd_sc_hd__fill_2
XFILLER_0_6_273 vssd1 vssd1 vccd1 vccd1 sky130_fd_sc_hd__fill_2
XFILLER_0_61_157 vssd1 vssd1 vccd1 vccd1 sky130_fd_sc_hd__decap_3
X_6548_ _6853_/CLK _6548_/D vssd1 vssd1 vccd1 vccd1 _6548_/Q sky130_fd_sc_hd__dfxtp_1
X_6479_ hold136/X sstream_i[37] _6493_/S vssd1 vssd1 vccd1 vccd1 _6870_/D sky130_fd_sc_hd__mux2_1
XFILLER_0_69_279 vssd1 vssd1 vccd1 vccd1 sky130_fd_sc_hd__fill_1
XFILLER_0_25_316 vssd1 vssd1 vccd1 vccd1 sky130_fd_sc_hd__decap_3
XANTENNA__5807__B _5807_/B vssd1 vssd1 vccd1 vccd1 sky130_fd_sc_hd__diode_2
XFILLER_0_20_15 vssd1 vssd1 vccd1 vccd1 sky130_ef_sc_hd__decap_12
XANTENNA__4380__A2 _4433_/D vssd1 vssd1 vccd1 vccd1 sky130_fd_sc_hd__diode_2
XFILLER_0_0_405 vssd1 vssd1 vccd1 vccd1 sky130_fd_sc_hd__fill_2
XFILLER_0_33_393 vssd1 vssd1 vccd1 vccd1 sky130_ef_sc_hd__decap_12
XFILLER_0_29_35 vssd1 vssd1 vccd1 vccd1 sky130_fd_sc_hd__fill_2
XTAP_706 vssd1 vccd1 sky130_fd_sc_hd__tapvpwrvgnd_1
XTAP_739 vssd1 vccd1 sky130_fd_sc_hd__tapvpwrvgnd_1
XTAP_728 vssd1 vccd1 sky130_fd_sc_hd__tapvpwrvgnd_1
XFILLER_0_29_57 vssd1 vssd1 vccd1 vccd1 sky130_fd_sc_hd__fill_2
XTAP_717 vssd1 vccd1 sky130_fd_sc_hd__tapvpwrvgnd_1
XANTENNA__6409__A1 hold53/A vssd1 vssd1 vccd1 vccd1 sky130_fd_sc_hd__diode_2
XANTENNA__3343__A _5296_/A vssd1 vssd1 vccd1 vccd1 sky130_fd_sc_hd__diode_2
XFILLER_0_45_34 vssd1 vssd1 vccd1 vccd1 sky130_fd_sc_hd__fill_2
XANTENNA__6373__B _6543_/Q vssd1 vssd1 vccd1 vccd1 sky130_fd_sc_hd__diode_2
XANTENNA__4174__A _4518_/D vssd1 vssd1 vccd1 vccd1 sky130_fd_sc_hd__diode_2
XFILLER_0_75_216 vssd1 vssd1 vccd1 vccd1 sky130_fd_sc_hd__fill_2
X_5850_ tex_addr_i[22] _5913_/B vssd1 vssd1 vccd1 vccd1 _5863_/C sky130_fd_sc_hd__xnor2_1
X_5781_ _5779_/X _5781_/B vssd1 vssd1 vccd1 vccd1 _5783_/A sky130_fd_sc_hd__and2b_1
XFILLER_0_0_69 vssd1 vssd1 vccd1 vccd1 sky130_ef_sc_hd__decap_12
XFILLER_0_28_110 vssd1 vssd1 vccd1 vccd1 sky130_fd_sc_hd__fill_2
XFILLER_0_28_132 vssd1 vssd1 vccd1 vccd1 sky130_fd_sc_hd__fill_2
X_4801_ _4800_/A _4800_/B _4800_/C vssd1 vssd1 vccd1 vccd1 _4802_/C sky130_fd_sc_hd__a21o_1
XFILLER_0_28_165 vssd1 vssd1 vccd1 vccd1 sky130_fd_sc_hd__decap_3
XANTENNA__3946__A2 _4971_/D vssd1 vssd1 vccd1 vccd1 sky130_fd_sc_hd__diode_2
X_4732_ _4784_/B _4729_/X _4183_/X _4186_/X vssd1 vssd1 vccd1 vccd1 _4733_/B sky130_fd_sc_hd__a211o_1
XFILLER_0_126_362 vssd1 vssd1 vccd1 vccd1 sky130_fd_sc_hd__fill_2
X_4663_ _4674_/A _4674_/B vssd1 vssd1 vccd1 vccd1 _4672_/A sky130_fd_sc_hd__nand2b_1
XFILLER_0_83_293 vssd1 vssd1 vccd1 vccd1 sky130_fd_sc_hd__decap_3
XFILLER_0_43_113 vssd1 vssd1 vccd1 vccd1 sky130_fd_sc_hd__fill_1
X_6402_ _6402_/A _6402_/B vssd1 vssd1 vccd1 vccd1 _6410_/B sky130_fd_sc_hd__xor2_1
X_3614_ _3587_/C _3590_/Y _3612_/A _3612_/Y vssd1 vssd1 vccd1 vccd1 _3616_/B sky130_fd_sc_hd__a211oi_2
X_4594_ _4594_/A _4594_/B _4594_/C vssd1 vssd1 vccd1 vccd1 _4648_/A sky130_fd_sc_hd__or3_1
XFILLER_0_24_371 vssd1 vssd1 vccd1 vccd1 sky130_fd_sc_hd__fill_1
XFILLER_0_24_382 vssd1 vssd1 vccd1 vccd1 sky130_ef_sc_hd__decap_12
X_6333_ hold185/X depth_mport_o[38] _6333_/S vssd1 vssd1 vccd1 vccd1 _6816_/D sky130_fd_sc_hd__mux2_1
X_3545_ _3545_/A _3545_/B vssd1 vssd1 vccd1 vccd1 _3552_/A sky130_fd_sc_hd__xor2_1
XFILLER_0_3_276 vssd1 vssd1 vccd1 vccd1 sky130_fd_sc_hd__fill_2
X_6264_ depth_mport_i[5] _3323_/Y _3324_/Y depth_mport_i[4] _6263_/X vssd1 vssd1 vccd1
+ vccd1 _6264_/X sky130_fd_sc_hd__o221a_1
X_3476_ _5299_/A _6690_/Q vssd1 vssd1 vccd1 vccd1 _3477_/B sky130_fd_sc_hd__nand2_1
X_5215_ _5215_/A _5215_/B _5215_/C vssd1 vssd1 vccd1 vccd1 _5215_/X sky130_fd_sc_hd__or3_1
X_6195_ _6193_/Y _6194_/Y _6185_/X vssd1 vssd1 vccd1 vccd1 _6195_/Y sky130_fd_sc_hd__o21ai_1
XFILLER_0_86_85 vssd1 vssd1 vccd1 vccd1 sky130_fd_sc_hd__fill_1
XANTENNA__3253__A _5666_/A vssd1 vssd1 vccd1 vccd1 sky130_fd_sc_hd__diode_2
XFILLER_0_43_3 vssd1 vssd1 vccd1 vccd1 sky130_fd_sc_hd__fill_2
X_5146_ _5145_/A _5144_/Y _3973_/X _5132_/Y vssd1 vssd1 vccd1 vccd1 _5148_/A sky130_fd_sc_hd__o211a_2
XANTENNA__5879__S _5922_/S vssd1 vssd1 vccd1 vccd1 sky130_fd_sc_hd__diode_2
X_5077_ _5175_/B _5175_/A vssd1 vssd1 vccd1 vccd1 _5078_/B sky130_fd_sc_hd__and2b_1
X_4028_ _4971_/D _4816_/B _4102_/A _4028_/D vssd1 vssd1 vccd1 vccd1 _4102_/B sky130_fd_sc_hd__nand4_2
XANTENNA__4084__A _4488_/A vssd1 vssd1 vccd1 vccd1 sky130_fd_sc_hd__diode_2
XFILLER_0_66_216 vssd1 vssd1 vccd1 vccd1 sky130_fd_sc_hd__fill_1
X_5979_ _5978_/Y hold125/X _6038_/C vssd1 vssd1 vccd1 vccd1 _5979_/X sky130_fd_sc_hd__mux2_1
XFILLER_0_59_290 vssd1 vssd1 vccd1 vccd1 sky130_fd_sc_hd__decap_3
XFILLER_0_74_260 vssd1 vssd1 vccd1 vccd1 sky130_fd_sc_hd__fill_2
XFILLER_0_136_159 vssd1 vssd1 vccd1 vccd1 sky130_fd_sc_hd__fill_2
XFILLER_0_117_362 vssd1 vssd1 vccd1 vccd1 sky130_fd_sc_hd__fill_1
XFILLER_0_34_124 vssd1 vssd1 vccd1 vccd1 sky130_fd_sc_hd__decap_3
XANTENNA__6336__B1 _6440_/B vssd1 vssd1 vccd1 vccd1 sky130_fd_sc_hd__diode_2
XFILLER_0_132_332 vssd1 vssd1 vccd1 vccd1 sky130_fd_sc_hd__decap_6
XFILLER_0_132_365 vssd1 vssd1 vccd1 vccd1 sky130_fd_sc_hd__fill_1
XFILLER_0_15_393 vssd1 vssd1 vccd1 vccd1 sky130_ef_sc_hd__decap_12
XANTENNA_clkbuf_leaf_5_clk_i_A clkbuf_leaf_9_clk_i/A vssd1 vssd1 vccd1 vccd1 sky130_fd_sc_hd__diode_2
XFILLER_0_89_308 vssd1 vssd1 vccd1 vccd1 sky130_fd_sc_hd__fill_2
XFILLER_0_15_15 vssd1 vssd1 vccd1 vccd1 sky130_ef_sc_hd__decap_12
XFILLER_0_97_374 vssd1 vssd1 vccd1 vccd1 sky130_ef_sc_hd__decap_12
XFILLER_0_65_260 vssd1 vssd1 vccd1 vccd1 sky130_fd_sc_hd__fill_2
XFILLER_0_65_293 vssd1 vssd1 vccd1 vccd1 sky130_fd_sc_hd__decap_6
XFILLER_0_25_113 vssd1 vssd1 vccd1 vccd1 sky130_fd_sc_hd__fill_2
Xhold209 _6803_/Q vssd1 vssd1 vccd1 vccd1 hold209/X sky130_fd_sc_hd__dlygate4sd3_1
X_3330_ _6782_/Q vssd1 vssd1 vccd1 vccd1 _6231_/A sky130_fd_sc_hd__inv_2
XFILLER_0_0_235 vssd1 vssd1 vccd1 vccd1 sky130_fd_sc_hd__fill_2
XANTENNA__5272__B _5272_/B vssd1 vssd1 vccd1 vccd1 sky130_fd_sc_hd__diode_2
XTAP_503 vssd1 vccd1 sky130_fd_sc_hd__tapvpwrvgnd_1
XTAP_514 vssd1 vccd1 sky130_fd_sc_hd__tapvpwrvgnd_1
XTAP_525 vssd1 vccd1 sky130_fd_sc_hd__tapvpwrvgnd_1
X_3261_ _5796_/A vssd1 vssd1 vccd1 vccd1 _3261_/Y sky130_fd_sc_hd__inv_2
XTAP_536 vssd1 vccd1 sky130_fd_sc_hd__tapvpwrvgnd_1
XTAP_547 vssd1 vccd1 sky130_fd_sc_hd__tapvpwrvgnd_1
XTAP_558 vssd1 vccd1 sky130_fd_sc_hd__tapvpwrvgnd_1
X_5000_ _5000_/A vssd1 vssd1 vccd1 vccd1 _5000_/Y sky130_fd_sc_hd__inv_2
XANTENNA__3864__A1 _5081_/B vssd1 vssd1 vccd1 vccd1 sky130_fd_sc_hd__diode_2
XTAP_569 vssd1 vccd1 sky130_fd_sc_hd__tapvpwrvgnd_1
X_6951_ vssd1 vssd1 vccd1 vccd1 _6951_/HI tex_mport_o[4] sky130_fd_sc_hd__conb_1
X_5902_ _5902_/A _5902_/B vssd1 vssd1 vccd1 vccd1 _5902_/X sky130_fd_sc_hd__xor2_1
XFILLER_0_48_227 vssd1 vssd1 vccd1 vccd1 sky130_fd_sc_hd__decap_4
X_6882_ _6892_/CLK _6882_/D vssd1 vssd1 vccd1 vccd1 hold74/A sky130_fd_sc_hd__dfxtp_1
X_5833_ _5837_/C _5833_/B vssd1 vssd1 vccd1 vccd1 _5833_/Y sky130_fd_sc_hd__xnor2_1
XFILLER_0_118_137 vssd1 vssd1 vccd1 vccd1 sky130_fd_sc_hd__fill_1
XANTENNA__5728__A _5796_/A vssd1 vssd1 vccd1 vccd1 sky130_fd_sc_hd__diode_2
XFILLER_0_8_313 vssd1 vssd1 vccd1 vccd1 sky130_fd_sc_hd__fill_2
X_5764_ hold268/X _5763_/X _5844_/S vssd1 vssd1 vccd1 vccd1 _6632_/D sky130_fd_sc_hd__mux2_1
XFILLER_0_133_107 vssd1 vssd1 vccd1 vccd1 sky130_fd_sc_hd__decap_3
X_5695_ _5695_/A _5695_/B _5695_/C _5695_/D vssd1 vssd1 vccd1 vccd1 _5696_/B sky130_fd_sc_hd__or4_1
X_4715_ _5392_/A _5392_/B _5400_/A _4714_/B _4368_/X vssd1 vssd1 vccd1 vccd1 _4715_/Y
+ sky130_fd_sc_hd__a41oi_4
XFILLER_0_16_146 vssd1 vssd1 vccd1 vccd1 sky130_fd_sc_hd__decap_3
XFILLER_0_114_354 vssd1 vssd1 vccd1 vccd1 sky130_fd_sc_hd__decap_4
XFILLER_0_112_93 vssd1 vssd1 vccd1 vccd1 sky130_fd_sc_hd__fill_1
X_4646_ _4650_/A _4650_/B vssd1 vssd1 vccd1 vccd1 _4667_/B sky130_fd_sc_hd__nor2_1
XFILLER_0_71_274 vssd1 vssd1 vccd1 vccd1 sky130_fd_sc_hd__fill_2
XFILLER_0_71_263 vssd1 vssd1 vccd1 vccd1 sky130_fd_sc_hd__fill_2
X_4577_ _4571_/B _4571_/Y _4575_/A _4576_/X vssd1 vssd1 vccd1 vccd1 _4580_/A sky130_fd_sc_hd__a211o_1
XFILLER_0_12_330 vssd1 vssd1 vccd1 vccd1 sky130_fd_sc_hd__decap_4
XFILLER_0_24_190 vssd1 vssd1 vccd1 vccd1 sky130_fd_sc_hd__fill_2
XFILLER_0_31_127 vssd1 vssd1 vccd1 vccd1 sky130_fd_sc_hd__fill_2
XFILLER_0_31_138 vssd1 vssd1 vccd1 vccd1 sky130_fd_sc_hd__decap_3
Xfanout3 _5459_/X vssd1 vssd1 vccd1 vccd1 _5601_/S sky130_fd_sc_hd__buf_4
X_6316_ hold73/X hold93/X _6319_/S vssd1 vssd1 vccd1 vccd1 _6799_/D sky130_fd_sc_hd__mux2_1
XFILLER_0_12_363 vssd1 vssd1 vccd1 vccd1 sky130_fd_sc_hd__fill_1
X_3528_ _5308_/A _5300_/A _3524_/A _3522_/Y vssd1 vssd1 vccd1 vccd1 _3534_/B sky130_fd_sc_hd__o2bb2a_1
X_6247_ _3315_/Y _6846_/Q _6245_/X _6246_/Y vssd1 vssd1 vccd1 vccd1 _6247_/X sky130_fd_sc_hd__o211a_1
X_3459_ _3462_/A vssd1 vssd1 vccd1 vccd1 _3461_/C sky130_fd_sc_hd__inv_2
X_6178_ _6789_/Q _6791_/Q vssd1 vssd1 vccd1 vccd1 _6179_/B sky130_fd_sc_hd__or2_1
X_5129_ _5098_/B _5100_/B _5127_/X _5128_/Y vssd1 vssd1 vccd1 vccd1 _5205_/B sky130_fd_sc_hd__a211o_1
XANTENNA__4526__B _4527_/B vssd1 vssd1 vccd1 vccd1 sky130_fd_sc_hd__diode_2
XANTENNA__3430__B _5327_/A vssd1 vssd1 vccd1 vccd1 sky130_fd_sc_hd__diode_2
XFILLER_0_94_377 vssd1 vssd1 vccd1 vccd1 sky130_ef_sc_hd__decap_12
XANTENNA__4583__A2 _4614_/C vssd1 vssd1 vccd1 vccd1 sky130_fd_sc_hd__diode_2
XFILLER_0_7_390 vssd1 vssd1 vccd1 vccd1 sky130_fd_sc_hd__fill_2
XFILLER_0_30_171 vssd1 vssd1 vccd1 vccd1 sky130_fd_sc_hd__decap_3
Xhold92 hold92/A vssd1 vssd1 vccd1 vccd1 hold92/X sky130_fd_sc_hd__dlygate4sd3_1
Xhold70 hold70/A vssd1 vssd1 vccd1 vccd1 hold70/X sky130_fd_sc_hd__dlygate4sd3_1
Xhold81 hold81/A vssd1 vssd1 vccd1 vccd1 hold81/X sky130_fd_sc_hd__dlygate4sd3_1
XFILLER_0_26_36 vssd1 vssd1 vccd1 vccd1 sky130_fd_sc_hd__fill_2
XANTENNA__4717__A _5656_/A vssd1 vssd1 vccd1 vccd1 sky130_fd_sc_hd__diode_2
XFILLER_0_26_69 vssd1 vssd1 vccd1 vccd1 sky130_fd_sc_hd__decap_3
XFILLER_0_85_300 vssd1 vssd1 vccd1 vccd1 sky130_fd_sc_hd__fill_1
XFILLER_0_97_182 vssd1 vssd1 vccd1 vccd1 sky130_fd_sc_hd__fill_2
XFILLER_0_85_333 vssd1 vssd1 vccd1 vccd1 sky130_fd_sc_hd__decap_3
XFILLER_0_85_322 vssd1 vssd1 vccd1 vccd1 sky130_fd_sc_hd__fill_2
XFILLER_0_85_366 vssd1 vssd1 vccd1 vccd1 sky130_ef_sc_hd__decap_12
XFILLER_0_45_208 vssd1 vssd1 vccd1 vccd1 sky130_fd_sc_hd__fill_2
XFILLER_0_26_400 vssd1 vssd1 vccd1 vccd1 sky130_fd_sc_hd__decap_6
XFILLER_0_42_79 vssd1 vssd1 vccd1 vccd1 sky130_fd_sc_hd__decap_3
XANTENNA__4171__B _4966_/A vssd1 vssd1 vccd1 vccd1 sky130_fd_sc_hd__diode_2
XFILLER_0_5_316 vssd1 vssd1 vccd1 vccd1 sky130_fd_sc_hd__fill_1
XFILLER_0_5_305 vssd1 vssd1 vccd1 vccd1 sky130_fd_sc_hd__fill_2
X_4500_ _4500_/A vssd1 vssd1 vccd1 vccd1 _4500_/Y sky130_fd_sc_hd__inv_2
X_5480_ hold149/X sstream_i[71] _6450_/S vssd1 vssd1 vccd1 vccd1 _6513_/D sky130_fd_sc_hd__mux2_1
XFILLER_0_111_302 vssd1 vssd1 vccd1 vccd1 sky130_fd_sc_hd__fill_1
XANTENNA_1 _5740_/X vssd1 vssd1 vccd1 vccd1 sky130_fd_sc_hd__diode_2
X_4431_ _4431_/A _4431_/B _4431_/C vssd1 vssd1 vccd1 vccd1 _4438_/A sky130_fd_sc_hd__nand3_1
XFILLER_0_123_184 vssd1 vssd1 vccd1 vccd1 sky130_fd_sc_hd__fill_2
XFILLER_0_111_335 vssd1 vssd1 vccd1 vccd1 sky130_fd_sc_hd__fill_1
X_4362_ _4362_/A _4362_/B _4362_/C vssd1 vssd1 vccd1 vccd1 _4362_/X sky130_fd_sc_hd__or3_2
X_3313_ _6848_/Q vssd1 vssd1 vccd1 vccd1 _6244_/B sky130_fd_sc_hd__inv_2
X_4293_ _6633_/Q _4354_/B vssd1 vssd1 vccd1 vccd1 _4355_/A sky130_fd_sc_hd__nand2_1
XTAP_333 vssd1 vccd1 sky130_fd_sc_hd__tapvpwrvgnd_1
XTAP_322 vssd1 vccd1 sky130_fd_sc_hd__tapvpwrvgnd_1
XTAP_300 vssd1 vccd1 sky130_fd_sc_hd__tapvpwrvgnd_1
XTAP_311 vssd1 vccd1 sky130_fd_sc_hd__tapvpwrvgnd_1
X_6101_ _6640_/Q hold288/X _6113_/S vssd1 vssd1 vccd1 vccd1 _6101_/X sky130_fd_sc_hd__mux2_1
X_6032_ _6038_/C _6032_/B _6038_/D vssd1 vssd1 vccd1 vccd1 _6032_/X sky130_fd_sc_hd__and3b_1
XTAP_366 vssd1 vccd1 sky130_fd_sc_hd__tapvpwrvgnd_1
XTAP_355 vssd1 vccd1 sky130_fd_sc_hd__tapvpwrvgnd_1
XTAP_344 vssd1 vccd1 sky130_fd_sc_hd__tapvpwrvgnd_1
XANTENNA__4049__D _4476_/D vssd1 vssd1 vccd1 vccd1 sky130_fd_sc_hd__diode_2
XTAP_399 vssd1 vccd1 sky130_fd_sc_hd__tapvpwrvgnd_1
XTAP_388 vssd1 vccd1 sky130_fd_sc_hd__tapvpwrvgnd_1
XTAP_377 vssd1 vccd1 sky130_fd_sc_hd__tapvpwrvgnd_1
XANTENNA__6318__S _6319_/S vssd1 vssd1 vccd1 vccd1 sky130_fd_sc_hd__diode_2
X_6934_ vssd1 vssd1 vccd1 vccd1 _6934_/HI pix_mport_o[54] sky130_fd_sc_hd__conb_1
XPHY_28 vssd1 vssd1 vccd1 vccd1 sky130_fd_sc_hd__decap_3
XPHY_17 vssd1 vssd1 vccd1 vccd1 sky130_fd_sc_hd__decap_3
XPHY_39 vssd1 vssd1 vccd1 vccd1 sky130_fd_sc_hd__decap_3
XFILLER_0_8_121 vssd1 vssd1 vccd1 vccd1 sky130_fd_sc_hd__fill_2
X_6865_ _6880_/CLK _6865_/D vssd1 vssd1 vccd1 vccd1 _6865_/Q sky130_fd_sc_hd__dfxtp_1
X_6796_ _6818_/CLK hold33/X vssd1 vssd1 vccd1 vccd1 hold32/A sky130_fd_sc_hd__dfxtp_1
XFILLER_0_91_314 vssd1 vssd1 vccd1 vccd1 sky130_ef_sc_hd__decap_12
X_5816_ _5599_/A _5407_/B _5814_/Y _5815_/X vssd1 vssd1 vccd1 vccd1 _5816_/X sky130_fd_sc_hd__a22o_1
X_5747_ _5761_/A _5747_/B vssd1 vssd1 vccd1 vccd1 _5747_/X sky130_fd_sc_hd__or2_1
XFILLER_0_44_274 vssd1 vssd1 vccd1 vccd1 sky130_fd_sc_hd__decap_4
X_5678_ _5677_/Y _6510_/Q _5802_/B vssd1 vssd1 vccd1 vccd1 _5680_/B sky130_fd_sc_hd__mux2_1
X_4629_ _4629_/A _4633_/B vssd1 vssd1 vccd1 vccd1 _4629_/Y sky130_fd_sc_hd__nor2_1
XANTENNA_fanout77_A _4527_/B vssd1 vssd1 vccd1 vccd1 sky130_fd_sc_hd__diode_2
XANTENNA__4256__B _5718_/B vssd1 vssd1 vccd1 vccd1 sky130_fd_sc_hd__diode_2
XFILLER_0_79_182 vssd1 vssd1 vccd1 vccd1 sky130_fd_sc_hd__decap_3
XFILLER_0_94_141 vssd1 vssd1 vccd1 vccd1 sky130_fd_sc_hd__fill_1
XFILLER_0_82_303 vssd1 vssd1 vccd1 vccd1 sky130_fd_sc_hd__fill_2
XFILLER_0_94_174 vssd1 vssd1 vccd1 vccd1 sky130_fd_sc_hd__decap_8
XFILLER_0_12_27 vssd1 vssd1 vccd1 vccd1 sky130_fd_sc_hd__fill_1
XFILLER_0_125_405 vssd1 vssd1 vccd1 vccd1 sky130_fd_sc_hd__fill_2
XANTENNA__5753__A1 _5754_/B vssd1 vssd1 vccd1 vccd1 sky130_fd_sc_hd__diode_2
XFILLER_0_35_285 vssd1 vssd1 vccd1 vccd1 sky130_fd_sc_hd__fill_1
XFILLER_0_50_211 vssd1 vssd1 vccd1 vccd1 sky130_fd_sc_hd__fill_2
XFILLER_0_50_222 vssd1 vssd1 vccd1 vccd1 sky130_fd_sc_hd__fill_1
XANTENNA__3516__B1 _5277_/B vssd1 vssd1 vccd1 vccd1 sky130_fd_sc_hd__diode_2
XFILLER_0_128_37 vssd1 vssd1 vccd1 vccd1 sky130_fd_sc_hd__fill_2
XFILLER_0_101_390 vssd1 vssd1 vccd1 vccd1 sky130_fd_sc_hd__fill_2
XANTENNA__3501__D _5296_/B vssd1 vssd1 vccd1 vccd1 sky130_fd_sc_hd__diode_2
XFILLER_0_58_300 vssd1 vssd1 vccd1 vccd1 sky130_fd_sc_hd__fill_1
X_4980_ _4839_/A _4839_/C _4839_/B vssd1 vssd1 vccd1 vccd1 _4981_/C sky130_fd_sc_hd__a21bo_1
XFILLER_0_53_78 vssd1 vssd1 vccd1 vccd1 sky130_fd_sc_hd__fill_2
X_3931_ _3932_/A _3932_/B _3932_/C vssd1 vssd1 vccd1 vccd1 _3931_/Y sky130_fd_sc_hd__nor3_2
XFILLER_0_53_89 vssd1 vssd1 vccd1 vccd1 sky130_fd_sc_hd__fill_1
XANTENNA__4795__A2 _4794_/B vssd1 vssd1 vccd1 vccd1 sky130_fd_sc_hd__diode_2
X_3862_ _3860_/X _3862_/B vssd1 vssd1 vccd1 vccd1 _3915_/A sky130_fd_sc_hd__and2b_1
X_6650_ _6747_/CLK _6650_/D _5937_/A vssd1 vssd1 vccd1 vccd1 _6650_/Q sky130_fd_sc_hd__dfstp_1
XANTENNA__4182__A _4971_/D vssd1 vssd1 vccd1 vccd1 sky130_fd_sc_hd__diode_2
X_6581_ _6812_/CLK _6581_/D fanout149/X vssd1 vssd1 vccd1 vccd1 depth_mport_o[25]
+ sky130_fd_sc_hd__dfrtp_4
X_5601_ _5457_/B tex_mport_o[63] _5601_/S vssd1 vssd1 vccd1 vccd1 _6620_/D sky130_fd_sc_hd__mux2_1
X_5532_ depth_mport_o[7] hold122/X _5541_/S vssd1 vssd1 vccd1 vccd1 _6563_/D sky130_fd_sc_hd__mux2_1
XFILLER_0_5_146 vssd1 vssd1 vccd1 vccd1 sky130_fd_sc_hd__fill_2
XFILLER_0_5_113 vssd1 vssd1 vccd1 vccd1 sky130_ef_sc_hd__decap_12
X_3793_ _5081_/A _5766_/A _5115_/B _5081_/B vssd1 vssd1 vccd1 vccd1 _3793_/X sky130_fd_sc_hd__a22o_1
XANTENNA__6765__RESET_B fanout153/X vssd1 vssd1 vccd1 vccd1 sky130_fd_sc_hd__diode_2
X_5463_ _3262_/Y _6073_/C _5588_/C _5784_/S _6098_/S vssd1 vssd1 vccd1 vccd1 _6808_/D
+ sky130_fd_sc_hd__o221ai_1
XFILLER_0_78_42 vssd1 vssd1 vccd1 vccd1 sky130_fd_sc_hd__fill_1
X_5394_ _3331_/Y _5360_/X _5391_/X _5393_/Y vssd1 vssd1 vccd1 vccd1 _5402_/A sky130_fd_sc_hd__o211a_1
X_4414_ _4414_/A _4414_/B _4414_/C vssd1 vssd1 vccd1 vccd1 _4414_/Y sky130_fd_sc_hd__nor3_4
X_4345_ _4345_/A _4345_/B _4345_/C vssd1 vssd1 vccd1 vccd1 _4399_/A sky130_fd_sc_hd__nand3_2
XFILLER_0_78_97 vssd1 vssd1 vccd1 vccd1 sky130_fd_sc_hd__decap_3
XFILLER_0_1_374 vssd1 vssd1 vccd1 vccd1 sky130_ef_sc_hd__decap_12
X_4276_ _4276_/A _4276_/B vssd1 vssd1 vccd1 vccd1 _4278_/B sky130_fd_sc_hd__xnor2_1
XANTENNA__3261__A _5796_/A vssd1 vssd1 vccd1 vccd1 sky130_fd_sc_hd__diode_2
XFILLER_0_94_85 vssd1 vssd1 vccd1 vccd1 sky130_fd_sc_hd__decap_4
XFILLER_0_94_74 vssd1 vssd1 vccd1 vccd1 sky130_fd_sc_hd__fill_2
X_6015_ tex_height_i[10] _6016_/C tex_height_i[11] vssd1 vssd1 vccd1 vccd1 _6017_/A
+ sky130_fd_sc_hd__o21ai_1
XFILLER_0_27_90 vssd1 vssd1 vccd1 vccd1 sky130_fd_sc_hd__fill_2
XFILLER_0_68_119 vssd1 vssd1 vccd1 vccd1 sky130_fd_sc_hd__fill_2
X_6917_ vssd1 vssd1 vccd1 vccd1 _6917_/HI pix_mport_o[18] sky130_fd_sc_hd__conb_1
XFILLER_0_134_80 vssd1 vssd1 vccd1 vccd1 sky130_fd_sc_hd__fill_2
XFILLER_0_76_141 vssd1 vssd1 vccd1 vccd1 sky130_fd_sc_hd__decap_4
X_6848_ _6864_/CLK _6848_/D vssd1 vssd1 vccd1 vccd1 _6848_/Q sky130_fd_sc_hd__dfxtp_1
XANTENNA__4092__A _4966_/A vssd1 vssd1 vccd1 vccd1 sky130_fd_sc_hd__diode_2
XFILLER_0_76_163 vssd1 vssd1 vccd1 vccd1 sky130_fd_sc_hd__fill_1
XFILLER_0_64_325 vssd1 vssd1 vccd1 vccd1 sky130_fd_sc_hd__decap_8
XFILLER_0_49_377 vssd1 vssd1 vccd1 vccd1 sky130_ef_sc_hd__decap_12
XFILLER_0_107_405 vssd1 vssd1 vccd1 vccd1 sky130_fd_sc_hd__fill_2
XFILLER_0_91_133 vssd1 vssd1 vccd1 vccd1 sky130_fd_sc_hd__fill_2
X_6779_ _6832_/CLK _6779_/D fanout152/X vssd1 vssd1 vccd1 vccd1 pix_mport_o[68] sky130_fd_sc_hd__dfrtp_4
XFILLER_0_134_224 vssd1 vssd1 vccd1 vccd1 sky130_fd_sc_hd__decap_6
XFILLER_0_91_188 vssd1 vssd1 vccd1 vccd1 sky130_fd_sc_hd__fill_1
XFILLER_0_17_285 vssd1 vssd1 vccd1 vccd1 sky130_fd_sc_hd__decap_4
XANTENNA__3436__A _5049_/A vssd1 vssd1 vccd1 vccd1 sky130_fd_sc_hd__diode_2
XFILLER_0_32_244 vssd1 vssd1 vccd1 vccd1 sky130_fd_sc_hd__decap_8
XFILLER_0_32_288 vssd1 vssd1 vccd1 vccd1 sky130_fd_sc_hd__fill_2
XFILLER_0_102_154 vssd1 vssd1 vccd1 vccd1 sky130_fd_sc_hd__decap_4
XANTENNA__4267__A _5687_/B vssd1 vssd1 vccd1 vccd1 sky130_fd_sc_hd__diode_2
XFILLER_0_23_15 vssd1 vssd1 vccd1 vccd1 sky130_ef_sc_hd__decap_12
XANTENNA__4777__A2 _4816_/B vssd1 vssd1 vccd1 vccd1 sky130_fd_sc_hd__diode_2
XFILLER_0_23_48 vssd1 vssd1 vccd1 vccd1 sky130_fd_sc_hd__fill_2
XANTENNA__4433__C _4476_/D vssd1 vssd1 vccd1 vccd1 sky130_fd_sc_hd__diode_2
XFILLER_0_82_133 vssd1 vssd1 vccd1 vccd1 sky130_fd_sc_hd__fill_2
XFILLER_0_82_122 vssd1 vssd1 vccd1 vccd1 sky130_fd_sc_hd__fill_2
XFILLER_0_125_279 vssd1 vssd1 vccd1 vccd1 sky130_fd_sc_hd__fill_1
XFILLER_0_63_391 vssd1 vssd1 vccd1 vccd1 sky130_fd_sc_hd__fill_1
XFILLER_0_23_277 vssd1 vssd1 vccd1 vccd1 sky130_fd_sc_hd__decap_3
XANTENNA__5561__A _5796_/A vssd1 vssd1 vccd1 vccd1 sky130_fd_sc_hd__diode_2
X_4130_ _6636_/Q _4130_/B vssd1 vssd1 vccd1 vccd1 _4131_/B sky130_fd_sc_hd__nor2_1
XANTENNA__6650__SET_B _5937_/A vssd1 vssd1 vccd1 vccd1 sky130_fd_sc_hd__diode_2
X_4061_ _5311_/A _4476_/D vssd1 vssd1 vccd1 vccd1 _4063_/B sky130_fd_sc_hd__and2_1
XANTENNA__4465__B2 _4816_/B vssd1 vssd1 vccd1 vccd1 sky130_fd_sc_hd__diode_2
XFILLER_0_64_22 vssd1 vssd1 vccd1 vccd1 sky130_fd_sc_hd__decap_4
XFILLER_0_3_69 vssd1 vssd1 vccd1 vccd1 sky130_ef_sc_hd__decap_12
X_4963_ _4963_/A _4963_/B vssd1 vssd1 vccd1 vccd1 _4964_/B sky130_fd_sc_hd__xnor2_2
X_6702_ _6830_/CLK hold12/X vssd1 vssd1 vccd1 vccd1 hold11/A sky130_fd_sc_hd__dfxtp_1
X_3914_ _3914_/A _3914_/B _3914_/C vssd1 vssd1 vccd1 vccd1 _3917_/A sky130_fd_sc_hd__nand3_1
X_6633_ _6633_/CLK _6633_/D fanout142/X vssd1 vssd1 vccd1 vccd1 _6633_/Q sky130_fd_sc_hd__dfstp_1
X_4894_ _4205_/B _4205_/Y _4879_/X _4893_/Y vssd1 vssd1 vccd1 vccd1 _4904_/C sky130_fd_sc_hd__a211o_2
XFILLER_0_46_347 vssd1 vssd1 vccd1 vccd1 sky130_fd_sc_hd__fill_2
XFILLER_0_104_83 vssd1 vssd1 vccd1 vccd1 sky130_fd_sc_hd__fill_1
X_3845_ _3845_/A _3895_/A vssd1 vssd1 vccd1 vccd1 _3852_/A sky130_fd_sc_hd__nand2_1
XANTENNA__6331__S _6440_/B vssd1 vssd1 vccd1 vccd1 sky130_fd_sc_hd__diode_2
X_6564_ _6853_/CLK _6564_/D _5468_/A vssd1 vssd1 vccd1 vccd1 depth_mport_o[8] sky130_fd_sc_hd__dfrtp_4
XANTENNA_fanout127_A _5754_/A vssd1 vssd1 vccd1 vccd1 sky130_fd_sc_hd__diode_2
X_3776_ _3779_/A _3779_/B vssd1 vssd1 vccd1 vccd1 _3776_/X sky130_fd_sc_hd__or2_1
X_5515_ hold146/X sstream_i[106] _6465_/S vssd1 vssd1 vccd1 vccd1 _6548_/D sky130_fd_sc_hd__mux2_1
X_6495_ hold90/X sstream_i[53] _6501_/S vssd1 vssd1 vccd1 vccd1 _6886_/D sky130_fd_sc_hd__mux2_1
XFILLER_0_89_96 vssd1 vssd1 vccd1 vccd1 sky130_fd_sc_hd__fill_2
XANTENNA__3256__A _5754_/A vssd1 vssd1 vccd1 vccd1 sky130_fd_sc_hd__diode_2
XFILLER_0_14_299 vssd1 vssd1 vccd1 vccd1 sky130_fd_sc_hd__decap_3
XFILLER_0_14_288 vssd1 vssd1 vccd1 vccd1 sky130_fd_sc_hd__decap_6
XFILLER_0_14_266 vssd1 vssd1 vccd1 vccd1 sky130_fd_sc_hd__fill_1
X_5446_ _5445_/A _5445_/C _5445_/B vssd1 vssd1 vccd1 vccd1 _5449_/C sky130_fd_sc_hd__a21o_1
X_5377_ _6722_/Q _5563_/B vssd1 vssd1 vccd1 vccd1 _5380_/C sky130_fd_sc_hd__xnor2_1
Xfanout102 tex_width_i[4] vssd1 vssd1 vccd1 vccd1 _5311_/A sky130_fd_sc_hd__buf_4
Xfanout113 tex_width_i[1] vssd1 vssd1 vccd1 vccd1 _5091_/B sky130_fd_sc_hd__clkbuf_4
Xfanout146 nrst_i vssd1 vssd1 vccd1 vccd1 _6073_/A sky130_fd_sc_hd__clkbuf_8
X_4328_ _4328_/A _4328_/B _4328_/C vssd1 vssd1 vccd1 vccd1 _4378_/A sky130_fd_sc_hd__nand3_1
Xfanout135 tex_width_i[0] vssd1 vssd1 vccd1 vccd1 _5091_/A sky130_fd_sc_hd__clkbuf_4
Xfanout124 _5766_/A vssd1 vssd1 vccd1 vccd1 _5273_/A sky130_fd_sc_hd__buf_4
X_4259_ _4842_/A _5718_/B _4258_/B _4255_/X vssd1 vssd1 vccd1 vccd1 _4261_/B sky130_fd_sc_hd__a31o_1
XANTENNA__4518__C _4551_/D vssd1 vssd1 vccd1 vccd1 sky130_fd_sc_hd__diode_2
XTAP_1104 vssd1 vccd1 sky130_fd_sc_hd__tapvpwrvgnd_1
XTAP_1137 vssd1 vccd1 sky130_fd_sc_hd__tapvpwrvgnd_1
XTAP_1126 vssd1 vccd1 sky130_fd_sc_hd__tapvpwrvgnd_1
XTAP_1115 vssd1 vccd1 sky130_fd_sc_hd__tapvpwrvgnd_1
XTAP_1159 vssd1 vccd1 sky130_fd_sc_hd__tapvpwrvgnd_1
XTAP_1148 vssd1 vccd1 sky130_fd_sc_hd__tapvpwrvgnd_1
XFILLER_0_37_303 vssd1 vssd1 vccd1 vccd1 sky130_fd_sc_hd__decap_6
XANTENNA_fanout6_A _5919_/B vssd1 vssd1 vccd1 vccd1 sky130_fd_sc_hd__diode_2
XFILLER_0_20_214 vssd1 vssd1 vccd1 vccd1 sky130_fd_sc_hd__decap_8
XANTENNA__3498__A2 _5273_/B vssd1 vssd1 vccd1 vccd1 sky130_fd_sc_hd__diode_2
XANTENNA__6723__SET_B fanout145/X vssd1 vssd1 vccd1 vccd1 sky130_fd_sc_hd__diode_2
XANTENNA__3388__A1_N _5299_/A vssd1 vssd1 vccd1 vccd1 sky130_fd_sc_hd__diode_2
XFILLER_0_18_15 vssd1 vssd1 vccd1 vccd1 sky130_ef_sc_hd__decap_12
XANTENNA__6436__A2 _6440_/B vssd1 vssd1 vccd1 vccd1 sky130_fd_sc_hd__diode_2
XFILLER_0_18_37 vssd1 vssd1 vccd1 vccd1 sky130_fd_sc_hd__fill_2
XFILLER_0_87_203 vssd1 vssd1 vccd1 vccd1 sky130_ef_sc_hd__decap_12
XFILLER_0_87_225 vssd1 vssd1 vccd1 vccd1 sky130_fd_sc_hd__decap_3
XFILLER_0_87_247 vssd1 vssd1 vccd1 vccd1 sky130_fd_sc_hd__decap_8
XFILLER_0_55_111 vssd1 vssd1 vccd1 vccd1 sky130_fd_sc_hd__fill_1
XFILLER_0_138_393 vssd1 vssd1 vccd1 vccd1 sky130_ef_sc_hd__decap_12
XANTENNA__6372__A1 hold53/A vssd1 vssd1 vccd1 vccd1 sky130_fd_sc_hd__diode_2
XFILLER_0_70_114 vssd1 vssd1 vccd1 vccd1 sky130_fd_sc_hd__decap_3
X_3630_ _3628_/X _3630_/B vssd1 vssd1 vccd1 vccd1 _3707_/A sky130_fd_sc_hd__nand2b_1
X_3561_ _3561_/A _3561_/B vssd1 vssd1 vccd1 vccd1 _3563_/B sky130_fd_sc_hd__xnor2_1
X_5300_ _5300_/A _5300_/B vssd1 vssd1 vccd1 vccd1 _5301_/B sky130_fd_sc_hd__nand2_1
XANTENNA__5990__S _6037_/S vssd1 vssd1 vccd1 vccd1 sky130_fd_sc_hd__diode_2
XFILLER_0_51_383 vssd1 vssd1 vccd1 vccd1 sky130_fd_sc_hd__decap_8
X_6280_ _3299_/Y _6860_/Q _3298_/Y depth_mport_i[28] vssd1 vssd1 vccd1 vccd1 _6283_/B
+ sky130_fd_sc_hd__a2bb2o_1
XFILLER_0_11_225 vssd1 vssd1 vccd1 vccd1 sky130_fd_sc_hd__decap_6
X_3492_ _3492_/A _3492_/B vssd1 vssd1 vccd1 vccd1 _3563_/A sky130_fd_sc_hd__nor2_1
XANTENNA__6387__A hold53/A vssd1 vssd1 vccd1 vccd1 sky130_fd_sc_hd__diode_2
X_5231_ _5229_/A _5234_/A _5201_/B _5224_/X vssd1 vssd1 vccd1 vccd1 _5232_/B sky130_fd_sc_hd__a211o_1
XFILLER_0_59_88 vssd1 vssd1 vccd1 vccd1 sky130_fd_sc_hd__fill_2
X_5162_ _5148_/Y _5149_/X _5160_/B _5160_/Y vssd1 vssd1 vccd1 vccd1 _5164_/C sky130_fd_sc_hd__o211a_1
XANTENNA__4619__B _4658_/D vssd1 vssd1 vccd1 vccd1 sky130_fd_sc_hd__diode_2
X_4113_ tex_width_i[6] _4433_/D _4774_/B _5687_/A vssd1 vssd1 vccd1 vccd1 _4114_/C
+ sky130_fd_sc_hd__a22o_1
X_5093_ _5093_/A _5273_/B vssd1 vssd1 vccd1 vccd1 _5094_/B sky130_fd_sc_hd__nand2_1
X_4044_ _5311_/A _4774_/B vssd1 vssd1 vccd1 vccd1 _4047_/A sky130_fd_sc_hd__and2_1
XPHY_209 vssd1 vssd1 vccd1 vccd1 sky130_fd_sc_hd__decap_3
XFILLER_0_93_206 vssd1 vssd1 vccd1 vccd1 sky130_fd_sc_hd__decap_6
XFILLER_0_19_314 vssd1 vssd1 vccd1 vccd1 sky130_fd_sc_hd__fill_2
X_5995_ tex_height_i[5] _5994_/C tex_height_i[6] vssd1 vssd1 vccd1 vccd1 _5996_/B
+ sky130_fd_sc_hd__o21ai_1
XFILLER_0_86_291 vssd1 vssd1 vccd1 vccd1 sky130_fd_sc_hd__fill_2
XFILLER_0_19_325 vssd1 vssd1 vccd1 vccd1 sky130_fd_sc_hd__fill_2
X_4946_ _4796_/A _4796_/C _4796_/B vssd1 vssd1 vccd1 vccd1 _4947_/C sky130_fd_sc_hd__a21bo_1
XFILLER_0_129_393 vssd1 vssd1 vccd1 vccd1 sky130_ef_sc_hd__decap_12
XFILLER_0_34_306 vssd1 vssd1 vccd1 vccd1 sky130_fd_sc_hd__fill_2
X_4877_ _4877_/A _4877_/B vssd1 vssd1 vccd1 vccd1 _4880_/B sky130_fd_sc_hd__xor2_2
XANTENNA__6061__S _6061_/S vssd1 vssd1 vccd1 vccd1 sky130_fd_sc_hd__diode_2
X_6616_ _6732_/CLK _6616_/D fanout142/X vssd1 vssd1 vccd1 vccd1 tex_mport_o[59] sky130_fd_sc_hd__dfrtp_4
X_3828_ _5093_/A _5296_/B _3826_/Y _3827_/X vssd1 vssd1 vccd1 vccd1 _3830_/A sky130_fd_sc_hd__o2bb2a_1
X_6547_ _6864_/CLK _6547_/D vssd1 vssd1 vccd1 vccd1 hold87/A sky130_fd_sc_hd__dfxtp_1
XFILLER_0_27_391 vssd1 vssd1 vccd1 vccd1 sky130_fd_sc_hd__fill_1
XFILLER_0_61_169 vssd1 vssd1 vccd1 vccd1 sky130_fd_sc_hd__fill_2
X_3759_ _3758_/A _3758_/Y _3678_/Y _3704_/X vssd1 vssd1 vccd1 vccd1 _3771_/A sky130_fd_sc_hd__o211a_1
X_6478_ hold133/X sstream_i[36] _6493_/S vssd1 vssd1 vccd1 vccd1 _6869_/D sky130_fd_sc_hd__mux2_1
X_5429_ _5427_/X _5428_/Y _5423_/Y _5424_/X vssd1 vssd1 vccd1 vccd1 _5429_/X sky130_fd_sc_hd__a211o_1
XFILLER_0_69_225 vssd1 vssd1 vccd1 vccd1 sky130_fd_sc_hd__fill_2
XFILLER_0_69_214 vssd1 vssd1 vccd1 vccd1 sky130_fd_sc_hd__fill_2
XFILLER_0_37_111 vssd1 vssd1 vccd1 vccd1 sky130_fd_sc_hd__fill_1
XFILLER_0_92_261 vssd1 vssd1 vccd1 vccd1 sky130_fd_sc_hd__decap_6
XFILLER_0_92_250 vssd1 vssd1 vccd1 vccd1 sky130_fd_sc_hd__fill_2
XFILLER_0_25_328 vssd1 vssd1 vccd1 vccd1 sky130_fd_sc_hd__fill_2
XFILLER_0_20_27 vssd1 vssd1 vccd1 vccd1 sky130_fd_sc_hd__fill_1
XFILLER_0_40_309 vssd1 vssd1 vccd1 vccd1 sky130_fd_sc_hd__fill_2
XANTENNA_clkbuf_leaf_1_clk_i_A clkbuf_leaf_1_clk_i/A vssd1 vssd1 vccd1 vccd1 sky130_fd_sc_hd__diode_2
XFILLER_0_52_136 vssd1 vssd1 vccd1 vccd1 sky130_fd_sc_hd__fill_2
XANTENNA__5823__B _5919_/B vssd1 vssd1 vccd1 vccd1 sky130_fd_sc_hd__diode_2
XTAP_707 vssd1 vccd1 sky130_fd_sc_hd__tapvpwrvgnd_1
XTAP_729 vssd1 vccd1 sky130_fd_sc_hd__tapvpwrvgnd_1
XFILLER_0_29_47 vssd1 vssd1 vccd1 vccd1 sky130_fd_sc_hd__decap_3
XANTENNA__5865__B1 _5882_/B vssd1 vssd1 vccd1 vccd1 sky130_fd_sc_hd__diode_2
XTAP_718 vssd1 vccd1 sky130_fd_sc_hd__tapvpwrvgnd_1
XANTENNA__6409__A2 hold7/A vssd1 vssd1 vccd1 vccd1 sky130_fd_sc_hd__diode_2
XANTENNA__3343__B _5276_/A vssd1 vssd1 vccd1 vccd1 sky130_fd_sc_hd__diode_2
XFILLER_0_0_15 vssd1 vssd1 vccd1 vccd1 sky130_ef_sc_hd__decap_12
XANTENNA__5985__S _6037_/S vssd1 vssd1 vccd1 vccd1 sky130_fd_sc_hd__diode_2
X_4800_ _4800_/A _4800_/B _4800_/C vssd1 vssd1 vccd1 vccd1 _4802_/B sky130_fd_sc_hd__nand3_1
XANTENNA__4174__B _4476_/D vssd1 vssd1 vccd1 vccd1 sky130_fd_sc_hd__diode_2
XFILLER_0_131_3 vssd1 vssd1 vccd1 vccd1 sky130_fd_sc_hd__fill_2
XFILLER_0_118_319 vssd1 vssd1 vccd1 vccd1 sky130_fd_sc_hd__fill_1
X_5780_ tex_addr_i[13] _5780_/B vssd1 vssd1 vccd1 vccd1 _5781_/B sky130_fd_sc_hd__or2_1
XFILLER_0_61_67 vssd1 vssd1 vccd1 vccd1 sky130_fd_sc_hd__fill_2
XFILLER_0_83_250 vssd1 vssd1 vccd1 vccd1 sky130_ef_sc_hd__decap_12
X_4731_ _4731_/A _4731_/B vssd1 vssd1 vccd1 vccd1 _4877_/A sky130_fd_sc_hd__nand2_1
XFILLER_0_16_306 vssd1 vssd1 vccd1 vccd1 sky130_fd_sc_hd__fill_2
X_4662_ _4662_/A _4678_/A vssd1 vssd1 vccd1 vccd1 _4674_/B sky130_fd_sc_hd__xor2_2
XANTENNA__5286__A _5286_/A vssd1 vssd1 vccd1 vccd1 sky130_fd_sc_hd__diode_2
X_6401_ _6408_/A _6401_/B vssd1 vssd1 vccd1 vccd1 _6402_/B sky130_fd_sc_hd__nand2_1
XFILLER_0_9_57 vssd1 vssd1 vccd1 vccd1 sky130_ef_sc_hd__decap_12
X_3613_ _3612_/A _3612_/Y _3587_/C _3590_/Y vssd1 vssd1 vccd1 vccd1 _3620_/B sky130_fd_sc_hd__o211a_1
XFILLER_0_31_309 vssd1 vssd1 vccd1 vccd1 sky130_fd_sc_hd__decap_3
X_4593_ _5656_/A _4637_/D _4582_/X _4583_/Y vssd1 vssd1 vccd1 vccd1 _4594_/C sky130_fd_sc_hd__o2bb2a_1
XFILLER_0_43_169 vssd1 vssd1 vccd1 vccd1 sky130_fd_sc_hd__decap_4
X_6332_ hold181/X depth_mport_o[37] _6333_/S vssd1 vssd1 vccd1 vccd1 _6815_/D sky130_fd_sc_hd__mux2_1
X_3544_ _3544_/A _3544_/B vssd1 vssd1 vccd1 vccd1 _3557_/A sky130_fd_sc_hd__xor2_1
XFILLER_0_24_394 vssd1 vssd1 vccd1 vccd1 sky130_ef_sc_hd__decap_12
XFILLER_0_51_191 vssd1 vssd1 vccd1 vccd1 sky130_fd_sc_hd__fill_2
X_6263_ _3324_/Y depth_mport_i[4] depth_mport_i[3] _3325_/Y _6262_/X vssd1 vssd1 vccd1
+ vccd1 _6263_/X sky130_fd_sc_hd__a221o_1
X_3475_ _6692_/Q _3474_/X _3473_/X vssd1 vssd1 vccd1 vccd1 _3477_/A sky130_fd_sc_hd__a21bo_1
X_5214_ _5215_/A _5215_/B _5215_/C vssd1 vssd1 vccd1 vccd1 _5214_/Y sky130_fd_sc_hd__nor3_1
X_6194_ fb_i _6194_/B vssd1 vssd1 vccd1 vccd1 _6194_/Y sky130_fd_sc_hd__nor2_1
X_5145_ _5145_/A _5145_/B _5145_/C vssd1 vssd1 vccd1 vccd1 _5145_/X sky130_fd_sc_hd__or3_2
XFILLER_0_98_309 vssd1 vssd1 vccd1 vccd1 sky130_fd_sc_hd__fill_2
X_5076_ _5076_/A _5076_/B vssd1 vssd1 vccd1 vccd1 _5175_/B sky130_fd_sc_hd__xor2_1
XANTENNA__6056__S _6072_/S vssd1 vssd1 vccd1 vccd1 sky130_fd_sc_hd__diode_2
X_4027_ _4842_/A _5732_/A _4814_/D _4582_/D vssd1 vssd1 vccd1 vccd1 _4028_/D sky130_fd_sc_hd__a22o_1
XFILLER_0_126_70 vssd1 vssd1 vccd1 vccd1 sky130_fd_sc_hd__fill_2
XANTENNA__4084__B _4776_/A vssd1 vssd1 vccd1 vccd1 sky130_fd_sc_hd__diode_2
XFILLER_0_66_239 vssd1 vssd1 vccd1 vccd1 sky130_fd_sc_hd__fill_2
X_5978_ _5978_/A _5982_/B vssd1 vssd1 vccd1 vccd1 _5978_/Y sky130_fd_sc_hd__nand2_1
XFILLER_0_81_209 vssd1 vssd1 vccd1 vccd1 sky130_fd_sc_hd__decap_4
XFILLER_0_19_155 vssd1 vssd1 vccd1 vccd1 sky130_fd_sc_hd__fill_2
X_4929_ _4929_/A _4929_/B vssd1 vssd1 vccd1 vccd1 _4931_/B sky130_fd_sc_hd__xnor2_1
XANTENNA__6336__A1 hold75/X vssd1 vssd1 vccd1 vccd1 sky130_fd_sc_hd__diode_2
XFILLER_0_19_199 vssd1 vssd1 vccd1 vccd1 sky130_fd_sc_hd__fill_1
XFILLER_0_22_309 vssd1 vssd1 vccd1 vccd1 sky130_fd_sc_hd__fill_2
XFILLER_0_30_331 vssd1 vssd1 vccd1 vccd1 sky130_fd_sc_hd__fill_1
XFILLER_0_42_180 vssd1 vssd1 vccd1 vccd1 sky130_fd_sc_hd__fill_1
XFILLER_0_30_342 vssd1 vssd1 vccd1 vccd1 sky130_fd_sc_hd__fill_2
XFILLER_0_30_386 vssd1 vssd1 vccd1 vccd1 sky130_ef_sc_hd__decap_12
XANTENNA__5081__D _5081_/D vssd1 vssd1 vccd1 vccd1 sky130_fd_sc_hd__diode_2
XANTENNA__4275__A _4432_/A vssd1 vssd1 vccd1 vccd1 sky130_fd_sc_hd__diode_2
XFILLER_0_106_29 vssd1 vssd1 vccd1 vccd1 sky130_fd_sc_hd__decap_4
XFILLER_0_15_27 vssd1 vssd1 vccd1 vccd1 sky130_ef_sc_hd__decap_12
XFILLER_0_97_386 vssd1 vssd1 vccd1 vccd1 sky130_fd_sc_hd__decap_6
XANTENNA__6024__A0 _5081_/B vssd1 vssd1 vccd1 vccd1 sky130_fd_sc_hd__diode_2
XFILLER_0_57_217 vssd1 vssd1 vccd1 vccd1 sky130_fd_sc_hd__fill_2
XFILLER_0_57_239 vssd1 vssd1 vccd1 vccd1 sky130_fd_sc_hd__fill_2
XFILLER_0_31_15 vssd1 vssd1 vccd1 vccd1 sky130_fd_sc_hd__fill_2
XANTENNA__5818__B _5919_/B vssd1 vssd1 vccd1 vccd1 sky130_fd_sc_hd__diode_2
XFILLER_0_108_341 vssd1 vssd1 vccd1 vccd1 sky130_fd_sc_hd__fill_2
XFILLER_0_65_272 vssd1 vssd1 vccd1 vccd1 sky130_fd_sc_hd__decap_3
XFILLER_0_108_363 vssd1 vssd1 vccd1 vccd1 sky130_fd_sc_hd__fill_1
XFILLER_0_80_231 vssd1 vssd1 vccd1 vccd1 sky130_fd_sc_hd__fill_2
XFILLER_0_25_136 vssd1 vssd1 vccd1 vccd1 sky130_fd_sc_hd__decap_3
XFILLER_0_80_275 vssd1 vssd1 vccd1 vccd1 sky130_ef_sc_hd__decap_12
XFILLER_0_40_139 vssd1 vssd1 vccd1 vccd1 sky130_fd_sc_hd__fill_1
XTAP_504 vssd1 vccd1 sky130_fd_sc_hd__tapvpwrvgnd_1
XTAP_515 vssd1 vccd1 sky130_fd_sc_hd__tapvpwrvgnd_1
XTAP_526 vssd1 vccd1 sky130_fd_sc_hd__tapvpwrvgnd_1
XTAP_537 vssd1 vccd1 sky130_fd_sc_hd__tapvpwrvgnd_1
XTAP_548 vssd1 vccd1 sky130_fd_sc_hd__tapvpwrvgnd_1
X_3260_ _6745_/Q vssd1 vssd1 vccd1 vccd1 _3260_/Y sky130_fd_sc_hd__inv_2
XTAP_559 vssd1 vccd1 sky130_fd_sc_hd__tapvpwrvgnd_1
XFILLER_0_56_56 vssd1 vssd1 vccd1 vccd1 sky130_fd_sc_hd__fill_2
XANTENNA__3864__A2 _5286_/A vssd1 vssd1 vccd1 vccd1 sky130_fd_sc_hd__diode_2
X_6950_ vssd1 vssd1 vccd1 vccd1 _6950_/HI tex_mport_o[3] sky130_fd_sc_hd__conb_1
X_5901_ _5878_/A _5887_/A _5900_/X _5899_/Y vssd1 vssd1 vccd1 vccd1 _5902_/B sky130_fd_sc_hd__o31a_1
XFILLER_0_48_206 vssd1 vssd1 vccd1 vccd1 sky130_fd_sc_hd__fill_2
X_6881_ _6892_/CLK _6881_/D vssd1 vssd1 vccd1 vccd1 hold97/A sky130_fd_sc_hd__dfxtp_1
X_5832_ tex_addr_i[18] _5919_/B _5827_/Y vssd1 vssd1 vccd1 vccd1 _5833_/B sky130_fd_sc_hd__a21o_1
X_5763_ _5784_/S _5772_/B _5761_/X _5762_/Y vssd1 vssd1 vccd1 vccd1 _5763_/X sky130_fd_sc_hd__a31o_1
X_4714_ _4714_/A _4714_/B vssd1 vssd1 vccd1 vccd1 _4714_/Y sky130_fd_sc_hd__nand2_1
XFILLER_0_126_160 vssd1 vssd1 vccd1 vccd1 sky130_fd_sc_hd__fill_1
X_5694_ _5695_/A _5695_/B _5695_/C _5695_/D vssd1 vssd1 vccd1 vccd1 _5694_/X sky130_fd_sc_hd__o22a_1
XFILLER_0_16_158 vssd1 vssd1 vccd1 vccd1 sky130_fd_sc_hd__fill_1
XFILLER_0_126_193 vssd1 vssd1 vccd1 vccd1 sky130_fd_sc_hd__decap_3
XFILLER_0_114_344 vssd1 vssd1 vccd1 vccd1 sky130_fd_sc_hd__fill_2
XFILLER_0_114_322 vssd1 vssd1 vccd1 vccd1 sky130_fd_sc_hd__fill_2
XFILLER_0_112_83 vssd1 vssd1 vccd1 vccd1 sky130_fd_sc_hd__fill_1
XFILLER_0_112_72 vssd1 vssd1 vccd1 vccd1 sky130_fd_sc_hd__fill_2
X_4645_ _6624_/Q _4656_/B _4643_/X vssd1 vssd1 vccd1 vccd1 _4650_/B sky130_fd_sc_hd__a21oi_2
X_4576_ _4574_/A _4574_/B _4603_/A vssd1 vssd1 vccd1 vccd1 _4576_/X sky130_fd_sc_hd__o21a_1
XFILLER_0_12_320 vssd1 vssd1 vccd1 vccd1 sky130_fd_sc_hd__fill_2
X_6315_ hold86/X hold67/X _6315_/S vssd1 vssd1 vccd1 vccd1 _6798_/D sky130_fd_sc_hd__mux2_1
X_3527_ _3527_/A _3527_/B vssd1 vssd1 vccd1 vccd1 _3540_/A sky130_fd_sc_hd__xnor2_1
XANTENNA__5829__B1 _5599_/A vssd1 vssd1 vccd1 vccd1 sky130_fd_sc_hd__diode_2
X_6246_ depth_mport_i[14] _3314_/Y _6244_/X vssd1 vssd1 vccd1 vccd1 _6246_/Y sky130_fd_sc_hd__a21oi_1
X_3458_ _5277_/A _5308_/A _5273_/A _5272_/A vssd1 vssd1 vccd1 vccd1 _3462_/A sky130_fd_sc_hd__and4_1
X_6177_ _6789_/Q _6791_/Q vssd1 vssd1 vccd1 vccd1 _6190_/A sky130_fd_sc_hd__nand2_1
X_3389_ _3387_/X _6687_/Q _5299_/A _3389_/D vssd1 vssd1 vccd1 vccd1 _3390_/B sky130_fd_sc_hd__and4b_1
X_5128_ _5127_/A _5127_/C _5127_/B vssd1 vssd1 vccd1 vccd1 _5128_/Y sky130_fd_sc_hd__a21oi_1
XANTENNA__6254__B1 _6841_/Q vssd1 vssd1 vccd1 vccd1 sky130_fd_sc_hd__diode_2
X_5059_ _4949_/A _5059_/B vssd1 vssd1 vccd1 vccd1 _5061_/B sky130_fd_sc_hd__nand2b_1
XANTENNA__6627__SET_B fanout145/X vssd1 vssd1 vccd1 vccd1 sky130_fd_sc_hd__diode_2
XFILLER_0_79_375 vssd1 vssd1 vccd1 vccd1 sky130_ef_sc_hd__decap_12
XANTENNA__6006__A0 _5115_/C vssd1 vssd1 vccd1 vccd1 sky130_fd_sc_hd__diode_2
XFILLER_0_39_206 vssd1 vssd1 vccd1 vccd1 sky130_fd_sc_hd__fill_2
XFILLER_0_94_345 vssd1 vssd1 vccd1 vccd1 sky130_fd_sc_hd__fill_1
XFILLER_0_39_228 vssd1 vssd1 vccd1 vccd1 sky130_ef_sc_hd__decap_12
XFILLER_0_94_389 vssd1 vssd1 vccd1 vccd1 sky130_ef_sc_hd__decap_12
XFILLER_0_62_253 vssd1 vssd1 vccd1 vccd1 sky130_fd_sc_hd__fill_1
XFILLER_0_22_106 vssd1 vssd1 vccd1 vccd1 sky130_fd_sc_hd__fill_2
XFILLER_0_132_163 vssd1 vssd1 vccd1 vccd1 sky130_fd_sc_hd__fill_1
XFILLER_0_132_141 vssd1 vssd1 vccd1 vccd1 sky130_fd_sc_hd__fill_1
XFILLER_0_62_297 vssd1 vssd1 vccd1 vccd1 sky130_fd_sc_hd__fill_1
XANTENNA_clkbuf_leaf_27_clk_i_A clkbuf_leaf_1_clk_i/A vssd1 vssd1 vccd1 vccd1 sky130_fd_sc_hd__diode_2
XFILLER_0_22_139 vssd1 vssd1 vccd1 vccd1 sky130_fd_sc_hd__fill_1
XFILLER_0_30_194 vssd1 vssd1 vccd1 vccd1 sky130_fd_sc_hd__fill_2
XFILLER_0_26_15 vssd1 vssd1 vccd1 vccd1 sky130_fd_sc_hd__decap_8
Xhold82 hold82/A vssd1 vssd1 vccd1 vccd1 hold82/X sky130_fd_sc_hd__dlygate4sd3_1
Xhold71 hold71/A vssd1 vssd1 vccd1 vccd1 hold71/X sky130_fd_sc_hd__dlygate4sd3_1
Xhold60 hold60/A vssd1 vssd1 vccd1 vccd1 hold60/X sky130_fd_sc_hd__dlygate4sd3_1
XANTENNA__4717__B _5049_/D vssd1 vssd1 vccd1 vccd1 sky130_fd_sc_hd__diode_2
Xhold93 hold93/A vssd1 vssd1 vccd1 vccd1 hold93/X sky130_fd_sc_hd__dlygate4sd3_1
XFILLER_0_89_139 vssd1 vssd1 vccd1 vccd1 sky130_fd_sc_hd__fill_1
XFILLER_0_97_150 vssd1 vssd1 vccd1 vccd1 sky130_ef_sc_hd__decap_12
XFILLER_0_97_194 vssd1 vssd1 vccd1 vccd1 sky130_fd_sc_hd__fill_1
XFILLER_0_85_378 vssd1 vssd1 vccd1 vccd1 sky130_ef_sc_hd__decap_12
XFILLER_0_42_58 vssd1 vssd1 vccd1 vccd1 sky130_fd_sc_hd__decap_3
XFILLER_0_38_250 vssd1 vssd1 vccd1 vccd1 sky130_fd_sc_hd__fill_2
XFILLER_0_38_261 vssd1 vssd1 vccd1 vccd1 sky130_fd_sc_hd__decap_3
XANTENNA__4171__C _4966_/C vssd1 vssd1 vccd1 vccd1 sky130_fd_sc_hd__diode_2
XFILLER_0_53_220 vssd1 vssd1 vccd1 vccd1 sky130_fd_sc_hd__fill_2
XFILLER_0_53_242 vssd1 vssd1 vccd1 vccd1 sky130_fd_sc_hd__decap_8
XFILLER_0_13_106 vssd1 vssd1 vccd1 vccd1 sky130_fd_sc_hd__decap_4
X_4430_ _4429_/B _4429_/C _4429_/A vssd1 vssd1 vccd1 vccd1 _4431_/C sky130_fd_sc_hd__a21bo_1
XFILLER_0_13_139 vssd1 vssd1 vccd1 vccd1 sky130_fd_sc_hd__fill_2
XFILLER_0_13_117 vssd1 vssd1 vccd1 vccd1 sky130_fd_sc_hd__fill_1
XANTENNA_2 filt_depth_fly_o vssd1 vssd1 vccd1 vccd1 sky130_fd_sc_hd__diode_2
XFILLER_0_111_369 vssd1 vssd1 vccd1 vccd1 sky130_ef_sc_hd__decap_12
X_4361_ _4362_/A _4362_/B _4362_/C vssd1 vssd1 vccd1 vccd1 _4361_/Y sky130_fd_sc_hd__nor3_1
XFILLER_0_67_22 vssd1 vssd1 vccd1 vccd1 sky130_fd_sc_hd__fill_1
X_6100_ _6639_/Q hold272/X _6113_/S vssd1 vssd1 vccd1 vccd1 _6100_/X sky130_fd_sc_hd__mux2_1
X_3312_ depth_mport_i[16] vssd1 vssd1 vccd1 vccd1 _6275_/B sky130_fd_sc_hd__inv_2
X_4292_ _4292_/A _4292_/B vssd1 vssd1 vccd1 vccd1 _4354_/B sky130_fd_sc_hd__xnor2_1
XTAP_323 vssd1 vccd1 sky130_fd_sc_hd__tapvpwrvgnd_1
XTAP_301 vssd1 vccd1 sky130_fd_sc_hd__tapvpwrvgnd_1
XTAP_312 vssd1 vccd1 sky130_fd_sc_hd__tapvpwrvgnd_1
X_6031_ tex_height_i[14] _6031_/B vssd1 vssd1 vccd1 vccd1 _6038_/D sky130_fd_sc_hd__or2_2
XTAP_367 vssd1 vccd1 sky130_fd_sc_hd__tapvpwrvgnd_1
XTAP_356 vssd1 vccd1 sky130_fd_sc_hd__tapvpwrvgnd_1
XTAP_345 vssd1 vccd1 sky130_fd_sc_hd__tapvpwrvgnd_1
XTAP_334 vssd1 vccd1 sky130_fd_sc_hd__tapvpwrvgnd_1
XTAP_389 vssd1 vccd1 sky130_fd_sc_hd__tapvpwrvgnd_1
XTAP_378 vssd1 vccd1 sky130_fd_sc_hd__tapvpwrvgnd_1
XFILLER_0_83_21 vssd1 vssd1 vccd1 vccd1 sky130_fd_sc_hd__fill_1
X_6933_ vssd1 vssd1 vccd1 vccd1 _6933_/HI pix_mport_o[53] sky130_fd_sc_hd__conb_1
XFILLER_0_107_61 vssd1 vssd1 vccd1 vccd1 sky130_fd_sc_hd__decap_3
XFILLER_0_16_70 vssd1 vssd1 vccd1 vccd1 sky130_fd_sc_hd__fill_1
XPHY_29 vssd1 vssd1 vccd1 vccd1 sky130_fd_sc_hd__decap_3
XPHY_18 vssd1 vssd1 vccd1 vccd1 sky130_fd_sc_hd__decap_3
XANTENNA__6334__S _6440_/B vssd1 vssd1 vccd1 vccd1 sky130_fd_sc_hd__diode_2
X_6864_ _6864_/CLK _6864_/D vssd1 vssd1 vccd1 vccd1 _6864_/Q sky130_fd_sc_hd__dfxtp_1
XANTENNA__4643__A _5666_/A vssd1 vssd1 vccd1 vccd1 sky130_fd_sc_hd__diode_2
XFILLER_0_76_334 vssd1 vssd1 vccd1 vccd1 sky130_fd_sc_hd__fill_1
XFILLER_0_76_378 vssd1 vssd1 vccd1 vccd1 sky130_ef_sc_hd__decap_12
X_5815_ _5824_/A _5825_/A _5922_/S vssd1 vssd1 vccd1 vccd1 _5815_/X sky130_fd_sc_hd__o21a_1
X_6795_ _6863_/CLK _6795_/D vssd1 vssd1 vccd1 vccd1 hold17/A sky130_fd_sc_hd__dfxtp_1
XFILLER_0_91_337 vssd1 vssd1 vccd1 vccd1 sky130_ef_sc_hd__decap_12
XFILLER_0_91_326 vssd1 vssd1 vccd1 vccd1 sky130_fd_sc_hd__decap_4
X_5746_ tex_addr_i[10] _5746_/B vssd1 vssd1 vccd1 vccd1 _5747_/B sky130_fd_sc_hd__nor2_1
XFILLER_0_32_80 vssd1 vssd1 vccd1 vccd1 sky130_fd_sc_hd__fill_2
X_5677_ _5687_/B _5687_/C vssd1 vssd1 vccd1 vccd1 _5677_/Y sky130_fd_sc_hd__xnor2_1
XFILLER_0_44_253 vssd1 vssd1 vccd1 vccd1 sky130_fd_sc_hd__fill_2
X_4628_ _4628_/A _4628_/B vssd1 vssd1 vccd1 vccd1 _4633_/B sky130_fd_sc_hd__xnor2_1
XFILLER_0_4_361 vssd1 vssd1 vccd1 vccd1 sky130_fd_sc_hd__decap_3
X_4559_ _6627_/Q _4596_/B _4557_/X vssd1 vssd1 vccd1 vccd1 _4571_/A sky130_fd_sc_hd__a21o_1
XFILLER_0_12_161 vssd1 vssd1 vccd1 vccd1 sky130_fd_sc_hd__decap_4
XFILLER_0_12_183 vssd1 vssd1 vccd1 vccd1 sky130_fd_sc_hd__fill_2
X_6229_ _5524_/B _6231_/B hold204/X vssd1 vssd1 vccd1 vccd1 _6229_/X sky130_fd_sc_hd__a21o_1
XTAP_890 vssd1 vccd1 sky130_fd_sc_hd__tapvpwrvgnd_1
XFILLER_0_94_131 vssd1 vssd1 vccd1 vccd1 sky130_fd_sc_hd__decap_3
XFILLER_0_137_266 vssd1 vssd1 vccd1 vccd1 sky130_fd_sc_hd__decap_3
XFILLER_0_94_197 vssd1 vssd1 vccd1 vccd1 sky130_fd_sc_hd__decap_4
XFILLER_0_35_297 vssd1 vssd1 vccd1 vccd1 sky130_fd_sc_hd__fill_2
XFILLER_0_120_144 vssd1 vssd1 vccd1 vccd1 sky130_fd_sc_hd__fill_2
XFILLER_0_10_109 vssd1 vssd1 vccd1 vccd1 sky130_ef_sc_hd__decap_12
XANTENNA__6466__A0 hold117/X vssd1 vssd1 vccd1 vccd1 sky130_fd_sc_hd__diode_2
XFILLER_0_37_14 vssd1 vssd1 vccd1 vccd1 sky130_fd_sc_hd__fill_2
XANTENNA__5831__B _5919_/B vssd1 vssd1 vccd1 vccd1 sky130_fd_sc_hd__diode_2
XANTENNA__4728__A _4774_/B vssd1 vssd1 vccd1 vccd1 sky130_fd_sc_hd__diode_2
XANTENNA__5559__A _5599_/A vssd1 vssd1 vccd1 vccd1 sky130_fd_sc_hd__diode_2
X_3930_ _3838_/Y _3905_/X _3927_/A _3927_/Y vssd1 vssd1 vccd1 vccd1 _3932_/C sky130_fd_sc_hd__a211oi_2
XFILLER_0_53_57 vssd1 vssd1 vccd1 vccd1 sky130_fd_sc_hd__fill_2
XFILLER_0_85_131 vssd1 vssd1 vccd1 vccd1 sky130_fd_sc_hd__decap_4
XFILLER_0_85_120 vssd1 vssd1 vccd1 vccd1 sky130_fd_sc_hd__fill_2
XFILLER_0_85_164 vssd1 vssd1 vccd1 vccd1 sky130_fd_sc_hd__fill_2
X_3861_ _5081_/A _5115_/B _5118_/B _5766_/A vssd1 vssd1 vccd1 vccd1 _3862_/B sky130_fd_sc_hd__a22o_1
XANTENNA__5993__S _6037_/S vssd1 vssd1 vccd1 vccd1 sky130_fd_sc_hd__diode_2
XANTENNA__4182__B _4822_/B vssd1 vssd1 vccd1 vccd1 sky130_fd_sc_hd__diode_2
X_6580_ _6812_/CLK _6580_/D _6320_/C vssd1 vssd1 vccd1 vccd1 depth_mport_o[24] sky130_fd_sc_hd__dfrtp_4
X_5600_ tex_mport_o[62] _5598_/S _5599_/X _5588_/C vssd1 vssd1 vccd1 vccd1 _6619_/D
+ sky130_fd_sc_hd__a22o_1
X_3792_ _3791_/A _3791_/B _3791_/C vssd1 vssd1 vccd1 vccd1 _3798_/B sky130_fd_sc_hd__a21o_1
X_5531_ depth_mport_o[6] hold119/X _5541_/S vssd1 vssd1 vccd1 vccd1 _6562_/D sky130_fd_sc_hd__mux2_1
XFILLER_0_5_125 vssd1 vssd1 vccd1 vccd1 sky130_ef_sc_hd__decap_12
XFILLER_0_26_275 vssd1 vssd1 vccd1 vccd1 sky130_fd_sc_hd__fill_2
X_5462_ tex_mport_i[32] hold71/A vssd1 vssd1 vccd1 vccd1 _6095_/S sky130_fd_sc_hd__nand2b_4
X_5393_ _6732_/Q _5393_/B vssd1 vssd1 vccd1 vccd1 _5393_/Y sky130_fd_sc_hd__xnor2_1
X_4413_ _4399_/A _4399_/C _4443_/A vssd1 vssd1 vccd1 vccd1 _4414_/C sky130_fd_sc_hd__a21oi_2
XFILLER_0_111_177 vssd1 vssd1 vccd1 vccd1 sky130_fd_sc_hd__decap_3
X_4344_ _4344_/A _4344_/B vssd1 vssd1 vccd1 vccd1 _4345_/C sky130_fd_sc_hd__xor2_1
XFILLER_0_1_386 vssd1 vssd1 vccd1 vccd1 sky130_fd_sc_hd__decap_6
XANTENNA__6329__S _6440_/B vssd1 vssd1 vccd1 vccd1 sky130_fd_sc_hd__diode_2
XANTENNA__4638__A _4638_/A vssd1 vssd1 vccd1 vccd1 sky130_fd_sc_hd__diode_2
X_4275_ _4432_/A _4774_/B vssd1 vssd1 vccd1 vccd1 _4276_/B sky130_fd_sc_hd__nand2_1
X_6014_ _5118_/B _6013_/X _6037_/S vssd1 vssd1 vccd1 vccd1 _6672_/D sky130_fd_sc_hd__mux2_1
XANTENNA__6064__S _6072_/S vssd1 vssd1 vccd1 vccd1 sky130_fd_sc_hd__diode_2
X_6916_ vssd1 vssd1 vccd1 vccd1 _6916_/HI pix_mport_o[17] sky130_fd_sc_hd__conb_1
XANTENNA__4373__A _5701_/A vssd1 vssd1 vccd1 vccd1 sky130_fd_sc_hd__diode_2
XFILLER_0_49_367 vssd1 vssd1 vccd1 vccd1 sky130_fd_sc_hd__fill_2
X_6847_ _6864_/CLK _6847_/D vssd1 vssd1 vccd1 vccd1 _6847_/Q sky130_fd_sc_hd__dfxtp_1
XFILLER_0_119_222 vssd1 vssd1 vccd1 vccd1 sky130_fd_sc_hd__fill_2
XANTENNA__4092__B _5754_/A vssd1 vssd1 vccd1 vccd1 sky130_fd_sc_hd__diode_2
XFILLER_0_49_389 vssd1 vssd1 vccd1 vccd1 sky130_fd_sc_hd__decap_3
X_6778_ _6830_/CLK _6778_/D fanout152/X vssd1 vssd1 vccd1 vccd1 pix_mport_o[50] sky130_fd_sc_hd__dfrtp_4
XFILLER_0_119_288 vssd1 vssd1 vccd1 vccd1 sky130_fd_sc_hd__fill_2
XFILLER_0_76_197 vssd1 vssd1 vccd1 vccd1 sky130_fd_sc_hd__fill_2
XFILLER_0_64_359 vssd1 vssd1 vccd1 vccd1 sky130_fd_sc_hd__fill_2
X_5729_ _5796_/A _5727_/Y _5728_/Y vssd1 vssd1 vccd1 vccd1 _5729_/Y sky130_fd_sc_hd__o21ai_1
XANTENNA__4943__B1 _5049_/D vssd1 vssd1 vccd1 vccd1 sky130_fd_sc_hd__diode_2
XANTENNA_hold117_A _6857_/Q vssd1 vssd1 vccd1 vccd1 sky130_fd_sc_hd__diode_2
XANTENNA__3717__A _3961_/A vssd1 vssd1 vccd1 vccd1 sky130_fd_sc_hd__diode_2
XFILLER_0_102_166 vssd1 vssd1 vccd1 vccd1 sky130_fd_sc_hd__fill_2
XANTENNA__4267__B _4518_/D vssd1 vssd1 vccd1 vccd1 sky130_fd_sc_hd__diode_2
XANTENNA__3682__B1 _3999_/A vssd1 vssd1 vccd1 vccd1 sky130_fd_sc_hd__diode_2
XFILLER_0_114_29 vssd1 vssd1 vccd1 vccd1 sky130_fd_sc_hd__fill_2
XFILLER_0_67_131 vssd1 vssd1 vccd1 vccd1 sky130_fd_sc_hd__fill_2
XFILLER_0_23_27 vssd1 vssd1 vccd1 vccd1 sky130_fd_sc_hd__decap_8
XANTENNA__4433__D _4433_/D vssd1 vssd1 vccd1 vccd1 sky130_fd_sc_hd__diode_2
XFILLER_0_55_337 vssd1 vssd1 vccd1 vccd1 sky130_fd_sc_hd__decap_4
XFILLER_0_125_225 vssd1 vssd1 vccd1 vccd1 sky130_fd_sc_hd__fill_1
XFILLER_0_23_223 vssd1 vssd1 vccd1 vccd1 sky130_fd_sc_hd__fill_1
XFILLER_0_2_139 vssd1 vssd1 vccd1 vccd1 sky130_fd_sc_hd__fill_1
XFILLER_0_23_289 vssd1 vssd1 vccd1 vccd1 sky130_fd_sc_hd__decap_3
XFILLER_0_48_46 vssd1 vssd1 vccd1 vccd1 sky130_fd_sc_hd__decap_4
X_4060_ _5701_/A _5687_/A _4551_/D _4970_/B vssd1 vssd1 vccd1 vccd1 _4063_/A sky130_fd_sc_hd__nand4_1
XFILLER_0_3_15 vssd1 vssd1 vccd1 vccd1 sky130_ef_sc_hd__decap_12
XANTENNA__4193__A _5787_/A vssd1 vssd1 vccd1 vccd1 sky130_fd_sc_hd__diode_2
X_4962_ _5086_/B _4962_/B vssd1 vssd1 vccd1 vccd1 _4963_/B sky130_fd_sc_hd__nand2_1
X_6701_ _6830_/CLK _6701_/D vssd1 vssd1 vccd1 vccd1 hold29/A sky130_fd_sc_hd__dfxtp_1
XFILLER_0_80_66 vssd1 vssd1 vccd1 vccd1 sky130_fd_sc_hd__decap_4
XFILLER_0_73_101 vssd1 vssd1 vccd1 vccd1 sky130_fd_sc_hd__fill_2
X_4893_ _4880_/A _4880_/C _4880_/B vssd1 vssd1 vccd1 vccd1 _4893_/Y sky130_fd_sc_hd__a21oi_2
X_3913_ _3912_/B _3912_/C _3912_/A vssd1 vssd1 vccd1 vccd1 _3914_/C sky130_fd_sc_hd__a21bo_1
XFILLER_0_104_62 vssd1 vssd1 vccd1 vccd1 sky130_fd_sc_hd__fill_2
X_6632_ _6732_/CLK _6632_/D fanout144/X vssd1 vssd1 vccd1 vccd1 _6632_/Q sky130_fd_sc_hd__dfstp_1
XFILLER_0_80_77 vssd1 vssd1 vccd1 vccd1 sky130_fd_sc_hd__fill_2
X_3844_ _6646_/Q _3894_/B vssd1 vssd1 vccd1 vccd1 _3895_/A sky130_fd_sc_hd__nand2_1
XFILLER_0_58_197 vssd1 vssd1 vccd1 vccd1 sky130_fd_sc_hd__decap_4
XANTENNA__3728__A1 _5320_/A vssd1 vssd1 vccd1 vccd1 sky130_fd_sc_hd__diode_2
X_6563_ _6853_/CLK _6563_/D _5468_/A vssd1 vssd1 vccd1 vccd1 depth_mport_o[7] sky130_fd_sc_hd__dfrtp_4
XFILLER_0_89_42 vssd1 vssd1 vccd1 vccd1 sky130_fd_sc_hd__fill_2
XFILLER_0_14_223 vssd1 vssd1 vccd1 vccd1 sky130_fd_sc_hd__decap_4
XFILLER_0_14_201 vssd1 vssd1 vccd1 vccd1 sky130_fd_sc_hd__fill_2
X_3775_ _3768_/A _3769_/A _3768_/B _3770_/B _3770_/A vssd1 vssd1 vccd1 vccd1 _3779_/B
+ sky130_fd_sc_hd__a32oi_4
X_5514_ hold87/X sstream_i[105] _6464_/S vssd1 vssd1 vccd1 vccd1 _6547_/D sky130_fd_sc_hd__mux2_1
XFILLER_0_89_53 vssd1 vssd1 vccd1 vccd1 sky130_fd_sc_hd__fill_1
X_6494_ hold107/X sstream_i[52] _6501_/S vssd1 vssd1 vccd1 vccd1 _6885_/D sky130_fd_sc_hd__mux2_1
XFILLER_0_124_280 vssd1 vssd1 vccd1 vccd1 sky130_fd_sc_hd__fill_2
X_5445_ _5445_/A _5445_/B _5445_/C vssd1 vssd1 vccd1 vccd1 _5449_/B sky130_fd_sc_hd__nand3_1
XFILLER_0_66_3 vssd1 vssd1 vccd1 vccd1 sky130_fd_sc_hd__decap_3
X_5376_ _5376_/A _5376_/B vssd1 vssd1 vccd1 vccd1 _5563_/B sky130_fd_sc_hd__xnor2_1
Xfanout103 _5106_/A vssd1 vssd1 vccd1 vccd1 _3999_/A sky130_fd_sc_hd__buf_4
Xfanout147 fanout149/X vssd1 vssd1 vccd1 vccd1 _5468_/A sky130_fd_sc_hd__clkbuf_8
XANTENNA__6059__S _6072_/S vssd1 vssd1 vccd1 vccd1 sky130_fd_sc_hd__diode_2
Xfanout136 _4789_/B vssd1 vssd1 vccd1 vccd1 _5645_/A sky130_fd_sc_hd__buf_4
X_4327_ _5701_/A _4614_/C _4582_/D tex_width_i[5] vssd1 vssd1 vccd1 vccd1 _4328_/C
+ sky130_fd_sc_hd__a22o_1
Xfanout114 _4789_/C vssd1 vssd1 vccd1 vccd1 _5645_/B sky130_fd_sc_hd__buf_4
Xfanout125 _5766_/A vssd1 vssd1 vccd1 vccd1 _4966_/A sky130_fd_sc_hd__buf_4
X_4258_ _4255_/X _4258_/B vssd1 vssd1 vccd1 vccd1 _4313_/B sky130_fd_sc_hd__and2b_1
XANTENNA__5653__A1 _5784_/S vssd1 vssd1 vccd1 vccd1 sky130_fd_sc_hd__diode_2
XANTENNA__4518__D _4518_/D vssd1 vssd1 vccd1 vccd1 sky130_fd_sc_hd__diode_2
XFILLER_0_96_204 vssd1 vssd1 vccd1 vccd1 sky130_fd_sc_hd__fill_1
X_4189_ _5801_/A _5787_/A _4527_/B _4841_/C vssd1 vssd1 vccd1 vccd1 _4191_/B sky130_fd_sc_hd__nand4_2
XTAP_1105 vssd1 vccd1 sky130_fd_sc_hd__tapvpwrvgnd_1
XTAP_1138 vssd1 vccd1 sky130_fd_sc_hd__tapvpwrvgnd_1
XTAP_1127 vssd1 vccd1 sky130_fd_sc_hd__tapvpwrvgnd_1
XTAP_1116 vssd1 vccd1 sky130_fd_sc_hd__tapvpwrvgnd_1
XFILLER_0_96_248 vssd1 vssd1 vccd1 vccd1 sky130_fd_sc_hd__decap_4
XTAP_1149 vssd1 vccd1 sky130_fd_sc_hd__tapvpwrvgnd_1
XFILLER_0_49_164 vssd1 vssd1 vccd1 vccd1 sky130_fd_sc_hd__fill_2
XFILLER_0_49_175 vssd1 vssd1 vccd1 vccd1 sky130_fd_sc_hd__fill_2
XFILLER_0_49_186 vssd1 vssd1 vccd1 vccd1 sky130_fd_sc_hd__decap_4
XFILLER_0_49_197 vssd1 vssd1 vccd1 vccd1 sky130_fd_sc_hd__fill_2
XFILLER_0_64_145 vssd1 vssd1 vccd1 vccd1 sky130_fd_sc_hd__fill_1
XFILLER_0_9_294 vssd1 vssd1 vccd1 vccd1 sky130_fd_sc_hd__fill_2
XFILLER_0_45_381 vssd1 vssd1 vccd1 vccd1 sky130_fd_sc_hd__decap_8
XFILLER_0_60_373 vssd1 vssd1 vccd1 vccd1 sky130_ef_sc_hd__decap_12
XANTENNA__4144__A1 _4476_/D vssd1 vssd1 vccd1 vccd1 sky130_fd_sc_hd__diode_2
Xhold190 _6874_/Q vssd1 vssd1 vccd1 vccd1 hold190/X sky130_fd_sc_hd__dlygate4sd3_1
XFILLER_0_18_27 vssd1 vssd1 vccd1 vccd1 sky130_fd_sc_hd__fill_1
XANTENNA__3910__A _5300_/A vssd1 vssd1 vccd1 vccd1 sky130_fd_sc_hd__diode_2
XANTENNA__5601__S _5601_/S vssd1 vssd1 vccd1 vccd1 sky130_fd_sc_hd__diode_2
XFILLER_0_87_237 vssd1 vssd1 vccd1 vccd1 sky130_fd_sc_hd__decap_4
XFILLER_0_87_215 vssd1 vssd1 vccd1 vccd1 sky130_fd_sc_hd__fill_1
XFILLER_0_34_15 vssd1 vssd1 vccd1 vccd1 sky130_fd_sc_hd__fill_2
XFILLER_0_50_14 vssd1 vssd1 vccd1 vccd1 sky130_fd_sc_hd__decap_3
XANTENNA__4741__A _4816_/A vssd1 vssd1 vccd1 vccd1 sky130_fd_sc_hd__diode_2
XFILLER_0_55_156 vssd1 vssd1 vccd1 vccd1 sky130_fd_sc_hd__fill_2
XFILLER_0_55_167 vssd1 vssd1 vccd1 vccd1 sky130_fd_sc_hd__fill_1
XANTENNA__3357__A _5290_/A vssd1 vssd1 vccd1 vccd1 sky130_fd_sc_hd__diode_2
X_3560_ _3560_/A _3560_/B vssd1 vssd1 vccd1 vccd1 _3561_/B sky130_fd_sc_hd__nor2_1
XFILLER_0_11_248 vssd1 vssd1 vccd1 vccd1 sky130_fd_sc_hd__decap_4
X_3491_ _3488_/X _3489_/Y _3441_/X _3445_/A vssd1 vssd1 vccd1 vccd1 _3492_/B sky130_fd_sc_hd__o211a_1
X_5230_ _5201_/B _5224_/X _5229_/A _5234_/A vssd1 vssd1 vccd1 vccd1 _5230_/X sky130_fd_sc_hd__o211a_1
XANTENNA__6387__B hold7/A vssd1 vssd1 vccd1 vccd1 sky130_fd_sc_hd__diode_2
XANTENNA__4188__A _5787_/B vssd1 vssd1 vccd1 vccd1 sky130_fd_sc_hd__diode_2
X_5161_ _5160_/B _5160_/Y _5148_/Y _5149_/X vssd1 vssd1 vccd1 vccd1 _5164_/B sky130_fd_sc_hd__a211oi_4
X_4112_ _5701_/A _5687_/A _4433_/D _4774_/B vssd1 vssd1 vccd1 vccd1 _4114_/B sky130_fd_sc_hd__nand4_1
X_5092_ _5092_/A _5092_/B vssd1 vssd1 vccd1 vccd1 _5094_/A sky130_fd_sc_hd__nor2_1
X_4043_ _4043_/A _4043_/B vssd1 vssd1 vccd1 vccd1 _4056_/A sky130_fd_sc_hd__xnor2_1
X_5994_ tex_height_i[6] tex_height_i[5] _5994_/C vssd1 vssd1 vccd1 vccd1 _6002_/C
+ sky130_fd_sc_hd__or3_2
XFILLER_0_115_50 vssd1 vssd1 vccd1 vccd1 sky130_fd_sc_hd__fill_2
XANTENNA__6060__A1 _6543_/Q vssd1 vssd1 vccd1 vccd1 sky130_fd_sc_hd__diode_2
XFILLER_0_93_229 vssd1 vssd1 vccd1 vccd1 sky130_fd_sc_hd__fill_2
XFILLER_0_91_98 vssd1 vssd1 vccd1 vccd1 sky130_fd_sc_hd__fill_2
XFILLER_0_91_87 vssd1 vssd1 vccd1 vccd1 sky130_fd_sc_hd__fill_1
X_4945_ _5687_/B _4944_/B _5053_/A _4944_/D vssd1 vssd1 vccd1 vccd1 _4947_/B sky130_fd_sc_hd__a22o_1
XFILLER_0_19_337 vssd1 vssd1 vccd1 vccd1 sky130_fd_sc_hd__fill_1
XFILLER_0_24_81 vssd1 vssd1 vccd1 vccd1 sky130_fd_sc_hd__fill_1
X_4876_ _4876_/A _4876_/B _4876_/C vssd1 vssd1 vccd1 vccd1 _4880_/A sky130_fd_sc_hd__nand3_4
X_6615_ _6792_/CLK _6615_/D fanout143/X vssd1 vssd1 vccd1 vccd1 tex_mport_o[58] sky130_fd_sc_hd__dfrtp_4
X_3827_ _5290_/A _5327_/A _5276_/B _6686_/Q vssd1 vssd1 vccd1 vccd1 _3827_/X sky130_fd_sc_hd__and4_1
X_6546_ _6864_/CLK _6546_/D vssd1 vssd1 vccd1 vccd1 _6546_/Q sky130_fd_sc_hd__dfxtp_2
X_3758_ _3758_/A _3758_/B _3757_/X vssd1 vssd1 vccd1 vccd1 _3758_/Y sky130_fd_sc_hd__nor3b_4
XFILLER_0_61_148 vssd1 vssd1 vccd1 vccd1 sky130_fd_sc_hd__fill_1
XFILLER_0_100_401 vssd1 vssd1 vccd1 vccd1 sky130_fd_sc_hd__decap_6
XANTENNA__4126__A1 _4794_/B vssd1 vssd1 vccd1 vccd1 sky130_fd_sc_hd__diode_2
X_3689_ _3689_/A _3689_/B vssd1 vssd1 vccd1 vccd1 _3691_/B sky130_fd_sc_hd__nand2_1
X_6477_ hold137/X sstream_i[35] _6493_/S vssd1 vssd1 vccd1 vccd1 _6868_/D sky130_fd_sc_hd__mux2_1
X_5428_ _6740_/Q _5428_/B _5428_/C vssd1 vssd1 vccd1 vccd1 _5428_/Y sky130_fd_sc_hd__nand3_1
X_5359_ _5389_/A _5389_/B _4546_/Y vssd1 vssd1 vccd1 vccd1 _5361_/B sky130_fd_sc_hd__a21o_1
XFILLER_0_84_229 vssd1 vssd1 vccd1 vccd1 sky130_fd_sc_hd__fill_1
XFILLER_0_127_309 vssd1 vssd1 vccd1 vccd1 sky130_fd_sc_hd__fill_2
XANTENNA__4062__B1 _4518_/D vssd1 vssd1 vccd1 vccd1 sky130_fd_sc_hd__diode_2
XFILLER_0_111_19 vssd1 vssd1 vccd1 vccd1 sky130_fd_sc_hd__fill_2
XFILLER_0_92_295 vssd1 vssd1 vccd1 vccd1 sky130_fd_sc_hd__fill_2
XFILLER_0_52_148 vssd1 vssd1 vccd1 vccd1 sky130_fd_sc_hd__fill_2
XFILLER_0_33_373 vssd1 vssd1 vccd1 vccd1 sky130_fd_sc_hd__fill_2
XFILLER_0_103_272 vssd1 vssd1 vccd1 vccd1 sky130_fd_sc_hd__fill_1
XTAP_708 vssd1 vccd1 sky130_fd_sc_hd__tapvpwrvgnd_1
XTAP_719 vssd1 vccd1 sky130_fd_sc_hd__tapvpwrvgnd_1
XANTENNA__3343__C _5064_/B vssd1 vssd1 vccd1 vccd1 sky130_fd_sc_hd__diode_2
XANTENNA__5617__B2 _5787_/B vssd1 vssd1 vccd1 vccd1 sky130_fd_sc_hd__diode_2
XANTENNA__5617__A1 _4832_/C vssd1 vssd1 vccd1 vccd1 sky130_fd_sc_hd__diode_2
XANTENNA__4736__A _5071_/A vssd1 vssd1 vccd1 vccd1 sky130_fd_sc_hd__diode_2
XANTENNA__6042__A1 _5273_/B vssd1 vssd1 vccd1 vccd1 sky130_fd_sc_hd__diode_2
XFILLER_0_0_27 vssd1 vssd1 vccd1 vccd1 sky130_fd_sc_hd__fill_1
XFILLER_0_118_309 vssd1 vssd1 vccd1 vccd1 sky130_fd_sc_hd__fill_1
XANTENNA__5567__A _5796_/A vssd1 vssd1 vccd1 vccd1 sky130_fd_sc_hd__diode_2
XFILLER_0_28_123 vssd1 vssd1 vccd1 vccd1 sky130_fd_sc_hd__fill_1
X_4730_ _4183_/X _4186_/X _4784_/B _4729_/X vssd1 vssd1 vccd1 vccd1 _4730_/X sky130_fd_sc_hd__o211a_1
XFILLER_0_138_191 vssd1 vssd1 vccd1 vccd1 sky130_fd_sc_hd__fill_1
XANTENNA__6578__RESET_B fanout149/X vssd1 vssd1 vccd1 vccd1 sky130_fd_sc_hd__diode_2
XFILLER_0_124_3 vssd1 vssd1 vccd1 vccd1 sky130_fd_sc_hd__decap_3
X_4661_ _4661_/A vssd1 vssd1 vccd1 vccd1 _4666_/A sky130_fd_sc_hd__inv_2
XFILLER_0_83_262 vssd1 vssd1 vccd1 vccd1 sky130_fd_sc_hd__fill_1
XANTENNA__5286__B _5286_/B vssd1 vssd1 vccd1 vccd1 sky130_fd_sc_hd__diode_2
XFILLER_0_16_329 vssd1 vssd1 vccd1 vccd1 sky130_fd_sc_hd__fill_2
XFILLER_0_28_178 vssd1 vssd1 vccd1 vccd1 sky130_fd_sc_hd__decap_4
X_6400_ _6543_/Q hold70/A vssd1 vssd1 vccd1 vccd1 _6401_/B sky130_fd_sc_hd__or2_1
XFILLER_0_9_69 vssd1 vssd1 vccd1 vccd1 sky130_ef_sc_hd__decap_12
X_3612_ _3612_/A _3612_/B _3611_/Y vssd1 vssd1 vccd1 vccd1 _3612_/Y sky130_fd_sc_hd__nor3b_2
X_6331_ hold168/X depth_mport_o[36] _6440_/B vssd1 vssd1 vccd1 vccd1 _6814_/D sky130_fd_sc_hd__mux2_1
X_4592_ _5687_/B _4688_/C vssd1 vssd1 vccd1 vccd1 _4594_/B sky130_fd_sc_hd__nand2_1
XFILLER_0_101_74 vssd1 vssd1 vccd1 vccd1 sky130_fd_sc_hd__fill_2
X_3543_ _3543_/A _3543_/B vssd1 vssd1 vccd1 vccd1 _3561_/A sky130_fd_sc_hd__nor2_1
X_6262_ depth_mport_i[3] _3325_/Y depth_mport_i[2] _3326_/Y _6261_/X vssd1 vssd1 vccd1
+ vccd1 _6262_/X sky130_fd_sc_hd__o221a_1
XFILLER_0_10_83 vssd1 vssd1 vccd1 vccd1 sky130_fd_sc_hd__fill_1
X_3474_ _5290_/A _5327_/A _6691_/Q vssd1 vssd1 vccd1 vccd1 _3474_/X sky130_fd_sc_hd__and3_1
X_6193_ _6193_/A vssd1 vssd1 vccd1 vccd1 _6193_/Y sky130_fd_sc_hd__inv_2
X_5213_ _3996_/Y _5211_/X _5148_/Y _5148_/A vssd1 vssd1 vccd1 vccd1 _5215_/C sky130_fd_sc_hd__a211oi_2
X_5144_ _5145_/A _5145_/B _5145_/C vssd1 vssd1 vccd1 vccd1 _5144_/Y sky130_fd_sc_hd__nor3_1
X_5075_ _5075_/A _5189_/A vssd1 vssd1 vccd1 vccd1 _5175_/A sky130_fd_sc_hd__nand2_1
X_4026_ _4614_/C _4582_/D _5732_/A _4814_/D vssd1 vssd1 vccd1 vccd1 _4102_/A sky130_fd_sc_hd__nand4_2
XFILLER_0_29_3 vssd1 vssd1 vccd1 vccd1 sky130_fd_sc_hd__decap_6
XANTENNA__5084__A2 _5083_/B vssd1 vssd1 vccd1 vccd1 sky130_fd_sc_hd__diode_2
XFILLER_0_35_80 vssd1 vssd1 vccd1 vccd1 sky130_fd_sc_hd__fill_2
X_5977_ tex_height_i[0] tex_height_i[2] tex_height_i[1] vssd1 vssd1 vccd1 vccd1 _5982_/B
+ sky130_fd_sc_hd__or3_1
XFILLER_0_59_281 vssd1 vssd1 vccd1 vccd1 sky130_fd_sc_hd__decap_4
XANTENNA__6072__S _6072_/S vssd1 vssd1 vccd1 vccd1 sky130_fd_sc_hd__diode_2
XANTENNA__4381__A _4789_/B vssd1 vssd1 vccd1 vccd1 sky130_fd_sc_hd__diode_2
X_4928_ _5051_/B _5666_/A vssd1 vssd1 vccd1 vccd1 _4929_/B sky130_fd_sc_hd__nand2_1
XFILLER_0_117_353 vssd1 vssd1 vccd1 vccd1 sky130_fd_sc_hd__fill_1
XFILLER_0_117_331 vssd1 vssd1 vccd1 vccd1 sky130_fd_sc_hd__fill_2
XFILLER_0_19_167 vssd1 vssd1 vccd1 vccd1 sky130_fd_sc_hd__fill_1
XFILLER_0_117_386 vssd1 vssd1 vccd1 vccd1 sky130_fd_sc_hd__decap_6
XANTENNA__4347__A1 _4432_/A vssd1 vssd1 vccd1 vccd1 sky130_fd_sc_hd__diode_2
XFILLER_0_34_148 vssd1 vssd1 vccd1 vccd1 sky130_fd_sc_hd__fill_2
X_4859_ _4859_/A _4859_/B _4859_/C vssd1 vssd1 vccd1 vccd1 _4862_/A sky130_fd_sc_hd__nand3_1
X_6529_ _6841_/CLK _6529_/D vssd1 vssd1 vccd1 vccd1 hold62/A sky130_fd_sc_hd__dfxtp_1
XFILLER_0_30_398 vssd1 vssd1 vccd1 vccd1 sky130_fd_sc_hd__decap_8
XFILLER_0_100_286 vssd1 vssd1 vccd1 vccd1 sky130_fd_sc_hd__fill_2
XANTENNA__4556__A _5666_/A vssd1 vssd1 vccd1 vccd1 sky130_fd_sc_hd__diode_2
XANTENNA__4275__B _4774_/B vssd1 vssd1 vccd1 vccd1 sky130_fd_sc_hd__diode_2
XANTENNA_clkbuf_leaf_23_clk_i_A _6684_/CLK vssd1 vssd1 vccd1 vccd1 sky130_fd_sc_hd__diode_2
XFILLER_0_15_39 vssd1 vssd1 vccd1 vccd1 sky130_ef_sc_hd__decap_12
XFILLER_0_97_354 vssd1 vssd1 vccd1 vccd1 sky130_fd_sc_hd__fill_2
XFILLER_0_122_29 vssd1 vssd1 vccd1 vccd1 sky130_fd_sc_hd__decap_3
XANTENNA__4586__A1 _5656_/A vssd1 vssd1 vccd1 vccd1 sky130_fd_sc_hd__diode_2
XFILLER_0_65_251 vssd1 vssd1 vccd1 vccd1 sky130_fd_sc_hd__fill_2
XFILLER_0_31_27 vssd1 vssd1 vccd1 vccd1 sky130_fd_sc_hd__fill_2
XFILLER_0_123_334 vssd1 vssd1 vccd1 vccd1 sky130_fd_sc_hd__fill_2
XFILLER_0_80_265 vssd1 vssd1 vccd1 vccd1 sky130_fd_sc_hd__fill_1
XFILLER_0_123_367 vssd1 vssd1 vccd1 vccd1 sky130_ef_sc_hd__decap_12
XFILLER_0_80_287 vssd1 vssd1 vccd1 vccd1 sky130_fd_sc_hd__fill_1
XFILLER_0_40_129 vssd1 vssd1 vccd1 vccd1 sky130_fd_sc_hd__decap_3
XTAP_505 vssd1 vccd1 sky130_fd_sc_hd__tapvpwrvgnd_1
XTAP_516 vssd1 vccd1 sky130_fd_sc_hd__tapvpwrvgnd_1
XANTENNA__5838__A1 _5807_/B vssd1 vssd1 vccd1 vccd1 sky130_fd_sc_hd__diode_2
XTAP_527 vssd1 vccd1 sky130_fd_sc_hd__tapvpwrvgnd_1
XTAP_538 vssd1 vccd1 sky130_fd_sc_hd__tapvpwrvgnd_1
XTAP_549 vssd1 vccd1 sky130_fd_sc_hd__tapvpwrvgnd_1
XANTENNA__3370__A _5311_/A vssd1 vssd1 vccd1 vccd1 sky130_fd_sc_hd__diode_2
X_5900_ _5840_/Y _5869_/Y _5870_/Y _5892_/A _5867_/A vssd1 vssd1 vccd1 vccd1 _5900_/X
+ sky130_fd_sc_hd__a311o_1
XFILLER_0_88_365 vssd1 vssd1 vccd1 vccd1 sky130_ef_sc_hd__decap_12
X_6880_ _6880_/CLK _6880_/D vssd1 vssd1 vccd1 vccd1 _6880_/Q sky130_fd_sc_hd__dfxtp_1
X_5831_ tex_addr_i[19] _5919_/B vssd1 vssd1 vccd1 vccd1 _5837_/C sky130_fd_sc_hd__xnor2_1
X_5762_ _5784_/S _5762_/B vssd1 vssd1 vccd1 vccd1 _5762_/Y sky130_fd_sc_hd__nor2_1
XFILLER_0_8_337 vssd1 vssd1 vccd1 vccd1 sky130_fd_sc_hd__fill_1
X_4713_ _4713_/A _4713_/B _5396_/B vssd1 vssd1 vccd1 vccd1 _4714_/B sky130_fd_sc_hd__nor3b_2
XANTENNA__3529__B _3961_/A vssd1 vssd1 vccd1 vccd1 sky130_fd_sc_hd__diode_2
XFILLER_0_8_348 vssd1 vssd1 vccd1 vccd1 sky130_fd_sc_hd__fill_2
XFILLER_0_56_284 vssd1 vssd1 vccd1 vccd1 sky130_fd_sc_hd__decap_6
X_5693_ tex_addr_i[5] _5693_/B vssd1 vssd1 vccd1 vccd1 _5695_/D sky130_fd_sc_hd__and2_1
X_4644_ _4644_/A _4644_/B vssd1 vssd1 vccd1 vccd1 _4656_/B sky130_fd_sc_hd__xnor2_2
XFILLER_0_97_20 vssd1 vssd1 vccd1 vccd1 sky130_fd_sc_hd__decap_4
X_4575_ _4575_/A vssd1 vssd1 vccd1 vccd1 _4575_/Y sky130_fd_sc_hd__inv_2
X_6314_ hold88/X hold95/A _6319_/S vssd1 vssd1 vccd1 vccd1 hold89/A sky130_fd_sc_hd__mux2_1
X_3526_ _3527_/A _3527_/B vssd1 vssd1 vccd1 vccd1 _3526_/Y sky130_fd_sc_hd__nor2_1
Xfanout5 _6000_/S vssd1 vssd1 vccd1 vccd1 _6038_/C sky130_fd_sc_hd__clkbuf_8
X_6245_ depth_mport_i[15] _6244_/B depth_mport_i[14] _3314_/Y vssd1 vssd1 vccd1 vccd1
+ _6245_/X sky130_fd_sc_hd__o22a_1
XFILLER_0_97_97 vssd1 vssd1 vccd1 vccd1 sky130_fd_sc_hd__fill_2
X_3457_ _3457_/A _3457_/B vssd1 vssd1 vccd1 vccd1 _3589_/A sky130_fd_sc_hd__xnor2_1
X_6176_ _6174_/Y _6175_/X pix_mport_o[43] _6207_/B vssd1 vssd1 vccd1 vccd1 _6771_/D
+ sky130_fd_sc_hd__a2bb2o_1
X_3388_ _5299_/A _6687_/Q _3386_/Y _3387_/X vssd1 vssd1 vccd1 vccd1 _3390_/A sky130_fd_sc_hd__o2bb2a_1
XANTENNA__6067__S _6072_/S vssd1 vssd1 vccd1 vccd1 sky130_fd_sc_hd__diode_2
X_5127_ _5127_/A _5127_/B _5127_/C vssd1 vssd1 vccd1 vccd1 _5127_/X sky130_fd_sc_hd__and3_1
X_5058_ _5058_/A _5101_/B _5058_/C vssd1 vssd1 vccd1 vccd1 _5061_/A sky130_fd_sc_hd__nand3_1
X_4009_ _4010_/B _4010_/A vssd1 vssd1 vccd1 vccd1 _4009_/Y sky130_fd_sc_hd__nand2b_1
XFILLER_0_94_335 vssd1 vssd1 vccd1 vccd1 sky130_fd_sc_hd__fill_2
XFILLER_0_94_313 vssd1 vssd1 vccd1 vccd1 sky130_fd_sc_hd__fill_1
XFILLER_0_79_387 vssd1 vssd1 vccd1 vccd1 sky130_fd_sc_hd__decap_4
XFILLER_0_1_81 vssd1 vssd1 vccd1 vccd1 sky130_ef_sc_hd__decap_12
XANTENNA__5919__B _5919_/B vssd1 vssd1 vccd1 vccd1 sky130_fd_sc_hd__diode_2
XFILLER_0_47_251 vssd1 vssd1 vccd1 vccd1 sky130_fd_sc_hd__decap_4
XANTENNA__5517__A0 hold181/X vssd1 vssd1 vccd1 vccd1 sky130_fd_sc_hd__diode_2
XFILLER_0_62_232 vssd1 vssd1 vccd1 vccd1 sky130_fd_sc_hd__fill_1
XFILLER_0_105_334 vssd1 vssd1 vccd1 vccd1 sky130_fd_sc_hd__fill_2
XFILLER_0_132_153 vssd1 vssd1 vccd1 vccd1 sky130_fd_sc_hd__fill_1
XFILLER_0_105_345 vssd1 vssd1 vccd1 vccd1 sky130_fd_sc_hd__decap_6
XFILLER_0_105_389 vssd1 vssd1 vccd1 vccd1 sky130_fd_sc_hd__decap_3
Xhold50 hold50/A vssd1 vssd1 vccd1 vccd1 hold50/X sky130_fd_sc_hd__dlygate4sd3_1
Xhold83 hold83/A vssd1 vssd1 vccd1 vccd1 hold83/X sky130_fd_sc_hd__dlygate4sd3_1
Xhold61 hold61/A vssd1 vssd1 vccd1 vccd1 hold61/X sky130_fd_sc_hd__dlygate4sd3_1
Xhold72 hold72/A vssd1 vssd1 vccd1 vccd1 hold72/X sky130_fd_sc_hd__dlygate4sd3_1
XFILLER_0_89_118 vssd1 vssd1 vccd1 vccd1 sky130_fd_sc_hd__fill_2
Xhold94 hold94/A vssd1 vssd1 vccd1 vccd1 hold94/X sky130_fd_sc_hd__dlygate4sd3_1
XFILLER_0_97_162 vssd1 vssd1 vccd1 vccd1 sky130_fd_sc_hd__decap_6
XFILLER_0_93_390 vssd1 vssd1 vccd1 vccd1 sky130_fd_sc_hd__fill_2
XANTENNA__4171__D _4841_/D vssd1 vssd1 vccd1 vccd1 sky130_fd_sc_hd__diode_2
XFILLER_0_123_120 vssd1 vssd1 vccd1 vccd1 sky130_fd_sc_hd__fill_1
XFILLER_0_108_183 vssd1 vssd1 vccd1 vccd1 sky130_fd_sc_hd__fill_1
XFILLER_0_41_405 vssd1 vssd1 vccd1 vccd1 sky130_fd_sc_hd__fill_2
XANTENNA_3 sstream_i[0] vssd1 vssd1 vccd1 vccd1 sky130_fd_sc_hd__diode_2
XFILLER_0_13_129 vssd1 vssd1 vccd1 vccd1 sky130_fd_sc_hd__fill_2
X_4360_ _4287_/X _4311_/X _4323_/X _4399_/A vssd1 vssd1 vccd1 vccd1 _4362_/C sky130_fd_sc_hd__o211a_1
XFILLER_0_6_15 vssd1 vssd1 vccd1 vccd1 sky130_ef_sc_hd__decap_12
X_3311_ _6850_/Q vssd1 vssd1 vccd1 vccd1 _3311_/Y sky130_fd_sc_hd__inv_2
X_4291_ _4292_/B _4292_/A vssd1 vssd1 vccd1 vccd1 _4294_/A sky130_fd_sc_hd__nand2b_1
XTAP_324 vssd1 vccd1 sky130_fd_sc_hd__tapvpwrvgnd_1
XTAP_302 vssd1 vccd1 sky130_fd_sc_hd__tapvpwrvgnd_1
XTAP_313 vssd1 vccd1 sky130_fd_sc_hd__tapvpwrvgnd_1
X_6030_ tex_height_i[14] _6031_/B vssd1 vssd1 vccd1 vccd1 _6032_/B sky130_fd_sc_hd__nand2_1
XTAP_357 vssd1 vccd1 sky130_fd_sc_hd__tapvpwrvgnd_1
XTAP_346 vssd1 vccd1 sky130_fd_sc_hd__tapvpwrvgnd_1
XTAP_335 vssd1 vccd1 sky130_fd_sc_hd__tapvpwrvgnd_1
XTAP_379 vssd1 vccd1 sky130_fd_sc_hd__tapvpwrvgnd_1
XTAP_368 vssd1 vccd1 sky130_fd_sc_hd__tapvpwrvgnd_1
X_6932_ vssd1 vssd1 vccd1 vccd1 _6932_/HI pix_mport_o[52] sky130_fd_sc_hd__conb_1
XFILLER_0_83_88 vssd1 vssd1 vccd1 vccd1 sky130_fd_sc_hd__fill_2
XPHY_19 vssd1 vssd1 vccd1 vccd1 sky130_fd_sc_hd__decap_3
X_6863_ _6863_/CLK _6863_/D vssd1 vssd1 vccd1 vccd1 _6863_/Q sky130_fd_sc_hd__dfxtp_2
XFILLER_0_88_195 vssd1 vssd1 vccd1 vccd1 sky130_fd_sc_hd__fill_1
XFILLER_0_88_173 vssd1 vssd1 vccd1 vccd1 sky130_fd_sc_hd__decap_8
XFILLER_0_76_302 vssd1 vssd1 vccd1 vccd1 sky130_fd_sc_hd__fill_2
XFILLER_0_76_357 vssd1 vssd1 vccd1 vccd1 sky130_fd_sc_hd__decap_4
X_5814_ _5824_/A _5825_/A vssd1 vssd1 vccd1 vccd1 _5814_/Y sky130_fd_sc_hd__nand2_1
XFILLER_0_123_61 vssd1 vssd1 vccd1 vccd1 sky130_fd_sc_hd__fill_1
X_6794_ _6863_/CLK _6794_/D vssd1 vssd1 vccd1 vccd1 hold48/A sky130_fd_sc_hd__dfxtp_1
XFILLER_0_91_349 vssd1 vssd1 vccd1 vccd1 sky130_ef_sc_hd__decap_12
X_5745_ tex_addr_i[10] _5746_/B vssd1 vssd1 vccd1 vccd1 _5761_/A sky130_fd_sc_hd__and2_1
XFILLER_0_8_167 vssd1 vssd1 vccd1 vccd1 sky130_fd_sc_hd__decap_3
XFILLER_0_29_284 vssd1 vssd1 vccd1 vccd1 sky130_fd_sc_hd__fill_2
XFILLER_0_29_295 vssd1 vssd1 vccd1 vccd1 sky130_fd_sc_hd__fill_1
XFILLER_0_44_210 vssd1 vssd1 vccd1 vccd1 sky130_fd_sc_hd__fill_1
X_5676_ _5671_/B _5673_/B _5671_/A vssd1 vssd1 vccd1 vccd1 _5683_/A sky130_fd_sc_hd__a21bo_1
X_4627_ _4635_/A _4635_/B vssd1 vssd1 vccd1 vccd1 _4633_/A sky130_fd_sc_hd__nor2_1
XFILLER_0_102_304 vssd1 vssd1 vccd1 vccd1 sky130_fd_sc_hd__fill_2
X_4558_ _4558_/A _4558_/B vssd1 vssd1 vccd1 vccd1 _4596_/B sky130_fd_sc_hd__xor2_1
X_4489_ _4489_/A _4489_/B vssd1 vssd1 vccd1 vccd1 _4534_/B sky130_fd_sc_hd__xnor2_1
XFILLER_0_12_195 vssd1 vssd1 vccd1 vccd1 sky130_fd_sc_hd__fill_1
X_3509_ _5286_/A _5272_/B vssd1 vssd1 vccd1 vccd1 _3514_/A sky130_fd_sc_hd__nand2_1
X_6228_ _6783_/Q _6784_/Q vssd1 vssd1 vccd1 vccd1 _6231_/B sky130_fd_sc_hd__nand2b_1
XFILLER_0_110_370 vssd1 vssd1 vccd1 vccd1 sky130_ef_sc_hd__decap_12
X_6159_ _6159_/A _6159_/B vssd1 vssd1 vccd1 vccd1 _6161_/B sky130_fd_sc_hd__xnor2_1
XTAP_880 vssd1 vccd1 sky130_fd_sc_hd__tapvpwrvgnd_1
XANTENNA__3722__B _4944_/B vssd1 vssd1 vccd1 vccd1 sky130_fd_sc_hd__diode_2
XFILLER_0_99_405 vssd1 vssd1 vccd1 vccd1 sky130_fd_sc_hd__fill_2
XTAP_891 vssd1 vccd1 sky130_fd_sc_hd__tapvpwrvgnd_1
XFILLER_0_79_162 vssd1 vssd1 vccd1 vccd1 sky130_fd_sc_hd__fill_1
XFILLER_0_79_195 vssd1 vssd1 vccd1 vccd1 sky130_fd_sc_hd__fill_2
XFILLER_0_137_223 vssd1 vssd1 vccd1 vccd1 sky130_fd_sc_hd__fill_1
XFILLER_0_67_379 vssd1 vssd1 vccd1 vccd1 sky130_ef_sc_hd__decap_12
XFILLER_0_12_29 vssd1 vssd1 vccd1 vccd1 sky130_ef_sc_hd__decap_12
XANTENNA__5665__A _5666_/A vssd1 vssd1 vccd1 vccd1 sky130_fd_sc_hd__diode_2
XFILLER_0_23_405 vssd1 vssd1 vccd1 vccd1 sky130_fd_sc_hd__fill_2
XFILLER_0_35_243 vssd1 vssd1 vccd1 vccd1 sky130_fd_sc_hd__fill_1
XFILLER_0_35_254 vssd1 vssd1 vccd1 vccd1 sky130_fd_sc_hd__fill_1
XANTENNA__4961__A1 _4794_/B vssd1 vssd1 vccd1 vccd1 sky130_fd_sc_hd__diode_2
XANTENNA__5384__B _5384_/B vssd1 vssd1 vccd1 vccd1 sky130_fd_sc_hd__diode_2
XFILLER_0_120_101 vssd1 vssd1 vccd1 vccd1 sky130_fd_sc_hd__fill_1
XFILLER_0_120_134 vssd1 vssd1 vccd1 vccd1 sky130_fd_sc_hd__fill_2
XANTENNA__5910__A0 _5440_/X vssd1 vssd1 vccd1 vccd1 sky130_fd_sc_hd__diode_2
XFILLER_0_128_17 vssd1 vssd1 vccd1 vccd1 sky130_fd_sc_hd__decap_4
XANTENNA__4728__B _4816_/B vssd1 vssd1 vccd1 vccd1 sky130_fd_sc_hd__diode_2
XANTENNA__3351__C _5320_/A vssd1 vssd1 vccd1 vccd1 sky130_fd_sc_hd__diode_2
XFILLER_0_53_36 vssd1 vssd1 vccd1 vccd1 sky130_fd_sc_hd__fill_2
XANTENNA__5559__B _5559_/B vssd1 vssd1 vccd1 vccd1 sky130_fd_sc_hd__diode_2
XFILLER_0_128_212 vssd1 vssd1 vccd1 vccd1 sky130_ef_sc_hd__decap_12
XANTENNA__3452__A1 _3999_/A vssd1 vssd1 vccd1 vccd1 sky130_fd_sc_hd__diode_2
X_3860_ _5081_/A _5766_/A _5115_/B _5118_/B vssd1 vssd1 vccd1 vccd1 _3860_/X sky130_fd_sc_hd__and4_1
XFILLER_0_85_198 vssd1 vssd1 vccd1 vccd1 sky130_fd_sc_hd__decap_4
X_3791_ _3791_/A _3791_/B _3791_/C vssd1 vssd1 vccd1 vccd1 _3798_/A sky130_fd_sc_hd__nand3_1
X_5530_ depth_mport_o[5] hold124/X _5541_/S vssd1 vssd1 vccd1 vccd1 _6561_/D sky130_fd_sc_hd__mux2_1
XPHY_190 vssd1 vssd1 vccd1 vccd1 sky130_fd_sc_hd__decap_3
XFILLER_0_5_137 vssd1 vssd1 vccd1 vccd1 sky130_fd_sc_hd__decap_3
X_5461_ tex_mport_i[32] hold71/A vssd1 vssd1 vccd1 vccd1 _5924_/B sky130_fd_sc_hd__and2b_1
XFILLER_0_81_393 vssd1 vssd1 vccd1 vccd1 sky130_ef_sc_hd__decap_12
X_4412_ _4412_/A _4412_/B vssd1 vssd1 vccd1 vccd1 _4414_/B sky130_fd_sc_hd__xnor2_2
XFILLER_0_78_33 vssd1 vssd1 vccd1 vccd1 sky130_fd_sc_hd__fill_1
X_5392_ _5392_/A _5392_/B vssd1 vssd1 vccd1 vccd1 _5393_/B sky130_fd_sc_hd__xor2_1
X_4343_ _4342_/B _4342_/C _4342_/A vssd1 vssd1 vccd1 vccd1 _4345_/B sky130_fd_sc_hd__a21o_1
XFILLER_0_1_354 vssd1 vssd1 vccd1 vccd1 sky130_fd_sc_hd__fill_2
X_4274_ _4274_/A _4274_/B vssd1 vssd1 vccd1 vccd1 _4276_/A sky130_fd_sc_hd__nor2_1
X_6013_ _6012_/Y _6875_/Q _6038_/C vssd1 vssd1 vccd1 vccd1 _6013_/X sky130_fd_sc_hd__mux2_1
XFILLER_0_118_94 vssd1 vssd1 vccd1 vccd1 sky130_fd_sc_hd__decap_3
XFILLER_0_27_81 vssd1 vssd1 vccd1 vccd1 sky130_fd_sc_hd__decap_3
X_6915_ vssd1 vssd1 vccd1 vccd1 _6915_/HI pix_mport_o[16] sky130_fd_sc_hd__conb_1
XFILLER_0_11_3 vssd1 vssd1 vccd1 vccd1 sky130_ef_sc_hd__decap_12
XANTENNA__4373__B _5687_/A vssd1 vssd1 vccd1 vccd1 sky130_fd_sc_hd__diode_2
X_6846_ _6862_/CLK _6846_/D vssd1 vssd1 vccd1 vccd1 _6846_/Q sky130_fd_sc_hd__dfxtp_1
XANTENNA__4092__C _4527_/B vssd1 vssd1 vccd1 vccd1 sky130_fd_sc_hd__diode_2
XFILLER_0_64_305 vssd1 vssd1 vccd1 vccd1 sky130_fd_sc_hd__fill_1
X_6777_ _6832_/CLK _6777_/D fanout152/X vssd1 vssd1 vccd1 vccd1 pix_mport_o[49] sky130_fd_sc_hd__dfrtp_4
XFILLER_0_119_278 vssd1 vssd1 vccd1 vccd1 sky130_fd_sc_hd__fill_2
XFILLER_0_91_113 vssd1 vssd1 vccd1 vccd1 sky130_fd_sc_hd__decap_3
XANTENNA__6080__S _6315_/S vssd1 vssd1 vccd1 vccd1 sky130_fd_sc_hd__diode_2
X_5728_ _5796_/A _5728_/B vssd1 vssd1 vccd1 vccd1 _5728_/Y sky130_fd_sc_hd__nand2_1
XFILLER_0_17_243 vssd1 vssd1 vccd1 vccd1 sky130_fd_sc_hd__fill_2
X_3989_ _3989_/A _3989_/B _3989_/C vssd1 vssd1 vccd1 vccd1 _5127_/A sky130_fd_sc_hd__nand3_1
XANTENNA__4943__A1 _4942_/A vssd1 vssd1 vccd1 vccd1 sky130_fd_sc_hd__diode_2
XANTENNA__3717__B _5286_/A vssd1 vssd1 vccd1 vccd1 sky130_fd_sc_hd__diode_2
XFILLER_0_32_213 vssd1 vssd1 vccd1 vccd1 sky130_fd_sc_hd__fill_1
XFILLER_0_32_224 vssd1 vssd1 vccd1 vccd1 sky130_fd_sc_hd__fill_2
XANTENNA__4943__B2 _4942_/B vssd1 vssd1 vccd1 vccd1 sky130_fd_sc_hd__diode_2
X_5659_ tex_addr_i[2] _5660_/B vssd1 vssd1 vccd1 vccd1 _5659_/Y sky130_fd_sc_hd__nand2_1
XANTENNA__3436__C _5276_/B vssd1 vssd1 vccd1 vccd1 sky130_fd_sc_hd__diode_2
XFILLER_0_4_181 vssd1 vssd1 vccd1 vccd1 sky130_fd_sc_hd__fill_2
XFILLER_0_4_192 vssd1 vssd1 vccd1 vccd1 sky130_fd_sc_hd__fill_2
XANTENNA_fanout82_A _4958_/B vssd1 vssd1 vccd1 vccd1 sky130_fd_sc_hd__diode_2
XANTENNA__5120__A1 _5049_/D vssd1 vssd1 vccd1 vccd1 sky130_fd_sc_hd__diode_2
XFILLER_0_67_143 vssd1 vssd1 vccd1 vccd1 sky130_fd_sc_hd__fill_2
XFILLER_0_67_121 vssd1 vssd1 vccd1 vccd1 sky130_fd_sc_hd__fill_2
XFILLER_0_55_316 vssd1 vssd1 vccd1 vccd1 sky130_fd_sc_hd__decap_8
XANTENNA__5187__A1 _5051_/B vssd1 vssd1 vccd1 vccd1 sky130_fd_sc_hd__diode_2
XFILLER_0_130_29 vssd1 vssd1 vccd1 vccd1 sky130_fd_sc_hd__fill_2
XFILLER_0_23_202 vssd1 vssd1 vccd1 vccd1 sky130_fd_sc_hd__decap_3
XFILLER_0_90_190 vssd1 vssd1 vccd1 vccd1 sky130_fd_sc_hd__fill_1
XFILLER_0_63_393 vssd1 vssd1 vccd1 vccd1 sky130_ef_sc_hd__decap_12
XFILLER_0_23_246 vssd1 vssd1 vccd1 vccd1 sky130_fd_sc_hd__decap_3
XFILLER_0_23_257 vssd1 vssd1 vccd1 vccd1 sky130_fd_sc_hd__fill_1
XFILLER_0_3_27 vssd1 vssd1 vccd1 vccd1 sky130_ef_sc_hd__decap_12
XANTENNA__4474__A _5656_/A vssd1 vssd1 vccd1 vccd1 sky130_fd_sc_hd__diode_2
XANTENNA__4193__B _5787_/B vssd1 vssd1 vccd1 vccd1 sky130_fd_sc_hd__diode_2
X_4961_ _4794_/B _5083_/B _5086_/A _4960_/D vssd1 vssd1 vccd1 vccd1 _4962_/B sky130_fd_sc_hd__a22o_1
X_6700_ _6830_/CLK _6700_/D vssd1 vssd1 vccd1 vccd1 hold5/A sky130_fd_sc_hd__dfxtp_1
X_3912_ _3912_/A _3912_/B _3912_/C vssd1 vssd1 vccd1 vccd1 _3949_/A sky130_fd_sc_hd__nand3_1
X_4892_ _4886_/A _4886_/C _4886_/B vssd1 vssd1 vccd1 vccd1 _4892_/X sky130_fd_sc_hd__o21a_1
X_6631_ _6633_/CLK _6631_/D fanout143/X vssd1 vssd1 vccd1 vccd1 _6631_/Q sky130_fd_sc_hd__dfstp_1
X_3843_ _3845_/A _3843_/B vssd1 vssd1 vccd1 vccd1 _3894_/B sky130_fd_sc_hd__and2_1
XFILLER_0_39_390 vssd1 vssd1 vccd1 vccd1 sky130_fd_sc_hd__fill_2
XANTENNA__4925__A1 _4944_/B vssd1 vssd1 vccd1 vccd1 sky130_fd_sc_hd__diode_2
XFILLER_0_61_308 vssd1 vssd1 vccd1 vccd1 sky130_fd_sc_hd__fill_1
X_6562_ _6853_/CLK _6562_/D _5468_/A vssd1 vssd1 vccd1 vccd1 depth_mport_o[6] sky130_fd_sc_hd__dfrtp_4
XFILLER_0_89_21 vssd1 vssd1 vccd1 vccd1 sky130_fd_sc_hd__decap_4
X_3774_ _3774_/A _3774_/B vssd1 vssd1 vccd1 vccd1 _3779_/A sky130_fd_sc_hd__xnor2_1
X_5513_ hold214/X sstream_i[104] _6464_/S vssd1 vssd1 vccd1 vccd1 _6546_/D sky130_fd_sc_hd__mux2_1
X_6493_ hold20/X sstream_i[51] _6493_/S vssd1 vssd1 vccd1 vccd1 _6884_/D sky130_fd_sc_hd__mux2_1
XFILLER_0_14_257 vssd1 vssd1 vccd1 vccd1 sky130_fd_sc_hd__fill_2
X_5444_ _6748_/Q _5444_/B vssd1 vssd1 vccd1 vccd1 _5444_/X sky130_fd_sc_hd__and2_1
X_5375_ _5375_/A _5375_/B vssd1 vssd1 vccd1 vccd1 _5376_/B sky130_fd_sc_hd__nand2_1
XANTENNA__3361__B1 _5276_/B vssd1 vssd1 vccd1 vccd1 sky130_fd_sc_hd__diode_2
Xfanout104 _5106_/A vssd1 vssd1 vccd1 vccd1 _5666_/A sky130_fd_sc_hd__clkbuf_8
XFILLER_0_59_3 vssd1 vssd1 vccd1 vccd1 sky130_fd_sc_hd__decap_4
X_4326_ _5311_/A _4551_/D vssd1 vssd1 vccd1 vccd1 _4328_/B sky130_fd_sc_hd__and2_1
Xfanout126 tex_width_i[12] vssd1 vssd1 vccd1 vccd1 _5766_/A sky130_fd_sc_hd__buf_4
Xfanout115 _4789_/C vssd1 vssd1 vccd1 vccd1 _4736_/D sky130_fd_sc_hd__buf_4
Xfanout137 _4789_/B vssd1 vssd1 vccd1 vccd1 _4736_/B sky130_fd_sc_hd__buf_4
Xfanout148 fanout149/X vssd1 vssd1 vccd1 vccd1 _6320_/C sky130_fd_sc_hd__clkbuf_8
X_4257_ _5732_/A _4658_/D _4637_/D _5718_/A vssd1 vssd1 vccd1 vccd1 _4258_/B sky130_fd_sc_hd__a22o_1
X_4188_ _5787_/B _4841_/D vssd1 vssd1 vccd1 vccd1 _4191_/A sky130_fd_sc_hd__and2_1
XANTENNA__6075__S _6315_/S vssd1 vssd1 vccd1 vccd1 sky130_fd_sc_hd__diode_2
XTAP_1128 vssd1 vccd1 sky130_fd_sc_hd__tapvpwrvgnd_1
XTAP_1117 vssd1 vccd1 sky130_fd_sc_hd__tapvpwrvgnd_1
XTAP_1106 vssd1 vccd1 sky130_fd_sc_hd__tapvpwrvgnd_1
XFILLER_0_96_238 vssd1 vssd1 vccd1 vccd1 sky130_fd_sc_hd__fill_2
XTAP_1139 vssd1 vccd1 sky130_fd_sc_hd__tapvpwrvgnd_1
X_6829_ _6832_/CLK _6829_/D fanout152/X vssd1 vssd1 vccd1 vccd1 depth_mport_o[51]
+ sky130_fd_sc_hd__dfrtp_4
XFILLER_0_45_393 vssd1 vssd1 vccd1 vccd1 sky130_ef_sc_hd__decap_12
XFILLER_0_60_341 vssd1 vssd1 vccd1 vccd1 sky130_fd_sc_hd__fill_2
XFILLER_0_60_363 vssd1 vssd1 vccd1 vccd1 sky130_fd_sc_hd__fill_1
XFILLER_0_130_262 vssd1 vssd1 vccd1 vccd1 sky130_fd_sc_hd__decap_3
XFILLER_0_130_251 vssd1 vssd1 vccd1 vccd1 sky130_fd_sc_hd__fill_1
XANTENNA__4144__A2 _5718_/B vssd1 vssd1 vccd1 vccd1 sky130_fd_sc_hd__diode_2
XFILLER_0_60_385 vssd1 vssd1 vccd1 vccd1 sky130_ef_sc_hd__decap_12
Xhold180 _6858_/Q vssd1 vssd1 vccd1 vccd1 hold180/X sky130_fd_sc_hd__dlygate4sd3_1
Xhold191 _6861_/Q vssd1 vssd1 vccd1 vccd1 hold191/X sky130_fd_sc_hd__dlygate4sd3_1
XFILLER_0_0_3 vssd1 vssd1 vccd1 vccd1 sky130_ef_sc_hd__decap_12
XANTENNA__3910__B _5115_/C vssd1 vssd1 vccd1 vccd1 sky130_fd_sc_hd__diode_2
XFILLER_0_95_271 vssd1 vssd1 vccd1 vccd1 sky130_fd_sc_hd__fill_1
XFILLER_0_55_113 vssd1 vssd1 vccd1 vccd1 sky130_fd_sc_hd__fill_2
XANTENNA__4741__B _4942_/A vssd1 vssd1 vccd1 vccd1 sky130_fd_sc_hd__diode_2
XFILLER_0_63_190 vssd1 vssd1 vccd1 vccd1 sky130_fd_sc_hd__fill_1
XANTENNA__3357__B _5327_/A vssd1 vssd1 vccd1 vccd1 sky130_fd_sc_hd__diode_2
XFILLER_0_3_405 vssd1 vssd1 vccd1 vccd1 sky130_fd_sc_hd__fill_2
XFILLER_0_106_292 vssd1 vssd1 vccd1 vccd1 sky130_fd_sc_hd__fill_2
XANTENNA_clkbuf_leaf_18_clk_i_A _6684_/CLK vssd1 vssd1 vccd1 vccd1 sky130_fd_sc_hd__diode_2
XFILLER_0_11_205 vssd1 vssd1 vccd1 vccd1 sky130_fd_sc_hd__fill_1
X_3490_ _3441_/X _3445_/A _3488_/X _3489_/Y vssd1 vssd1 vccd1 vccd1 _3492_/A sky130_fd_sc_hd__a211oi_2
XFILLER_0_59_57 vssd1 vssd1 vccd1 vccd1 sky130_fd_sc_hd__fill_2
XANTENNA__4469__A _5687_/B vssd1 vssd1 vccd1 vccd1 sky130_fd_sc_hd__diode_2
XANTENNA__4188__B _4841_/D vssd1 vssd1 vccd1 vccd1 sky130_fd_sc_hd__diode_2
X_5160_ _5160_/A _5160_/B _5160_/C _5160_/D vssd1 vssd1 vccd1 vccd1 _5160_/Y sky130_fd_sc_hd__nand4_4
X_4111_ _5311_/A _4776_/A vssd1 vssd1 vccd1 vccd1 _4114_/A sky130_fd_sc_hd__and2_1
XANTENNA__3523__D _5300_/A vssd1 vssd1 vccd1 vccd1 sky130_fd_sc_hd__diode_2
X_5091_ _5091_/A _5091_/B _6682_/Q _6683_/Q vssd1 vssd1 vccd1 vccd1 _5092_/B sky130_fd_sc_hd__and4_1
XFILLER_0_75_89 vssd1 vssd1 vccd1 vccd1 sky130_fd_sc_hd__fill_2
X_4042_ _4816_/A _4432_/A vssd1 vssd1 vccd1 vccd1 _4043_/B sky130_fd_sc_hd__nand2_1
XANTENNA__4843__B1 _4841_/D vssd1 vssd1 vccd1 vccd1 sky130_fd_sc_hd__diode_2
XFILLER_0_91_33 vssd1 vssd1 vccd1 vccd1 sky130_fd_sc_hd__fill_2
XFILLER_0_78_205 vssd1 vssd1 vccd1 vccd1 sky130_fd_sc_hd__fill_1
XFILLER_0_91_66 vssd1 vssd1 vccd1 vccd1 sky130_fd_sc_hd__decap_3
XFILLER_0_91_55 vssd1 vssd1 vccd1 vccd1 sky130_fd_sc_hd__fill_1
X_5993_ _4971_/D _5992_/X _6037_/S vssd1 vssd1 vccd1 vccd1 _6667_/D sky130_fd_sc_hd__mux2_1
X_4944_ _5687_/B _4944_/B _5053_/A _4944_/D vssd1 vssd1 vccd1 vccd1 _5053_/B sky130_fd_sc_hd__nand4_1
XFILLER_0_115_95 vssd1 vssd1 vccd1 vccd1 sky130_fd_sc_hd__decap_4
XFILLER_0_129_373 vssd1 vssd1 vccd1 vccd1 sky130_ef_sc_hd__decap_12
X_4875_ _4196_/A _4196_/C _4196_/B vssd1 vssd1 vccd1 vccd1 _4876_/C sky130_fd_sc_hd__a21bo_1
X_3826_ _3829_/D vssd1 vssd1 vccd1 vccd1 _3826_/Y sky130_fd_sc_hd__inv_2
XANTENNA_fanout132_A _5754_/B vssd1 vssd1 vccd1 vccd1 sky130_fd_sc_hd__diode_2
X_6614_ _6745_/CLK _6614_/D fanout140/X vssd1 vssd1 vccd1 vccd1 tex_mport_o[57] sky130_fd_sc_hd__dfrtp_4
X_6545_ _6855_/CLK _6545_/D vssd1 vssd1 vccd1 vccd1 hold70/A sky130_fd_sc_hd__dfxtp_2
X_3757_ _3757_/A _3757_/B vssd1 vssd1 vccd1 vccd1 _3757_/X sky130_fd_sc_hd__xor2_1
XFILLER_0_27_393 vssd1 vssd1 vccd1 vccd1 sky130_ef_sc_hd__decap_12
X_3688_ _6649_/Q _3688_/B vssd1 vssd1 vccd1 vccd1 _3689_/B sky130_fd_sc_hd__or2_1
X_6476_ hold125/X sstream_i[34] _6493_/S vssd1 vssd1 vccd1 vccd1 _6867_/D sky130_fd_sc_hd__mux2_1
XFILLER_0_112_284 vssd1 vssd1 vccd1 vccd1 sky130_fd_sc_hd__fill_2
XANTENNA__4379__A _4432_/A vssd1 vssd1 vccd1 vccd1 sky130_fd_sc_hd__diode_2
XANTENNA__4126__A2 _4432_/A vssd1 vssd1 vccd1 vccd1 sky130_fd_sc_hd__diode_2
XANTENNA__5323__A1 _3999_/A vssd1 vssd1 vccd1 vccd1 sky130_fd_sc_hd__diode_2
X_5427_ _5428_/B _5428_/C _6740_/Q vssd1 vssd1 vccd1 vccd1 _5427_/X sky130_fd_sc_hd__a21o_1
XFILLER_0_10_260 vssd1 vssd1 vccd1 vccd1 sky130_fd_sc_hd__fill_2
X_5358_ _5358_/A _5583_/B vssd1 vssd1 vccd1 vccd1 _5358_/Y sky130_fd_sc_hd__nand2_1
X_4309_ _4309_/A _4309_/B vssd1 vssd1 vccd1 vccd1 _4712_/A sky130_fd_sc_hd__xnor2_4
X_5289_ _3505_/A _3505_/B _3508_/A vssd1 vssd1 vccd1 vccd1 _5291_/A sky130_fd_sc_hd__a21oi_1
XANTENNA__4834__B1 _4841_/D vssd1 vssd1 vccd1 vccd1 sky130_fd_sc_hd__diode_2
XANTENNA_fanout45_A _5051_/B vssd1 vssd1 vccd1 vccd1 sky130_fd_sc_hd__diode_2
XANTENNA__4842__A _4842_/A vssd1 vssd1 vccd1 vccd1 sky130_fd_sc_hd__diode_2
XANTENNA__6051__A2 _6038_/B vssd1 vssd1 vccd1 vccd1 sky130_fd_sc_hd__diode_2
XANTENNA__4062__A1 _5701_/A vssd1 vssd1 vccd1 vccd1 sky130_fd_sc_hd__diode_2
XANTENNA__4062__B2 _5687_/A vssd1 vssd1 vccd1 vccd1 sky130_fd_sc_hd__diode_2
XFILLER_0_77_260 vssd1 vssd1 vccd1 vccd1 sky130_fd_sc_hd__decap_4
XFILLER_0_37_124 vssd1 vssd1 vccd1 vccd1 sky130_fd_sc_hd__fill_2
XFILLER_0_92_241 vssd1 vssd1 vccd1 vccd1 sky130_fd_sc_hd__fill_2
XFILLER_0_92_230 vssd1 vssd1 vccd1 vccd1 sky130_fd_sc_hd__fill_2
XFILLER_0_20_29 vssd1 vssd1 vccd1 vccd1 sky130_fd_sc_hd__decap_4
XANTENNA__5562__B2 _5588_/C vssd1 vssd1 vccd1 vccd1 sky130_fd_sc_hd__diode_2
XFILLER_0_33_352 vssd1 vssd1 vccd1 vccd1 sky130_fd_sc_hd__fill_2
XFILLER_0_33_363 vssd1 vssd1 vccd1 vccd1 sky130_fd_sc_hd__fill_1
XFILLER_0_29_16 vssd1 vssd1 vccd1 vccd1 sky130_fd_sc_hd__fill_1
XFILLER_0_29_27 vssd1 vssd1 vccd1 vccd1 sky130_fd_sc_hd__fill_2
XTAP_709 vssd1 vccd1 sky130_fd_sc_hd__tapvpwrvgnd_1
XANTENNA__3343__D _5273_/B vssd1 vssd1 vccd1 vccd1 sky130_fd_sc_hd__diode_2
XANTENNA__4736__B _4736_/B vssd1 vssd1 vccd1 vccd1 sky130_fd_sc_hd__diode_2
Xmax_cap4 _6038_/Y vssd1 vssd1 vccd1 vccd1 _6054_/B1 sky130_fd_sc_hd__clkbuf_4
XFILLER_0_45_48 vssd1 vssd1 vccd1 vccd1 sky130_fd_sc_hd__fill_2
XFILLER_0_75_208 vssd1 vssd1 vccd1 vccd1 sky130_fd_sc_hd__fill_2
XANTENNA__6042__A2 _6038_/B vssd1 vssd1 vccd1 vccd1 sky130_fd_sc_hd__diode_2
XANTENNA__4174__D _4814_/D vssd1 vssd1 vccd1 vccd1 sky130_fd_sc_hd__diode_2
XFILLER_0_126_343 vssd1 vssd1 vccd1 vccd1 sky130_ef_sc_hd__decap_12
X_4660_ _4662_/A _4678_/A vssd1 vssd1 vccd1 vccd1 _4661_/A sky130_fd_sc_hd__nor2_1
XFILLER_0_9_15 vssd1 vssd1 vccd1 vccd1 sky130_ef_sc_hd__decap_12
X_3611_ _3611_/A _3611_/B vssd1 vssd1 vccd1 vccd1 _3611_/Y sky130_fd_sc_hd__xnor2_1
X_6330_ hold146/X depth_mport_o[35] _6440_/B vssd1 vssd1 vccd1 vccd1 _6813_/D sky130_fd_sc_hd__mux2_1
X_4591_ _4566_/A _4566_/C _4566_/B vssd1 vssd1 vccd1 vccd1 _4595_/B sky130_fd_sc_hd__a21oi_1
XANTENNA__5583__A _5599_/A vssd1 vssd1 vccd1 vccd1 sky130_fd_sc_hd__diode_2
XFILLER_0_24_363 vssd1 vssd1 vccd1 vccd1 sky130_fd_sc_hd__fill_1
X_3542_ _3541_/B _3541_/C _3541_/A vssd1 vssd1 vccd1 vccd1 _3543_/B sky130_fd_sc_hd__a21oi_1
X_6261_ depth_mport_i[0] _3328_/Y _6259_/X _6260_/X vssd1 vssd1 vccd1 vccd1 _6261_/X
+ sky130_fd_sc_hd__a31o_1
X_3473_ _5327_/A _6691_/Q _6692_/Q _5290_/A vssd1 vssd1 vccd1 vccd1 _3473_/X sky130_fd_sc_hd__a22o_1
X_6192_ fb_i _6194_/B vssd1 vssd1 vccd1 vccd1 _6193_/A sky130_fd_sc_hd__nand2_1
X_5212_ _5148_/A _5148_/Y _5211_/X _3996_/Y vssd1 vssd1 vccd1 vccd1 _5215_/B sky130_fd_sc_hd__o211a_2
X_5143_ _5141_/A _5141_/B _5141_/C vssd1 vssd1 vccd1 vccd1 _5145_/C sky130_fd_sc_hd__a21oi_2
X_5074_ _6641_/Q _5188_/B vssd1 vssd1 vccd1 vccd1 _5189_/A sky130_fd_sc_hd__nand2_1
X_4025_ _4966_/C _4822_/B _4527_/B _4658_/D vssd1 vssd1 vccd1 vccd1 _4253_/A sky130_fd_sc_hd__and4_1
XFILLER_0_66_208 vssd1 vssd1 vccd1 vccd1 sky130_fd_sc_hd__fill_2
XANTENNA__6033__A2 _6038_/C vssd1 vssd1 vccd1 vccd1 sky130_fd_sc_hd__diode_2
XFILLER_0_19_113 vssd1 vssd1 vccd1 vccd1 sky130_fd_sc_hd__fill_2
X_5976_ tex_height_i[0] tex_height_i[1] tex_height_i[2] vssd1 vssd1 vccd1 vccd1 _5978_/A
+ sky130_fd_sc_hd__o21ai_1
XANTENNA__4381__B _4789_/C vssd1 vssd1 vccd1 vccd1 sky130_fd_sc_hd__diode_2
XFILLER_0_19_146 vssd1 vssd1 vccd1 vccd1 sky130_fd_sc_hd__fill_2
X_4927_ _5051_/B _5656_/A _4792_/A _4790_/B vssd1 vssd1 vccd1 vccd1 _4929_/A sky130_fd_sc_hd__a31o_1
X_4858_ _4191_/A _4191_/C _4191_/B vssd1 vssd1 vccd1 vccd1 _4859_/C sky130_fd_sc_hd__a21bo_1
XANTENNA__4347__A2 _4433_/D vssd1 vssd1 vccd1 vccd1 sky130_fd_sc_hd__diode_2
X_3809_ _3733_/B _3809_/B _3809_/C vssd1 vssd1 vccd1 vccd1 _3835_/A sky130_fd_sc_hd__and3b_2
XFILLER_0_27_190 vssd1 vssd1 vccd1 vccd1 sky130_fd_sc_hd__fill_2
X_4789_ _5071_/A _4789_/B _4789_/C _5064_/B vssd1 vssd1 vccd1 vccd1 _4790_/B sky130_fd_sc_hd__and4_1
X_6528_ _6841_/CLK _6528_/D vssd1 vssd1 vccd1 vccd1 hold63/A sky130_fd_sc_hd__dfxtp_1
XFILLER_0_42_171 vssd1 vssd1 vccd1 vccd1 sky130_fd_sc_hd__fill_2
X_6459_ hold213/X sstream_i[17] _6472_/S vssd1 vssd1 vccd1 vccd1 _6850_/D sky130_fd_sc_hd__mux2_1
XANTENNA__3725__B _5320_/A vssd1 vssd1 vccd1 vccd1 sky130_fd_sc_hd__diode_2
XANTENNA__4556__B _4614_/C vssd1 vssd1 vccd1 vccd1 sky130_fd_sc_hd__diode_2
XFILLER_0_97_333 vssd1 vssd1 vccd1 vccd1 sky130_fd_sc_hd__decap_3
XFILLER_0_57_208 vssd1 vssd1 vccd1 vccd1 sky130_fd_sc_hd__fill_2
XANTENNA__4035__A1 _4971_/B vssd1 vssd1 vccd1 vccd1 sky130_fd_sc_hd__diode_2
XFILLER_0_127_129 vssd1 vssd1 vccd1 vccd1 sky130_fd_sc_hd__fill_1
XFILLER_0_31_39 vssd1 vssd1 vccd1 vccd1 sky130_fd_sc_hd__fill_2
XFILLER_0_108_365 vssd1 vssd1 vccd1 vccd1 sky130_ef_sc_hd__decap_12
XFILLER_0_25_149 vssd1 vssd1 vccd1 vccd1 sky130_fd_sc_hd__decap_3
XFILLER_0_135_173 vssd1 vssd1 vccd1 vccd1 sky130_fd_sc_hd__decap_4
XFILLER_0_123_379 vssd1 vssd1 vccd1 vccd1 sky130_ef_sc_hd__decap_12
XFILLER_0_0_205 vssd1 vssd1 vccd1 vccd1 sky130_fd_sc_hd__decap_3
XFILLER_0_131_390 vssd1 vssd1 vccd1 vccd1 sky130_fd_sc_hd__fill_2
XFILLER_0_21_377 vssd1 vssd1 vccd1 vccd1 sky130_fd_sc_hd__fill_1
XTAP_506 vssd1 vccd1 sky130_fd_sc_hd__tapvpwrvgnd_1
XTAP_517 vssd1 vccd1 sky130_fd_sc_hd__tapvpwrvgnd_1
XTAP_528 vssd1 vccd1 sky130_fd_sc_hd__tapvpwrvgnd_1
XTAP_539 vssd1 vccd1 sky130_fd_sc_hd__tapvpwrvgnd_1
XANTENNA__3370__B _5276_/B vssd1 vssd1 vccd1 vccd1 sky130_fd_sc_hd__diode_2
XFILLER_0_88_377 vssd1 vssd1 vccd1 vccd1 sky130_ef_sc_hd__decap_12
XFILLER_0_72_79 vssd1 vssd1 vccd1 vccd1 sky130_fd_sc_hd__decap_3
X_5830_ hold281/X _5829_/X _5923_/S vssd1 vssd1 vccd1 vccd1 _6639_/D sky130_fd_sc_hd__mux2_1
X_5761_ _5761_/A _5761_/B _5759_/Y vssd1 vssd1 vccd1 vccd1 _5761_/X sky130_fd_sc_hd__or3b_1
XFILLER_0_8_327 vssd1 vssd1 vccd1 vccd1 sky130_fd_sc_hd__fill_2
XFILLER_0_8_305 vssd1 vssd1 vccd1 vccd1 sky130_fd_sc_hd__decap_3
XFILLER_0_56_241 vssd1 vssd1 vccd1 vccd1 sky130_fd_sc_hd__decap_6
X_4712_ _4712_/A _4712_/B vssd1 vssd1 vccd1 vccd1 _5396_/B sky130_fd_sc_hd__xnor2_4
XANTENNA_hold70_A hold70/A vssd1 vssd1 vccd1 vccd1 sky130_fd_sc_hd__diode_2
X_5692_ _5692_/A vssd1 vssd1 vccd1 vccd1 _5695_/C sky130_fd_sc_hd__inv_2
XFILLER_0_71_211 vssd1 vssd1 vccd1 vccd1 sky130_fd_sc_hd__decap_4
XFILLER_0_114_313 vssd1 vssd1 vccd1 vccd1 sky130_fd_sc_hd__fill_1
XFILLER_0_112_85 vssd1 vssd1 vccd1 vccd1 sky130_fd_sc_hd__fill_2
X_4643_ _5666_/A _4688_/C _4644_/A vssd1 vssd1 vccd1 vccd1 _4643_/X sky130_fd_sc_hd__and3_1
X_4574_ _4574_/A _4574_/B _4603_/A vssd1 vssd1 vccd1 vccd1 _4575_/A sky130_fd_sc_hd__nor3_2
XFILLER_0_24_171 vssd1 vssd1 vccd1 vccd1 sky130_fd_sc_hd__decap_6
X_6313_ hold32/X hold51/A _6319_/S vssd1 vssd1 vccd1 vccd1 hold33/A sky130_fd_sc_hd__mux2_1
XFILLER_0_97_65 vssd1 vssd1 vccd1 vccd1 sky130_fd_sc_hd__fill_2
XFILLER_0_12_355 vssd1 vssd1 vccd1 vccd1 sky130_fd_sc_hd__fill_2
X_3525_ _3525_/A _3525_/B vssd1 vssd1 vccd1 vccd1 _3527_/B sky130_fd_sc_hd__xnor2_1
Xfanout6 _5919_/B vssd1 vssd1 vccd1 vccd1 _5913_/B sky130_fd_sc_hd__buf_4
X_6244_ depth_mport_i[15] _6244_/B vssd1 vssd1 vccd1 vccd1 _6244_/X sky130_fd_sc_hd__and2_1
X_3456_ _3457_/A _3457_/B vssd1 vssd1 vccd1 vccd1 _3456_/Y sky130_fd_sc_hd__nand2_1
X_6175_ _6162_/A _6184_/A _6184_/B _6207_/B vssd1 vssd1 vccd1 vccd1 _6175_/X sky130_fd_sc_hd__a31o_1
X_3387_ _5290_/A _5327_/A _6688_/Q _6689_/Q vssd1 vssd1 vccd1 vccd1 _3387_/X sky130_fd_sc_hd__and4_1
XFILLER_0_41_3 vssd1 vssd1 vccd1 vccd1 sky130_fd_sc_hd__decap_3
X_5126_ _3989_/A _3989_/C _3989_/B vssd1 vssd1 vccd1 vccd1 _5127_/C sky130_fd_sc_hd__a21o_1
X_5057_ _5101_/A _5056_/C _5056_/A vssd1 vssd1 vccd1 vccd1 _5058_/C sky130_fd_sc_hd__a21o_1
XFILLER_0_79_333 vssd1 vssd1 vccd1 vccd1 sky130_fd_sc_hd__decap_3
X_4008_ _4008_/A _4008_/B vssd1 vssd1 vccd1 vccd1 _4010_/B sky130_fd_sc_hd__xor2_2
XANTENNA__6083__S _6098_/S vssd1 vssd1 vccd1 vccd1 sky130_fd_sc_hd__diode_2
XFILLER_0_39_219 vssd1 vssd1 vccd1 vccd1 sky130_fd_sc_hd__decap_4
XFILLER_0_137_405 vssd1 vssd1 vccd1 vccd1 sky130_fd_sc_hd__fill_2
XFILLER_0_1_93 vssd1 vssd1 vccd1 vccd1 sky130_ef_sc_hd__decap_12
X_5959_ _6872_/Q _3286_/Y _5951_/X _5958_/X vssd1 vssd1 vccd1 vccd1 _5959_/X sky130_fd_sc_hd__a22o_1
XFILLER_0_47_230 vssd1 vssd1 vccd1 vccd1 sky130_fd_sc_hd__fill_2
XFILLER_0_47_263 vssd1 vssd1 vccd1 vccd1 sky130_fd_sc_hd__decap_6
XFILLER_0_7_393 vssd1 vssd1 vccd1 vccd1 sky130_ef_sc_hd__decap_12
XFILLER_0_105_357 vssd1 vssd1 vccd1 vccd1 sky130_ef_sc_hd__decap_12
XFILLER_0_15_160 vssd1 vssd1 vccd1 vccd1 sky130_fd_sc_hd__fill_2
XFILLER_0_30_163 vssd1 vssd1 vccd1 vccd1 sky130_fd_sc_hd__fill_2
XFILLER_0_117_19 vssd1 vssd1 vccd1 vccd1 sky130_fd_sc_hd__fill_1
Xhold40 hold40/A vssd1 vssd1 vccd1 vccd1 hold40/X sky130_fd_sc_hd__dlygate4sd3_1
Xhold73 hold73/A vssd1 vssd1 vccd1 vccd1 hold73/X sky130_fd_sc_hd__dlygate4sd3_1
Xhold51 hold51/A vssd1 vssd1 vccd1 vccd1 hold51/X sky130_fd_sc_hd__dlygate4sd3_1
Xhold62 hold62/A vssd1 vssd1 vccd1 vccd1 hold62/X sky130_fd_sc_hd__dlygate4sd3_1
Xhold84 hold84/A vssd1 vssd1 vccd1 vccd1 hold84/X sky130_fd_sc_hd__dlygate4sd3_1
Xhold95 hold95/A vssd1 vssd1 vccd1 vccd1 hold95/X sky130_fd_sc_hd__dlygate4sd3_1
XFILLER_0_97_141 vssd1 vssd1 vccd1 vccd1 sky130_fd_sc_hd__fill_1
XFILLER_0_42_27 vssd1 vssd1 vccd1 vccd1 sky130_fd_sc_hd__fill_1
XFILLER_0_53_211 vssd1 vssd1 vccd1 vccd1 sky130_fd_sc_hd__fill_2
XFILLER_0_53_277 vssd1 vssd1 vccd1 vccd1 sky130_fd_sc_hd__fill_1
XANTENNA_4 sstream_i[0] vssd1 vssd1 vccd1 vccd1 sky130_fd_sc_hd__diode_2
XFILLER_0_21_130 vssd1 vssd1 vccd1 vccd1 sky130_fd_sc_hd__fill_2
X_3310_ depth_mport_i[17] vssd1 vssd1 vccd1 vccd1 _3310_/Y sky130_fd_sc_hd__inv_2
XFILLER_0_6_27 vssd1 vssd1 vccd1 vccd1 sky130_fd_sc_hd__fill_1
X_4290_ _5666_/A _5115_/D vssd1 vssd1 vccd1 vccd1 _4292_/B sky130_fd_sc_hd__nand2_1
XTAP_303 vssd1 vccd1 sky130_fd_sc_hd__tapvpwrvgnd_1
XTAP_314 vssd1 vccd1 sky130_fd_sc_hd__tapvpwrvgnd_1
XTAP_358 vssd1 vccd1 sky130_fd_sc_hd__tapvpwrvgnd_1
XTAP_347 vssd1 vccd1 sky130_fd_sc_hd__tapvpwrvgnd_1
XTAP_336 vssd1 vccd1 sky130_fd_sc_hd__tapvpwrvgnd_1
XTAP_325 vssd1 vccd1 sky130_fd_sc_hd__tapvpwrvgnd_1
XTAP_369 vssd1 vccd1 sky130_fd_sc_hd__tapvpwrvgnd_1
XFILLER_0_83_67 vssd1 vssd1 vccd1 vccd1 sky130_fd_sc_hd__decap_3
X_6931_ vssd1 vssd1 vccd1 vccd1 _6931_/HI pix_mport_o[51] sky130_fd_sc_hd__conb_1
XFILLER_0_88_141 vssd1 vssd1 vccd1 vccd1 sky130_fd_sc_hd__fill_2
XFILLER_0_16_61 vssd1 vssd1 vccd1 vccd1 sky130_fd_sc_hd__fill_1
X_6862_ _6862_/CLK _6862_/D vssd1 vssd1 vccd1 vccd1 _6862_/Q sky130_fd_sc_hd__dfxtp_1
XFILLER_0_16_83 vssd1 vssd1 vccd1 vccd1 sky130_fd_sc_hd__fill_1
XFILLER_0_119_405 vssd1 vssd1 vccd1 vccd1 sky130_fd_sc_hd__fill_2
X_5813_ _5807_/B _5812_/X _5804_/A vssd1 vssd1 vccd1 vccd1 _5825_/A sky130_fd_sc_hd__o21ai_2
X_6793_ _6830_/CLK _6793_/D vssd1 vssd1 vccd1 vccd1 hold49/A sky130_fd_sc_hd__dfxtp_1
XFILLER_0_91_306 vssd1 vssd1 vccd1 vccd1 sky130_fd_sc_hd__fill_2
X_5744_ _5743_/Y _6516_/Q _5802_/B vssd1 vssd1 vccd1 vccd1 _5746_/B sky130_fd_sc_hd__mux2_1
XANTENNA__4940__A _5071_/A vssd1 vssd1 vccd1 vccd1 sky130_fd_sc_hd__diode_2
X_5675_ hold296/X _5674_/X _5844_/S vssd1 vssd1 vccd1 vccd1 _6624_/D sky130_fd_sc_hd__mux2_1
XFILLER_0_32_93 vssd1 vssd1 vccd1 vccd1 sky130_fd_sc_hd__fill_1
XFILLER_0_32_406 vssd1 vssd1 vccd1 vccd1 sky130_fd_sc_hd__fill_1
X_4626_ _4626_/A _4626_/B vssd1 vssd1 vccd1 vccd1 _4635_/B sky130_fd_sc_hd__or2_1
XFILLER_0_89_3 vssd1 vssd1 vccd1 vccd1 sky130_fd_sc_hd__fill_2
XFILLER_0_114_187 vssd1 vssd1 vccd1 vccd1 sky130_fd_sc_hd__fill_1
X_4557_ _4558_/A _4558_/B vssd1 vssd1 vccd1 vccd1 _4557_/X sky130_fd_sc_hd__and2_1
X_4488_ _4488_/A _4551_/D _4489_/A vssd1 vssd1 vccd1 vccd1 _4488_/X sky130_fd_sc_hd__and3_1
X_3508_ _3508_/A _3508_/B vssd1 vssd1 vccd1 vccd1 _3541_/A sky130_fd_sc_hd__nor2_1
XANTENNA__6078__S _6315_/S vssd1 vssd1 vccd1 vccd1 sky130_fd_sc_hd__diode_2
X_6227_ hold220/X depth_mport_o[68] _6333_/S vssd1 vssd1 vccd1 vccd1 _6780_/D sky130_fd_sc_hd__mux2_1
XFILLER_0_110_382 vssd1 vssd1 vccd1 vccd1 sky130_ef_sc_hd__decap_12
XANTENNA__4486__A1 _4432_/A vssd1 vssd1 vccd1 vccd1 sky130_fd_sc_hd__diode_2
X_3439_ _3483_/B _3441_/B vssd1 vssd1 vccd1 vccd1 _3442_/A sky130_fd_sc_hd__or2_1
X_6158_ _6150_/A _6150_/B _6149_/A vssd1 vssd1 vccd1 vccd1 _6159_/B sky130_fd_sc_hd__o21ai_2
XTAP_870 vssd1 vccd1 sky130_fd_sc_hd__tapvpwrvgnd_1
XTAP_892 vssd1 vccd1 sky130_fd_sc_hd__tapvpwrvgnd_1
XTAP_881 vssd1 vccd1 sky130_fd_sc_hd__tapvpwrvgnd_1
X_5109_ _6643_/Q _5109_/B vssd1 vssd1 vccd1 vccd1 _5110_/B sky130_fd_sc_hd__nor2_1
X_6089_ _6628_/Q hold256/X _6098_/S vssd1 vssd1 vccd1 vccd1 _6089_/X sky130_fd_sc_hd__mux2_1
XFILLER_0_79_152 vssd1 vssd1 vccd1 vccd1 sky130_fd_sc_hd__fill_2
XFILLER_0_94_100 vssd1 vssd1 vccd1 vccd1 sky130_fd_sc_hd__fill_2
XFILLER_0_94_122 vssd1 vssd1 vccd1 vccd1 sky130_fd_sc_hd__fill_2
XFILLER_0_137_279 vssd1 vssd1 vccd1 vccd1 sky130_fd_sc_hd__fill_1
XFILLER_0_94_188 vssd1 vssd1 vccd1 vccd1 sky130_fd_sc_hd__fill_2
XFILLER_0_75_391 vssd1 vssd1 vccd1 vccd1 sky130_fd_sc_hd__fill_1
XANTENNA__4961__A2 _5083_/B vssd1 vssd1 vccd1 vccd1 sky130_fd_sc_hd__diode_2
XANTENNA__3466__A _5320_/A vssd1 vssd1 vccd1 vccd1 sky130_fd_sc_hd__diode_2
XFILLER_0_128_29 vssd1 vssd1 vccd1 vccd1 sky130_fd_sc_hd__fill_2
XFILLER_0_101_393 vssd1 vssd1 vccd1 vccd1 sky130_ef_sc_hd__decap_12
XANTENNA__3351__D _5273_/B vssd1 vssd1 vccd1 vccd1 sky130_fd_sc_hd__diode_2
XANTENNA__5559__C _5588_/C vssd1 vssd1 vccd1 vccd1 sky130_fd_sc_hd__diode_2
XFILLER_0_128_224 vssd1 vssd1 vccd1 vccd1 sky130_fd_sc_hd__decap_6
XANTENNA__5729__A1 _5796_/A vssd1 vssd1 vccd1 vccd1 sky130_fd_sc_hd__diode_2
XFILLER_0_85_177 vssd1 vssd1 vccd1 vccd1 sky130_fd_sc_hd__fill_2
XFILLER_0_128_246 vssd1 vssd1 vccd1 vccd1 sky130_fd_sc_hd__decap_3
X_3790_ _3791_/A _3791_/B _3791_/C vssd1 vssd1 vccd1 vccd1 _3801_/B sky130_fd_sc_hd__and3_1
XPHY_191 vssd1 vssd1 vccd1 vccd1 sky130_fd_sc_hd__decap_3
XPHY_180 vssd1 vssd1 vccd1 vccd1 sky130_fd_sc_hd__decap_3
XFILLER_0_81_350 vssd1 vssd1 vccd1 vccd1 sky130_ef_sc_hd__decap_12
XFILLER_0_5_105 vssd1 vssd1 vccd1 vccd1 sky130_fd_sc_hd__decap_6
X_5460_ tex_mport_i[32] _3266_/Y _5576_/S vssd1 vssd1 vccd1 vccd1 _6809_/D sky130_fd_sc_hd__o21ai_1
XFILLER_0_14_406 vssd1 vssd1 vccd1 vccd1 sky130_fd_sc_hd__fill_1
X_4411_ _4412_/A _4412_/B vssd1 vssd1 vccd1 vccd1 _4411_/X sky130_fd_sc_hd__and2_1
XFILLER_0_41_236 vssd1 vssd1 vccd1 vccd1 sky130_fd_sc_hd__decap_3
XFILLER_0_111_113 vssd1 vssd1 vccd1 vccd1 sky130_fd_sc_hd__fill_2
X_5391_ _6731_/Q _5762_/B _5387_/X _5388_/Y _5390_/Y vssd1 vssd1 vccd1 vccd1 _5391_/X
+ sky130_fd_sc_hd__o2111a_1
XFILLER_0_1_322 vssd1 vssd1 vccd1 vccd1 sky130_fd_sc_hd__decap_3
XANTENNA__5591__A _5599_/A vssd1 vssd1 vccd1 vccd1 sky130_fd_sc_hd__diode_2
X_4342_ _4342_/A _4342_/B _4342_/C vssd1 vssd1 vccd1 vccd1 _4345_/A sky130_fd_sc_hd__nand3_1
XFILLER_0_78_89 vssd1 vssd1 vccd1 vccd1 sky130_fd_sc_hd__decap_3
XFILLER_0_1_366 vssd1 vssd1 vccd1 vccd1 sky130_fd_sc_hd__fill_2
X_4273_ _4816_/A _4736_/B _4736_/D _4776_/A vssd1 vssd1 vccd1 vccd1 _4274_/B sky130_fd_sc_hd__and4_1
X_6012_ tex_height_i[10] _6016_/C vssd1 vssd1 vccd1 vccd1 _6012_/Y sky130_fd_sc_hd__xnor2_1
.ends
