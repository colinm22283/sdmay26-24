* NGSPICE file created from spi_mem_m.ext - technology: sky130A

* Black-box entry subcircuit for sky130_fd_sc_hd__tapvpwrvgnd_1 abstract view
.subckt sky130_fd_sc_hd__tapvpwrvgnd_1 VGND VPWR
.ends

* Black-box entry subcircuit for sky130_ef_sc_hd__decap_12 abstract view
.subckt sky130_ef_sc_hd__decap_12 VGND VNB VPB VPWR
.ends

* Black-box entry subcircuit for sky130_fd_sc_hd__diode_2 abstract view
.subckt sky130_fd_sc_hd__diode_2 DIODE VGND VNB VPB VPWR
.ends

* Black-box entry subcircuit for sky130_fd_sc_hd__decap_4 abstract view
.subckt sky130_fd_sc_hd__decap_4 VGND VNB VPB VPWR
.ends

* Black-box entry subcircuit for sky130_fd_sc_hd__o21ai_1 abstract view
.subckt sky130_fd_sc_hd__o21ai_1 A1 A2 B1 VGND VNB VPB VPWR Y
.ends

* Black-box entry subcircuit for sky130_fd_sc_hd__inv_2 abstract view
.subckt sky130_fd_sc_hd__inv_2 A VGND VNB VPB VPWR Y
.ends

* Black-box entry subcircuit for sky130_fd_sc_hd__dfrtp_1 abstract view
.subckt sky130_fd_sc_hd__dfrtp_1 CLK D RESET_B VGND VNB VPB VPWR Q
.ends

* Black-box entry subcircuit for sky130_fd_sc_hd__clkbuf_8 abstract view
.subckt sky130_fd_sc_hd__clkbuf_8 A VGND VNB VPB VPWR X
.ends

* Black-box entry subcircuit for sky130_fd_sc_hd__nand2_1 abstract view
.subckt sky130_fd_sc_hd__nand2_1 A B VGND VNB VPB VPWR Y
.ends

* Black-box entry subcircuit for sky130_fd_sc_hd__dlygate4sd3_1 abstract view
.subckt sky130_fd_sc_hd__dlygate4sd3_1 A VGND VNB VPB VPWR X
.ends

* Black-box entry subcircuit for sky130_fd_sc_hd__or2_1 abstract view
.subckt sky130_fd_sc_hd__or2_1 A B VGND VNB VPB VPWR X
.ends

* Black-box entry subcircuit for sky130_fd_sc_hd__nand2_4 abstract view
.subckt sky130_fd_sc_hd__nand2_4 A B VGND VNB VPB VPWR Y
.ends

* Black-box entry subcircuit for sky130_fd_sc_hd__fill_1 abstract view
.subckt sky130_fd_sc_hd__fill_1 VGND VNB VPB VPWR
.ends

* Black-box entry subcircuit for sky130_fd_sc_hd__fill_2 abstract view
.subckt sky130_fd_sc_hd__fill_2 VGND VNB VPB VPWR
.ends

* Black-box entry subcircuit for sky130_fd_sc_hd__decap_3 abstract view
.subckt sky130_fd_sc_hd__decap_3 VGND VNB VPB VPWR
.ends

* Black-box entry subcircuit for sky130_fd_sc_hd__nand3_1 abstract view
.subckt sky130_fd_sc_hd__nand3_1 A B C VGND VNB VPB VPWR Y
.ends

* Black-box entry subcircuit for sky130_fd_sc_hd__o2bb2ai_1 abstract view
.subckt sky130_fd_sc_hd__o2bb2ai_1 A1_N A2_N B1 B2 VGND VNB VPB VPWR Y
.ends

* Black-box entry subcircuit for sky130_fd_sc_hd__clkbuf_1 abstract view
.subckt sky130_fd_sc_hd__clkbuf_1 A VGND VNB VPB VPWR X
.ends

* Black-box entry subcircuit for sky130_fd_sc_hd__and3_1 abstract view
.subckt sky130_fd_sc_hd__and3_1 A B C VGND VNB VPB VPWR X
.ends

* Black-box entry subcircuit for sky130_fd_sc_hd__nor2_4 abstract view
.subckt sky130_fd_sc_hd__nor2_4 A B VGND VNB VPB VPWR Y
.ends

* Black-box entry subcircuit for sky130_fd_sc_hd__buf_1 abstract view
.subckt sky130_fd_sc_hd__buf_1 A VGND VNB VPB VPWR X
.ends

* Black-box entry subcircuit for sky130_fd_sc_hd__dlymetal6s2s_1 abstract view
.subckt sky130_fd_sc_hd__dlymetal6s2s_1 A VGND VNB VPB VPWR X
.ends

* Black-box entry subcircuit for sky130_fd_sc_hd__clkbuf_2 abstract view
.subckt sky130_fd_sc_hd__clkbuf_2 A VGND VNB VPB VPWR X
.ends

* Black-box entry subcircuit for sky130_fd_sc_hd__decap_8 abstract view
.subckt sky130_fd_sc_hd__decap_8 VGND VNB VPB VPWR
.ends

* Black-box entry subcircuit for sky130_fd_sc_hd__buf_12 abstract view
.subckt sky130_fd_sc_hd__buf_12 A VGND VNB VPB VPWR X
.ends

* Black-box entry subcircuit for sky130_fd_sc_hd__nor2_1 abstract view
.subckt sky130_fd_sc_hd__nor2_1 A B VGND VNB VPB VPWR Y
.ends

* Black-box entry subcircuit for sky130_fd_sc_hd__dfrtp_2 abstract view
.subckt sky130_fd_sc_hd__dfrtp_2 CLK D RESET_B VGND VNB VPB VPWR Q
.ends

* Black-box entry subcircuit for sky130_fd_sc_hd__buf_6 abstract view
.subckt sky130_fd_sc_hd__buf_6 A VGND VNB VPB VPWR X
.ends

* Black-box entry subcircuit for sky130_fd_sc_hd__nor3_1 abstract view
.subckt sky130_fd_sc_hd__nor3_1 A B C VGND VNB VPB VPWR Y
.ends

* Black-box entry subcircuit for sky130_fd_sc_hd__a21o_1 abstract view
.subckt sky130_fd_sc_hd__a21o_1 A1 A2 B1 VGND VNB VPB VPWR X
.ends

* Black-box entry subcircuit for sky130_fd_sc_hd__mux2_1 abstract view
.subckt sky130_fd_sc_hd__mux2_1 A0 A1 S VGND VNB VPB VPWR X
.ends

* Black-box entry subcircuit for sky130_fd_sc_hd__decap_6 abstract view
.subckt sky130_fd_sc_hd__decap_6 VGND VNB VPB VPWR
.ends

* Black-box entry subcircuit for sky130_fd_sc_hd__inv_4 abstract view
.subckt sky130_fd_sc_hd__inv_4 A VGND VNB VPB VPWR Y
.ends

* Black-box entry subcircuit for sky130_fd_sc_hd__nand2_2 abstract view
.subckt sky130_fd_sc_hd__nand2_2 A B VGND VNB VPB VPWR Y
.ends

* Black-box entry subcircuit for sky130_fd_sc_hd__and2_1 abstract view
.subckt sky130_fd_sc_hd__and2_1 A B VGND VNB VPB VPWR X
.ends

* Black-box entry subcircuit for sky130_fd_sc_hd__a22oi_1 abstract view
.subckt sky130_fd_sc_hd__a22oi_1 A1 A2 B1 B2 VGND VNB VPB VPWR Y
.ends

* Black-box entry subcircuit for sky130_fd_sc_hd__or2b_1 abstract view
.subckt sky130_fd_sc_hd__or2b_1 A B_N VGND VNB VPB VPWR X
.ends

* Black-box entry subcircuit for sky130_fd_sc_hd__buf_2 abstract view
.subckt sky130_fd_sc_hd__buf_2 A VGND VNB VPB VPWR X
.ends

* Black-box entry subcircuit for sky130_fd_sc_hd__nor2_2 abstract view
.subckt sky130_fd_sc_hd__nor2_2 A B VGND VNB VPB VPWR Y
.ends

* Black-box entry subcircuit for sky130_fd_sc_hd__o2bb2a_1 abstract view
.subckt sky130_fd_sc_hd__o2bb2a_1 A1_N A2_N B1 B2 VGND VNB VPB VPWR X
.ends

* Black-box entry subcircuit for sky130_fd_sc_hd__a22o_1 abstract view
.subckt sky130_fd_sc_hd__a22o_1 A1 A2 B1 B2 VGND VNB VPB VPWR X
.ends

* Black-box entry subcircuit for sky130_fd_sc_hd__a31o_1 abstract view
.subckt sky130_fd_sc_hd__a31o_1 A1 A2 A3 B1 VGND VNB VPB VPWR X
.ends

* Black-box entry subcircuit for sky130_fd_sc_hd__clkinv_4 abstract view
.subckt sky130_fd_sc_hd__clkinv_4 A VGND VNB VPB VPWR Y
.ends

* Black-box entry subcircuit for sky130_fd_sc_hd__o2111ai_1 abstract view
.subckt sky130_fd_sc_hd__o2111ai_1 A1 A2 B1 C1 D1 VGND VNB VPB VPWR Y
.ends

* Black-box entry subcircuit for sky130_fd_sc_hd__clkbuf_16 abstract view
.subckt sky130_fd_sc_hd__clkbuf_16 A VGND VNB VPB VPWR X
.ends

* Black-box entry subcircuit for sky130_fd_sc_hd__a21oi_1 abstract view
.subckt sky130_fd_sc_hd__a21oi_1 A1 A2 B1 VGND VNB VPB VPWR Y
.ends

* Black-box entry subcircuit for sky130_fd_sc_hd__o211a_1 abstract view
.subckt sky130_fd_sc_hd__o211a_1 A1 A2 B1 C1 VGND VNB VPB VPWR X
.ends

* Black-box entry subcircuit for sky130_fd_sc_hd__nand3b_1 abstract view
.subckt sky130_fd_sc_hd__nand3b_1 A_N B C VGND VNB VPB VPWR Y
.ends

* Black-box entry subcircuit for sky130_fd_sc_hd__inv_6 abstract view
.subckt sky130_fd_sc_hd__inv_6 A VGND VNB VPB VPWR Y
.ends

* Black-box entry subcircuit for sky130_fd_sc_hd__or3b_1 abstract view
.subckt sky130_fd_sc_hd__or3b_1 A B C_N VGND VNB VPB VPWR X
.ends

* Black-box entry subcircuit for sky130_fd_sc_hd__buf_4 abstract view
.subckt sky130_fd_sc_hd__buf_4 A VGND VNB VPB VPWR X
.ends

* Black-box entry subcircuit for sky130_fd_sc_hd__dfstp_1 abstract view
.subckt sky130_fd_sc_hd__dfstp_1 CLK D SET_B VGND VNB VPB VPWR Q
.ends

* Black-box entry subcircuit for sky130_fd_sc_hd__o21a_1 abstract view
.subckt sky130_fd_sc_hd__o21a_1 A1 A2 B1 VGND VNB VPB VPWR X
.ends

* Black-box entry subcircuit for sky130_fd_sc_hd__a211o_1 abstract view
.subckt sky130_fd_sc_hd__a211o_1 A1 A2 B1 C1 VGND VNB VPB VPWR X
.ends

* Black-box entry subcircuit for sky130_fd_sc_hd__a21oi_4 abstract view
.subckt sky130_fd_sc_hd__a21oi_4 A1 A2 B1 VGND VNB VPB VPWR Y
.ends

* Black-box entry subcircuit for sky130_fd_sc_hd__dfstp_2 abstract view
.subckt sky130_fd_sc_hd__dfstp_2 CLK D SET_B VGND VNB VPB VPWR Q
.ends

* Black-box entry subcircuit for sky130_fd_sc_hd__clkinvlp_2 abstract view
.subckt sky130_fd_sc_hd__clkinvlp_2 A VGND VNB VPB VPWR Y
.ends

* Black-box entry subcircuit for sky130_fd_sc_hd__o22ai_1 abstract view
.subckt sky130_fd_sc_hd__o22ai_1 A1 A2 B1 B2 VGND VNB VPB VPWR Y
.ends

* Black-box entry subcircuit for sky130_fd_sc_hd__o211ai_4 abstract view
.subckt sky130_fd_sc_hd__o211ai_4 A1 A2 B1 C1 VGND VNB VPB VPWR Y
.ends

* Black-box entry subcircuit for sky130_fd_sc_hd__dfrtp_4 abstract view
.subckt sky130_fd_sc_hd__dfrtp_4 CLK D RESET_B VGND VNB VPB VPWR Q
.ends

* Black-box entry subcircuit for sky130_fd_sc_hd__nand3_2 abstract view
.subckt sky130_fd_sc_hd__nand3_2 A B C VGND VNB VPB VPWR Y
.ends

* Black-box entry subcircuit for sky130_fd_sc_hd__o31ai_4 abstract view
.subckt sky130_fd_sc_hd__o31ai_4 A1 A2 A3 B1 VGND VNB VPB VPWR Y
.ends

* Black-box entry subcircuit for sky130_fd_sc_hd__o22a_1 abstract view
.subckt sky130_fd_sc_hd__o22a_1 A1 A2 B1 B2 VGND VNB VPB VPWR X
.ends

* Black-box entry subcircuit for sky130_fd_sc_hd__o211ai_1 abstract view
.subckt sky130_fd_sc_hd__o211ai_1 A1 A2 B1 C1 VGND VNB VPB VPWR Y
.ends

* Black-box entry subcircuit for sky130_fd_sc_hd__o21bai_1 abstract view
.subckt sky130_fd_sc_hd__o21bai_1 A1 A2 B1_N VGND VNB VPB VPWR Y
.ends

* Black-box entry subcircuit for sky130_fd_sc_hd__clkdlybuf4s25_1 abstract view
.subckt sky130_fd_sc_hd__clkdlybuf4s25_1 A VGND VNB VPB VPWR X
.ends

* Black-box entry subcircuit for sky130_fd_sc_hd__nor3_2 abstract view
.subckt sky130_fd_sc_hd__nor3_2 A B C VGND VNB VPB VPWR Y
.ends

* Black-box entry subcircuit for sky130_fd_sc_hd__o21ai_2 abstract view
.subckt sky130_fd_sc_hd__o21ai_2 A1 A2 B1 VGND VNB VPB VPWR Y
.ends

.subckt spi_mem_m clk_i nrst_i spi_clk_o spi_cs_o spi_dqsm_en_o spi_dqsm_i spi_dqsm_o
+ spi_miso_i[0] spi_miso_i[1] spi_miso_i[2] spi_miso_i[3] spi_mosi_o[0] spi_mosi_o[1]
+ spi_mosi_o[2] spi_mosi_o[3] spi_sio_en_o[0] spi_sio_en_o[1] spi_sio_en_o[2] spi_sio_en_o[3]
+ sport_i[0] sport_i[10] sport_i[11] sport_i[12] sport_i[13] sport_i[14] sport_i[15]
+ sport_i[16] sport_i[17] sport_i[18] sport_i[19] sport_i[1] sport_i[20] sport_i[21]
+ sport_i[22] sport_i[23] sport_i[24] sport_i[25] sport_i[26] sport_i[27] sport_i[28]
+ sport_i[29] sport_i[2] sport_i[30] sport_i[31] sport_i[32] sport_i[33] sport_i[34]
+ sport_i[35] sport_i[36] sport_i[37] sport_i[38] sport_i[39] sport_i[3] sport_i[40]
+ sport_i[41] sport_i[42] sport_i[43] sport_i[44] sport_i[45] sport_i[46] sport_i[47]
+ sport_i[48] sport_i[49] sport_i[4] sport_i[50] sport_i[51] sport_i[52] sport_i[53]
+ sport_i[54] sport_i[55] sport_i[56] sport_i[57] sport_i[58] sport_i[59] sport_i[5]
+ sport_i[60] sport_i[61] sport_i[62] sport_i[63] sport_i[64] sport_i[65] sport_i[66]
+ sport_i[67] sport_i[68] sport_i[6] sport_i[7] sport_i[8] sport_i[9] sport_o[0] sport_o[10]
+ sport_o[11] sport_o[12] sport_o[13] sport_o[14] sport_o[15] sport_o[16] sport_o[17]
+ sport_o[18] sport_o[19] sport_o[1] sport_o[20] sport_o[21] sport_o[22] sport_o[23]
+ sport_o[24] sport_o[25] sport_o[26] sport_o[27] sport_o[28] sport_o[29] sport_o[2]
+ sport_o[30] sport_o[31] sport_o[32] sport_o[33] sport_o[3] sport_o[4] sport_o[5]
+ sport_o[6] sport_o[7] sport_o[8] sport_o[9] vccd1 vssd1
XTAP_177 vssd1 vccd1 sky130_fd_sc_hd__tapvpwrvgnd_1
XTAP_188 vssd1 vccd1 sky130_fd_sc_hd__tapvpwrvgnd_1
XTAP_199 vssd1 vccd1 sky130_fd_sc_hd__tapvpwrvgnd_1
XFILLER_0_7_81 vssd1 vssd1 vccd1 vccd1 sky130_ef_sc_hd__decap_12
XFILLER_0_4_171 vssd1 vssd1 vccd1 vccd1 sky130_ef_sc_hd__decap_12
XANTENNA__1466__RESET_B fanout125/X vssd1 vssd1 vccd1 vccd1 sky130_fd_sc_hd__diode_2
XFILLER_0_31_291 vssd1 vssd1 vccd1 vccd1 sky130_fd_sc_hd__decap_4
X_1270_ _1281_/A _1235_/B _1269_/Y vssd1 vssd1 vccd1 vccd1 _1270_/Y sky130_fd_sc_hd__o21ai_1
X_0985_ _0985_/A vssd1 vssd1 vccd1 vccd1 _1182_/A sky130_fd_sc_hd__inv_2
XFILLER_0_14_236 vssd1 vssd1 vccd1 vccd1 sky130_fd_sc_hd__decap_4
X_1468_ _1541_/CLK _1468_/D fanout125/X vssd1 vssd1 vccd1 vccd1 _1468_/Q sky130_fd_sc_hd__dfrtp_1
X_1537_ _1537_/CLK _1537_/D fanout129/X vssd1 vssd1 vccd1 vccd1 _1537_/Q sky130_fd_sc_hd__dfrtp_1
Xfanout127 fanout129/X vssd1 vssd1 vccd1 vccd1 fanout127/X sky130_fd_sc_hd__clkbuf_8
XANTENNA__1073__B _1073_/B vssd1 vssd1 vccd1 vccd1 sky130_fd_sc_hd__diode_2
X_1399_ _1418_/A _1399_/B vssd1 vssd1 vccd1 vccd1 _1400_/B sky130_fd_sc_hd__nand2_1
Xhold181 _1534_/Q vssd1 vssd1 vccd1 vccd1 hold45/A sky130_fd_sc_hd__dlygate4sd3_1
Xhold170 _1509_/Q vssd1 vssd1 vccd1 vccd1 _0743_/A sky130_fd_sc_hd__dlygate4sd3_1
Xhold192 _1515_/Q vssd1 vssd1 vccd1 vccd1 hold43/A sky130_fd_sc_hd__dlygate4sd3_1
XFILLER_0_18_29 vssd1 vssd1 vccd1 vccd1 sky130_ef_sc_hd__decap_12
X_0770_ hold19/X vssd1 vssd1 vccd1 vccd1 _1162_/B sky130_fd_sc_hd__inv_2
X_1322_ _1422_/A hold81/X vssd1 vssd1 vccd1 vccd1 _1328_/A sky130_fd_sc_hd__nand2_1
X_1253_ _1262_/B _1253_/B vssd1 vssd1 vccd1 vccd1 _1315_/A sky130_fd_sc_hd__or2_1
X_1184_ _1184_/A _1262_/B vssd1 vssd1 vccd1 vccd1 _1345_/A sky130_fd_sc_hd__nand2_4
XANTENNA__0952__S _0966_/S vssd1 vssd1 vccd1 vccd1 sky130_fd_sc_hd__diode_2
XANTENNA_fanout125_A fanout126/X vssd1 vssd1 vccd1 vccd1 sky130_fd_sc_hd__diode_2
X_0968_ _1047_/A vssd1 vssd1 vccd1 vccd1 _0969_/B sky130_fd_sc_hd__inv_2
XFILLER_0_24_83 vssd1 vssd1 vccd1 vccd1 sky130_fd_sc_hd__fill_1
XFILLER_0_10_261 vssd1 vssd1 vccd1 vccd1 sky130_fd_sc_hd__fill_2
X_0899_ _0899_/A hold60/X vssd1 vssd1 vccd1 vccd1 hold61/A sky130_fd_sc_hd__nand2_1
XFILLER_0_10_283 vssd1 vssd1 vccd1 vccd1 sky130_fd_sc_hd__decap_3
XFILLER_0_45_180 vssd1 vssd1 vccd1 vccd1 sky130_fd_sc_hd__fill_1
XFILLER_0_36_180 vssd1 vssd1 vccd1 vccd1 sky130_fd_sc_hd__fill_2
X_0822_ _0822_/A _0822_/B _0872_/A vssd1 vssd1 vccd1 vccd1 _0970_/B sky130_fd_sc_hd__nand3_1
X_0753_ _0753_/A _1471_/Q vssd1 vssd1 vccd1 vccd1 _0754_/B sky130_fd_sc_hd__nand2_1
X_1236_ hold43/X _1221_/Y _1223_/Y _1299_/A vssd1 vssd1 vccd1 vccd1 _1237_/A sky130_fd_sc_hd__o2bb2ai_1
X_1305_ _1313_/A hold46/X vssd1 vssd1 vccd1 vccd1 _1312_/A sky130_fd_sc_hd__nand2_1
X_1098_ _1098_/A vssd1 vssd1 vccd1 vccd1 _1483_/D sky130_fd_sc_hd__clkbuf_1
X_1167_ _1167_/A _1167_/B _1167_/C vssd1 vssd1 vccd1 vccd1 _1168_/S sky130_fd_sc_hd__and3_1
XFILLER_0_34_139 vssd1 vssd1 vccd1 vccd1 sky130_fd_sc_hd__fill_1
XFILLER_0_34_106 vssd1 vssd1 vccd1 vccd1 sky130_fd_sc_hd__fill_2
XFILLER_0_19_169 vssd1 vssd1 vccd1 vccd1 sky130_fd_sc_hd__decap_3
XFILLER_0_42_194 vssd1 vssd1 vccd1 vccd1 sky130_fd_sc_hd__fill_2
XFILLER_0_25_117 vssd1 vssd1 vccd1 vccd1 sky130_fd_sc_hd__fill_1
XFILLER_0_40_109 vssd1 vssd1 vccd1 vccd1 sky130_fd_sc_hd__fill_1
XFILLER_0_33_150 vssd1 vssd1 vccd1 vccd1 sky130_fd_sc_hd__fill_1
XFILLER_0_0_217 vssd1 vssd1 vccd1 vccd1 sky130_fd_sc_hd__fill_2
X_1021_ _1021_/A _1021_/B vssd1 vssd1 vccd1 vccd1 _1022_/B sky130_fd_sc_hd__nand2_1
X_0805_ _1046_/A _0805_/B vssd1 vssd1 vccd1 vccd1 _1222_/A sky130_fd_sc_hd__nor2_4
XFILLER_0_24_150 vssd1 vssd1 vccd1 vccd1 sky130_fd_sc_hd__fill_1
XFILLER_0_21_95 vssd1 vssd1 vccd1 vccd1 sky130_fd_sc_hd__fill_1
X_0736_ _0736_/A vssd1 vssd1 vccd1 vccd1 _0736_/X sky130_fd_sc_hd__buf_1
X_1219_ _1219_/A _1219_/B vssd1 vssd1 vccd1 vccd1 _1219_/Y sky130_fd_sc_hd__nand2_1
XFILLER_0_1_83 vssd1 vssd1 vccd1 vccd1 sky130_fd_sc_hd__fill_1
XANTENNA__1256__B _1256_/B vssd1 vssd1 vccd1 vccd1 sky130_fd_sc_hd__diode_2
XFILLER_0_22_109 vssd1 vssd1 vccd1 vccd1 sky130_fd_sc_hd__fill_1
Xhold63 hold63/A vssd1 vssd1 vccd1 vccd1 hold63/X sky130_fd_sc_hd__dlymetal6s2s_1
XFILLER_0_30_197 vssd1 vssd1 vccd1 vccd1 sky130_ef_sc_hd__decap_12
Xhold30 hold30/A vssd1 vssd1 vccd1 vccd1 hold30/X sky130_fd_sc_hd__dlygate4sd3_1
Xhold52 hold52/A vssd1 vssd1 vccd1 vccd1 hold52/X sky130_fd_sc_hd__dlygate4sd3_1
Xhold41 hold41/A vssd1 vssd1 vccd1 vccd1 hold41/X sky130_fd_sc_hd__clkbuf_2
Xhold74 hold74/A vssd1 vssd1 vccd1 vccd1 hold74/X sky130_fd_sc_hd__buf_1
XANTENNA__1272__A _1401_/A vssd1 vssd1 vccd1 vccd1 sky130_fd_sc_hd__diode_2
Xhold96 hold96/A vssd1 vssd1 vccd1 vccd1 hold96/X sky130_fd_sc_hd__dlygate4sd3_1
Xhold85 hold85/A vssd1 vssd1 vccd1 vccd1 hold85/X sky130_fd_sc_hd__dlygate4sd3_1
XFILLER_0_38_253 vssd1 vssd1 vccd1 vccd1 sky130_ef_sc_hd__decap_12
XTAP_337 vssd1 vccd1 sky130_fd_sc_hd__tapvpwrvgnd_1
XTAP_326 vssd1 vccd1 sky130_fd_sc_hd__tapvpwrvgnd_1
XTAP_315 vssd1 vccd1 sky130_fd_sc_hd__tapvpwrvgnd_1
XTAP_304 vssd1 vccd1 sky130_fd_sc_hd__tapvpwrvgnd_1
XFILLER_0_21_120 vssd1 vssd1 vccd1 vccd1 sky130_fd_sc_hd__fill_2
XFILLER_0_21_142 vssd1 vssd1 vccd1 vccd1 sky130_ef_sc_hd__decap_12
XFILLER_0_21_164 vssd1 vssd1 vccd1 vccd1 sky130_fd_sc_hd__decap_4
XFILLER_0_21_186 vssd1 vssd1 vccd1 vccd1 sky130_ef_sc_hd__decap_12
XFILLER_0_20_9 vssd1 vssd1 vccd1 vccd1 sky130_fd_sc_hd__decap_3
XANTENNA__0960__S _0966_/S vssd1 vssd1 vccd1 vccd1 sky130_fd_sc_hd__diode_2
XFILLER_0_29_264 vssd1 vssd1 vccd1 vccd1 sky130_ef_sc_hd__decap_12
XFILLER_0_8_158 vssd1 vssd1 vccd1 vccd1 sky130_fd_sc_hd__fill_1
X_1004_ _1004_/A vssd1 vssd1 vccd1 vccd1 _1005_/B sky130_fd_sc_hd__inv_2
XANTENNA__1076__B _1426_/B vssd1 vssd1 vccd1 vccd1 sky130_fd_sc_hd__diode_2
XFILLER_0_12_164 vssd1 vssd1 vccd1 vccd1 sky130_ef_sc_hd__decap_12
XANTENNA__1513__RESET_B fanout125/X vssd1 vssd1 vccd1 vccd1 sky130_fd_sc_hd__diode_2
X_0719_ _0734_/B _1077_/B vssd1 vssd1 vccd1 vccd1 _0814_/A sky130_fd_sc_hd__nand2_4
XFILLER_0_12_197 vssd1 vssd1 vccd1 vccd1 sky130_fd_sc_hd__decap_8
XFILLER_0_35_234 vssd1 vssd1 vccd1 vccd1 sky130_fd_sc_hd__fill_2
XFILLER_0_7_180 vssd1 vssd1 vccd1 vccd1 sky130_fd_sc_hd__fill_1
Xoutput97 _1457_/Q vssd1 vssd1 vccd1 vccd1 sport_o[18] sky130_fd_sc_hd__buf_12
Xoutput86 _1544_/X vssd1 vssd1 vccd1 vccd1 spi_sio_en_o[2] sky130_fd_sc_hd__buf_12
XFILLER_0_37_39 vssd1 vssd1 vccd1 vccd1 sky130_fd_sc_hd__fill_1
XFILLER_0_26_201 vssd1 vssd1 vccd1 vccd1 sky130_fd_sc_hd__fill_1
XTAP_134 vssd1 vccd1 sky130_fd_sc_hd__tapvpwrvgnd_1
XTAP_123 vssd1 vccd1 sky130_fd_sc_hd__tapvpwrvgnd_1
X_1484_ _1521_/CLK _1484_/D fanout122/X vssd1 vssd1 vccd1 vccd1 _1484_/Q sky130_fd_sc_hd__dfrtp_1
XTAP_112 vssd1 vccd1 sky130_fd_sc_hd__tapvpwrvgnd_1
XTAP_101 vssd1 vccd1 sky130_fd_sc_hd__tapvpwrvgnd_1
XTAP_145 vssd1 vccd1 sky130_fd_sc_hd__tapvpwrvgnd_1
XTAP_156 vssd1 vccd1 sky130_fd_sc_hd__tapvpwrvgnd_1
XTAP_167 vssd1 vccd1 sky130_fd_sc_hd__tapvpwrvgnd_1
XTAP_178 vssd1 vccd1 sky130_fd_sc_hd__tapvpwrvgnd_1
XTAP_189 vssd1 vccd1 sky130_fd_sc_hd__tapvpwrvgnd_1
Xclkbuf_4_12_0_clk_i clkbuf_0_clk_i/X vssd1 vssd1 vccd1 vccd1 _1540_/CLK sky130_fd_sc_hd__clkbuf_8
XFILLER_0_17_212 vssd1 vssd1 vccd1 vccd1 sky130_fd_sc_hd__fill_2
XFILLER_0_17_223 vssd1 vssd1 vccd1 vccd1 sky130_fd_sc_hd__fill_1
XFILLER_0_7_93 vssd1 vssd1 vccd1 vccd1 sky130_fd_sc_hd__decap_3
XFILLER_0_4_183 vssd1 vssd1 vccd1 vccd1 sky130_fd_sc_hd__decap_8
XANTENNA__1435__RESET_B fanout127/X vssd1 vssd1 vccd1 vccd1 sky130_fd_sc_hd__diode_2
X_0984_ _0984_/A hold27/A vssd1 vssd1 vccd1 vccd1 _0990_/B sky130_fd_sc_hd__nor2_1
X_1536_ _1537_/CLK _1536_/D fanout128/X vssd1 vssd1 vccd1 vccd1 _1536_/Q sky130_fd_sc_hd__dfrtp_1
XFILLER_0_14_215 vssd1 vssd1 vccd1 vccd1 sky130_fd_sc_hd__fill_1
X_1467_ _1541_/CLK _1467_/D fanout125/X vssd1 vssd1 vccd1 vccd1 _1467_/Q sky130_fd_sc_hd__dfrtp_2
XFILLER_0_38_93 vssd1 vssd1 vccd1 vccd1 sky130_fd_sc_hd__fill_1
X_1398_ _1398_/A _1398_/B vssd1 vssd1 vccd1 vccd1 _1400_/A sky130_fd_sc_hd__nand2_1
XFILLER_0_1_197 vssd1 vssd1 vccd1 vccd1 sky130_fd_sc_hd__fill_1
Xfanout128 fanout129/X vssd1 vssd1 vccd1 vccd1 fanout128/X sky130_fd_sc_hd__clkbuf_8
Xhold182 _1536_/Q vssd1 vssd1 vccd1 vccd1 hold67/A sky130_fd_sc_hd__dlygate4sd3_1
Xhold193 _1541_/Q vssd1 vssd1 vccd1 vccd1 hold48/A sky130_fd_sc_hd__dlygate4sd3_1
Xhold171 _1181_/Y vssd1 vssd1 vccd1 vccd1 _1509_/D sky130_fd_sc_hd__dlygate4sd3_1
Xhold160 _1456_/Q vssd1 vssd1 vccd1 vccd1 hold160/X sky130_fd_sc_hd__dlygate4sd3_1
XFILLER_0_11_207 vssd1 vssd1 vccd1 vccd1 sky130_fd_sc_hd__decap_4
X_1321_ _1321_/A vssd1 vssd1 vccd1 vccd1 _1422_/A sky130_fd_sc_hd__buf_6
X_1252_ _1252_/A _1433_/Q vssd1 vssd1 vccd1 vccd1 _1253_/B sky130_fd_sc_hd__nand2_1
X_1183_ _1183_/A _1397_/S _1183_/C vssd1 vssd1 vccd1 vccd1 _1183_/Y sky130_fd_sc_hd__nor3_1
X_0967_ _0967_/A vssd1 vssd1 vccd1 vccd1 _1470_/D sky130_fd_sc_hd__clkbuf_1
X_0898_ _0898_/A hold59/X vssd1 vssd1 vccd1 vccd1 hold60/A sky130_fd_sc_hd__nand2_1
X_1519_ _1521_/CLK _1519_/D fanout123/X vssd1 vssd1 vccd1 vccd1 _1519_/Q sky130_fd_sc_hd__dfrtp_1
XFILLER_0_4_50 vssd1 vssd1 vccd1 vccd1 sky130_fd_sc_hd__fill_1
XFILLER_0_29_18 vssd1 vssd1 vccd1 vccd1 sky130_fd_sc_hd__decap_3
XFILLER_0_36_192 vssd1 vssd1 vccd1 vccd1 sky130_fd_sc_hd__fill_2
X_0752_ hold16/X _1398_/B hold27/X vssd1 vssd1 vccd1 vccd1 _1438_/D sky130_fd_sc_hd__a21o_1
X_0821_ _1129_/S _0821_/B vssd1 vssd1 vccd1 vccd1 _0826_/A sky130_fd_sc_hd__or2_1
XANTENNA__1538__RESET_B fanout128/X vssd1 vssd1 vccd1 vccd1 sky130_fd_sc_hd__diode_2
X_1166_ _1164_/Y _1165_/A hold20/X vssd1 vssd1 vccd1 vccd1 hold21/A sky130_fd_sc_hd__o21ai_1
X_1304_ _1304_/A _1304_/B vssd1 vssd1 vccd1 vccd1 hold77/A sky130_fd_sc_hd__nand2_1
X_1235_ _1262_/B _1235_/B vssd1 vssd1 vccd1 vccd1 _1299_/A sky130_fd_sc_hd__or2_1
X_1097_ hold101/X _0998_/C _1117_/S vssd1 vssd1 vccd1 vccd1 _1098_/A sky130_fd_sc_hd__mux2_1
XFILLER_0_19_104 vssd1 vssd1 vccd1 vccd1 sky130_fd_sc_hd__fill_2
XFILLER_0_27_181 vssd1 vssd1 vccd1 vccd1 sky130_ef_sc_hd__decap_12
XFILLER_0_33_195 vssd1 vssd1 vccd1 vccd1 sky130_fd_sc_hd__fill_2
X_1020_ _1020_/A vssd1 vssd1 vccd1 vccd1 _1021_/B sky130_fd_sc_hd__inv_2
X_0804_ _1351_/A _1530_/Q vssd1 vssd1 vccd1 vccd1 _0804_/Y sky130_fd_sc_hd__nand2_1
X_0735_ _0734_/Y _0759_/B _1474_/Q vssd1 vssd1 vccd1 vccd1 _0736_/A sky130_fd_sc_hd__mux2_1
XANTENNA__0958__S _0966_/S vssd1 vssd1 vccd1 vccd1 sky130_fd_sc_hd__diode_2
X_1218_ _1218_/A _1426_/A _1334_/C vssd1 vssd1 vccd1 vccd1 _1219_/B sky130_fd_sc_hd__nand3_1
X_1149_ _1152_/A _1148_/Y _1170_/A vssd1 vssd1 vccd1 vccd1 _1149_/X sky130_fd_sc_hd__a21o_1
XFILLER_0_30_121 vssd1 vssd1 vccd1 vccd1 sky130_fd_sc_hd__fill_2
XFILLER_0_30_110 vssd1 vssd1 vccd1 vccd1 sky130_fd_sc_hd__decap_3
XFILLER_0_15_173 vssd1 vssd1 vccd1 vccd1 sky130_fd_sc_hd__fill_1
Xhold53 hold53/A vssd1 vssd1 vccd1 vccd1 hold53/X sky130_fd_sc_hd__buf_1
Xhold64 hold64/A vssd1 vssd1 vccd1 vccd1 hold64/X sky130_fd_sc_hd__dlygate4sd3_1
Xhold20 hold20/A vssd1 vssd1 vccd1 vccd1 hold20/X sky130_fd_sc_hd__dlygate4sd3_1
Xhold31 hold31/A vssd1 vssd1 vccd1 vccd1 hold31/X sky130_fd_sc_hd__dlygate4sd3_1
Xhold86 hold86/A vssd1 vssd1 vccd1 vccd1 hold86/X sky130_fd_sc_hd__dlygate4sd3_1
Xhold97 hold97/A vssd1 vssd1 vccd1 vccd1 hold97/X sky130_fd_sc_hd__dlygate4sd3_1
Xhold42 hold42/A vssd1 vssd1 vccd1 vccd1 hold42/X sky130_fd_sc_hd__dlygate4sd3_1
Xhold75 hold75/A vssd1 vssd1 vccd1 vccd1 hold75/X sky130_fd_sc_hd__dlygate4sd3_1
XFILLER_0_38_265 vssd1 vssd1 vccd1 vccd1 sky130_fd_sc_hd__decap_6
XTAP_338 vssd1 vccd1 sky130_fd_sc_hd__tapvpwrvgnd_1
XTAP_327 vssd1 vccd1 sky130_fd_sc_hd__tapvpwrvgnd_1
XTAP_316 vssd1 vccd1 sky130_fd_sc_hd__tapvpwrvgnd_1
XTAP_305 vssd1 vccd1 sky130_fd_sc_hd__tapvpwrvgnd_1
XFILLER_0_21_154 vssd1 vssd1 vccd1 vccd1 sky130_fd_sc_hd__decap_3
XFILLER_0_21_198 vssd1 vssd1 vccd1 vccd1 sky130_fd_sc_hd__decap_6
XFILLER_0_16_85 vssd1 vssd1 vccd1 vccd1 sky130_fd_sc_hd__fill_1
X_1003_ _1003_/A vssd1 vssd1 vccd1 vccd1 _1005_/A sky130_fd_sc_hd__inv_2
XFILLER_0_29_276 vssd1 vssd1 vccd1 vccd1 sky130_fd_sc_hd__decap_4
X_0718_ _1071_/B vssd1 vssd1 vccd1 vccd1 _0734_/B sky130_fd_sc_hd__inv_4
XFILLER_0_12_176 vssd1 vssd1 vccd1 vccd1 sky130_fd_sc_hd__decap_8
XFILLER_0_12_187 vssd1 vssd1 vccd1 vccd1 sky130_fd_sc_hd__fill_2
XANTENNA__1373__A _1401_/A vssd1 vssd1 vccd1 vccd1 sky130_fd_sc_hd__diode_2
XFILLER_0_35_202 vssd1 vssd1 vccd1 vccd1 sky130_fd_sc_hd__fill_1
Xoutput87 _1544_/A vssd1 vssd1 vccd1 vccd1 spi_sio_en_o[3] sky130_fd_sc_hd__buf_12
Xoutput98 _1458_/Q vssd1 vssd1 vccd1 vccd1 sport_o[19] sky130_fd_sc_hd__buf_12
Xoutput76 _0723_/Y vssd1 vssd1 vccd1 vccd1 spi_clk_o sky130_fd_sc_hd__buf_12
XTAP_135 vssd1 vccd1 sky130_fd_sc_hd__tapvpwrvgnd_1
XTAP_124 vssd1 vccd1 sky130_fd_sc_hd__tapvpwrvgnd_1
XTAP_113 vssd1 vccd1 sky130_fd_sc_hd__tapvpwrvgnd_1
XTAP_102 vssd1 vccd1 sky130_fd_sc_hd__tapvpwrvgnd_1
X_1483_ _1491_/CLK _1483_/D fanout122/X vssd1 vssd1 vccd1 vccd1 _1483_/Q sky130_fd_sc_hd__dfrtp_1
XTAP_146 vssd1 vccd1 sky130_fd_sc_hd__tapvpwrvgnd_1
XTAP_157 vssd1 vccd1 sky130_fd_sc_hd__tapvpwrvgnd_1
XTAP_168 vssd1 vccd1 sky130_fd_sc_hd__tapvpwrvgnd_1
XTAP_179 vssd1 vccd1 sky130_fd_sc_hd__tapvpwrvgnd_1
XFILLER_0_27_84 vssd1 vssd1 vccd1 vccd1 sky130_fd_sc_hd__fill_2
XFILLER_0_32_227 vssd1 vssd1 vccd1 vccd1 sky130_ef_sc_hd__decap_12
XFILLER_0_32_205 vssd1 vssd1 vccd1 vccd1 sky130_fd_sc_hd__fill_1
XFILLER_0_32_249 vssd1 vssd1 vccd1 vccd1 sky130_fd_sc_hd__decap_3
XANTENNA__1278__A _1401_/A vssd1 vssd1 vccd1 vccd1 sky130_fd_sc_hd__diode_2
XFILLER_0_13_20 vssd1 vssd1 vccd1 vccd1 sky130_fd_sc_hd__fill_1
XFILLER_0_14_227 vssd1 vssd1 vccd1 vccd1 sky130_fd_sc_hd__decap_6
X_0983_ _0983_/A _0983_/B vssd1 vssd1 vccd1 vccd1 _0984_/A sky130_fd_sc_hd__nand2_1
X_1535_ _1537_/CLK _1535_/D fanout128/X vssd1 vssd1 vccd1 vccd1 _1535_/Q sky130_fd_sc_hd__dfrtp_1
Xfanout129 input1/X vssd1 vssd1 vccd1 vccd1 fanout129/X sky130_fd_sc_hd__clkbuf_8
X_1466_ _1539_/CLK _1466_/D fanout125/X vssd1 vssd1 vccd1 vccd1 _1466_/Q sky130_fd_sc_hd__dfrtp_1
XANTENNA__0966__S _0966_/S vssd1 vssd1 vccd1 vccd1 sky130_fd_sc_hd__diode_2
XFILLER_0_38_61 vssd1 vssd1 vccd1 vccd1 sky130_fd_sc_hd__fill_2
XFILLER_0_38_50 vssd1 vssd1 vccd1 vccd1 sky130_fd_sc_hd__decap_3
X_1397_ _1433_/Q hold28/X _1397_/S vssd1 vssd1 vccd1 vccd1 _1398_/A sky130_fd_sc_hd__mux2_1
Xhold150 _1464_/Q vssd1 vssd1 vccd1 vccd1 hold150/X sky130_fd_sc_hd__dlygate4sd3_1
Xhold161 _1462_/Q vssd1 vssd1 vccd1 vccd1 hold161/X sky130_fd_sc_hd__dlygate4sd3_1
Xhold172 _1475_/Q vssd1 vssd1 vccd1 vccd1 _1080_/S sky130_fd_sc_hd__dlygate4sd3_1
Xhold183 _1520_/Q vssd1 vssd1 vccd1 vccd1 hold32/A sky130_fd_sc_hd__dlygate4sd3_1
X_1320_ _1320_/A _1320_/B vssd1 vssd1 vccd1 vccd1 hold75/A sky130_fd_sc_hd__nand2_1
X_1182_ _1182_/A _1262_/B vssd1 vssd1 vccd1 vccd1 _1397_/S sky130_fd_sc_hd__nand2_2
X_1251_ _1313_/A hold72/X vssd1 vssd1 vccd1 vccd1 _1259_/A sky130_fd_sc_hd__nand2_1
XFILLER_0_24_41 vssd1 vssd1 vccd1 vccd1 sky130_fd_sc_hd__decap_6
X_0966_ hold141/X hold48/X _0966_/S vssd1 vssd1 vccd1 vccd1 _0967_/A sky130_fd_sc_hd__mux2_1
X_0897_ _0897_/A _0897_/B vssd1 vssd1 vccd1 vccd1 _0899_/A sky130_fd_sc_hd__nand2_1
X_1449_ _1531_/CLK _1449_/D fanout124/X vssd1 vssd1 vccd1 vccd1 _1449_/Q sky130_fd_sc_hd__dfrtp_1
X_1518_ _1521_/CLK _1518_/D fanout123/X vssd1 vssd1 vccd1 vccd1 _1518_/Q sky130_fd_sc_hd__dfrtp_1
X_0751_ hold26/X _0751_/B vssd1 vssd1 vccd1 vccd1 hold27/A sky130_fd_sc_hd__nor2_1
XFILLER_0_10_32 vssd1 vssd1 vccd1 vccd1 sky130_fd_sc_hd__decap_4
X_0820_ _1193_/A _0820_/B vssd1 vssd1 vccd1 vccd1 _0821_/B sky130_fd_sc_hd__nand2_1
X_1303_ _1303_/A _1426_/A _1334_/C vssd1 vssd1 vccd1 vccd1 _1304_/B sky130_fd_sc_hd__nand3_1
XFILLER_0_35_51 vssd1 vssd1 vccd1 vccd1 sky130_fd_sc_hd__fill_2
X_1096_ _1096_/A vssd1 vssd1 vccd1 vccd1 _1482_/D sky130_fd_sc_hd__clkbuf_1
X_1165_ _1165_/A hold19/X vssd1 vssd1 vccd1 vccd1 hold20/A sky130_fd_sc_hd__nand2_1
X_1234_ _1252_/A _1431_/Q vssd1 vssd1 vccd1 vccd1 _1235_/B sky130_fd_sc_hd__nand2_1
XFILLER_0_35_95 vssd1 vssd1 vccd1 vccd1 sky130_fd_sc_hd__decap_4
XFILLER_0_34_119 vssd1 vssd1 vccd1 vccd1 sky130_fd_sc_hd__fill_2
XANTENNA__1507__RESET_B fanout129/X vssd1 vssd1 vccd1 vccd1 sky130_fd_sc_hd__diode_2
XFILLER_0_19_116 vssd1 vssd1 vccd1 vccd1 sky130_fd_sc_hd__fill_1
XFILLER_0_19_149 vssd1 vssd1 vccd1 vccd1 sky130_fd_sc_hd__fill_1
X_0949_ _0949_/A vssd1 vssd1 vccd1 vccd1 _1461_/D sky130_fd_sc_hd__clkbuf_1
XFILLER_0_42_174 vssd1 vssd1 vccd1 vccd1 sky130_fd_sc_hd__fill_2
XFILLER_0_42_141 vssd1 vssd1 vccd1 vccd1 sky130_fd_sc_hd__fill_2
XFILLER_0_27_193 vssd1 vssd1 vccd1 vccd1 sky130_ef_sc_hd__decap_12
XFILLER_0_33_141 vssd1 vssd1 vccd1 vccd1 sky130_fd_sc_hd__decap_3
X_0803_ _1508_/Q _1262_/B vssd1 vssd1 vccd1 vccd1 _1351_/A sky130_fd_sc_hd__nor2_4
XFILLER_0_24_141 vssd1 vssd1 vccd1 vccd1 sky130_fd_sc_hd__fill_1
X_0734_ _0759_/B _0734_/B vssd1 vssd1 vccd1 vccd1 _0734_/Y sky130_fd_sc_hd__nand2_1
X_1148_ _1148_/A hold33/X vssd1 vssd1 vccd1 vccd1 _1148_/Y sky130_fd_sc_hd__nand2_1
X_1079_ _1079_/A _1079_/B vssd1 vssd1 vccd1 vccd1 _1084_/A sky130_fd_sc_hd__nand2_1
X_1217_ _1215_/X _1208_/X _1216_/X vssd1 vssd1 vccd1 vccd1 _1218_/A sky130_fd_sc_hd__a21o_1
XFILLER_0_15_130 vssd1 vssd1 vccd1 vccd1 sky130_fd_sc_hd__fill_1
Xhold65 hold65/A vssd1 vssd1 vccd1 vccd1 hold65/X sky130_fd_sc_hd__buf_1
Xhold54 hold54/A vssd1 vssd1 vccd1 vccd1 hold54/X sky130_fd_sc_hd__dlygate4sd3_1
Xhold98 hold98/A vssd1 vssd1 vccd1 vccd1 hold98/X sky130_fd_sc_hd__dlygate4sd3_1
Xhold10 hold10/A vssd1 vssd1 vccd1 vccd1 hold10/X sky130_fd_sc_hd__dlygate4sd3_1
Xhold21 hold21/A vssd1 vssd1 vccd1 vccd1 hold21/X sky130_fd_sc_hd__dlygate4sd3_1
Xhold87 hold87/A vssd1 vssd1 vccd1 vccd1 hold87/X sky130_fd_sc_hd__dlygate4sd3_1
Xhold76 hold76/A vssd1 vssd1 vccd1 vccd1 hold76/X sky130_fd_sc_hd__buf_1
Xhold43 hold43/A vssd1 vssd1 vccd1 vccd1 hold43/X sky130_fd_sc_hd__clkbuf_2
XANTENNA__1429__RESET_B fanout127/X vssd1 vssd1 vccd1 vccd1 sky130_fd_sc_hd__diode_2
Xhold32 hold32/A vssd1 vssd1 vccd1 vccd1 hold32/X sky130_fd_sc_hd__dlymetal6s2s_1
XFILLER_0_38_222 vssd1 vssd1 vccd1 vccd1 sky130_ef_sc_hd__decap_12
XFILLER_0_21_111 vssd1 vssd1 vccd1 vccd1 sky130_fd_sc_hd__fill_1
XTAP_328 vssd1 vccd1 sky130_fd_sc_hd__tapvpwrvgnd_1
XTAP_317 vssd1 vccd1 sky130_fd_sc_hd__tapvpwrvgnd_1
XTAP_306 vssd1 vccd1 sky130_fd_sc_hd__tapvpwrvgnd_1
X_1002_ _1002_/A _1002_/B vssd1 vssd1 vccd1 vccd1 _1010_/A sky130_fd_sc_hd__and2_1
XFILLER_0_32_85 vssd1 vssd1 vccd1 vccd1 sky130_fd_sc_hd__fill_2
XFILLER_0_8_105 vssd1 vssd1 vccd1 vccd1 sky130_fd_sc_hd__fill_2
XANTENNA__1373__B _1426_/B vssd1 vssd1 vccd1 vccd1 sky130_fd_sc_hd__diode_2
XFILLER_0_12_144 vssd1 vssd1 vccd1 vccd1 sky130_fd_sc_hd__fill_1
X_0717_ hold24/X _1061_/B vssd1 vssd1 vccd1 vccd1 _0900_/A sky130_fd_sc_hd__nand2_2
XFILLER_0_35_214 vssd1 vssd1 vccd1 vccd1 sky130_fd_sc_hd__fill_2
XANTENNA__0733__A _0733_/A vssd1 vssd1 vccd1 vccd1 sky130_fd_sc_hd__diode_2
Xoutput99 _1440_/Q vssd1 vssd1 vccd1 vccd1 sport_o[1] sky130_fd_sc_hd__buf_12
Xoutput88 _1439_/Q vssd1 vssd1 vccd1 vccd1 sport_o[0] sky130_fd_sc_hd__buf_12
Xoutput77 _0733_/Y vssd1 vssd1 vccd1 vccd1 spi_cs_o sky130_fd_sc_hd__buf_12
XTAP_114 vssd1 vccd1 sky130_fd_sc_hd__tapvpwrvgnd_1
X_1482_ _1491_/CLK _1482_/D fanout122/X vssd1 vssd1 vccd1 vccd1 hold86/A sky130_fd_sc_hd__dfrtp_1
XTAP_103 vssd1 vccd1 sky130_fd_sc_hd__tapvpwrvgnd_1
XTAP_125 vssd1 vccd1 sky130_fd_sc_hd__tapvpwrvgnd_1
XTAP_136 vssd1 vccd1 sky130_fd_sc_hd__tapvpwrvgnd_1
XTAP_147 vssd1 vccd1 sky130_fd_sc_hd__tapvpwrvgnd_1
XTAP_158 vssd1 vccd1 sky130_fd_sc_hd__tapvpwrvgnd_1
XTAP_169 vssd1 vccd1 sky130_fd_sc_hd__tapvpwrvgnd_1
XFILLER_0_32_239 vssd1 vssd1 vccd1 vccd1 sky130_fd_sc_hd__decap_4
XFILLER_0_4_163 vssd1 vssd1 vccd1 vccd1 sky130_fd_sc_hd__fill_2
XFILLER_0_4_141 vssd1 vssd1 vccd1 vccd1 sky130_fd_sc_hd__fill_1
XFILLER_0_4_130 vssd1 vssd1 vccd1 vccd1 sky130_fd_sc_hd__decap_8
XFILLER_0_7_40 vssd1 vssd1 vccd1 vccd1 sky130_fd_sc_hd__fill_1
Xclkbuf_4_6_0_clk_i clkbuf_0_clk_i/X vssd1 vssd1 vccd1 vccd1 _1541_/CLK sky130_fd_sc_hd__clkbuf_8
XFILLER_0_23_206 vssd1 vssd1 vccd1 vccd1 sky130_ef_sc_hd__decap_12
XFILLER_0_13_65 vssd1 vssd1 vccd1 vccd1 sky130_fd_sc_hd__fill_2
XFILLER_0_13_87 vssd1 vssd1 vccd1 vccd1 sky130_fd_sc_hd__fill_2
X_0982_ _0982_/A _0982_/B vssd1 vssd1 vccd1 vccd1 _0983_/B sky130_fd_sc_hd__nand2_1
X_1465_ _1540_/CLK _1465_/D fanout128/X vssd1 vssd1 vccd1 vccd1 _1465_/Q sky130_fd_sc_hd__dfrtp_1
X_1534_ _1537_/CLK _1534_/D fanout128/X vssd1 vssd1 vccd1 vccd1 _1534_/Q sky130_fd_sc_hd__dfrtp_1
X_1396_ _1422_/A hold28/X vssd1 vssd1 vccd1 vccd1 _1402_/A sky130_fd_sc_hd__nand2_1
XFILLER_0_9_277 vssd1 vssd1 vccd1 vccd1 sky130_fd_sc_hd__decap_3
Xhold151 _1465_/Q vssd1 vssd1 vccd1 vccd1 hold151/X sky130_fd_sc_hd__dlygate4sd3_1
Xhold162 _1459_/Q vssd1 vssd1 vccd1 vccd1 hold162/X sky130_fd_sc_hd__dlygate4sd3_1
Xhold140 _1443_/Q vssd1 vssd1 vccd1 vccd1 hold140/X sky130_fd_sc_hd__dlygate4sd3_1
Xhold173 _1508_/Q vssd1 vssd1 vccd1 vccd1 _0805_/B sky130_fd_sc_hd__buf_1
Xhold184 _1514_/Q vssd1 vssd1 vccd1 vccd1 hold36/A sky130_fd_sc_hd__dlygate4sd3_1
X_1181_ _1179_/Y _1180_/A _1180_/Y vssd1 vssd1 vccd1 vccd1 _1181_/Y sky130_fd_sc_hd__o21ai_1
X_1250_ _1250_/A _1250_/B vssd1 vssd1 vccd1 vccd1 hold58/A sky130_fd_sc_hd__nand2_1
X_0965_ _0965_/A vssd1 vssd1 vccd1 vccd1 _1469_/D sky130_fd_sc_hd__clkbuf_1
X_0896_ _0896_/A _0896_/B _0896_/C vssd1 vssd1 vccd1 vccd1 _0897_/A sky130_fd_sc_hd__nand3_1
X_1448_ _1520_/CLK _1448_/D fanout124/X vssd1 vssd1 vccd1 vccd1 _1448_/Q sky130_fd_sc_hd__dfrtp_1
XFILLER_0_10_231 vssd1 vssd1 vccd1 vccd1 sky130_fd_sc_hd__fill_1
XFILLER_0_10_242 vssd1 vssd1 vccd1 vccd1 sky130_fd_sc_hd__fill_2
XFILLER_0_10_297 vssd1 vssd1 vccd1 vccd1 sky130_fd_sc_hd__fill_2
X_1517_ _1525_/CLK hold73/X fanout127/X vssd1 vssd1 vccd1 vccd1 hold72/A sky130_fd_sc_hd__dfrtp_1
X_1379_ _1379_/A _1379_/B vssd1 vssd1 vccd1 vccd1 _1380_/C sky130_fd_sc_hd__nand2_1
XFILLER_0_45_19 vssd1 vssd1 vccd1 vccd1 sky130_fd_sc_hd__decap_4
XFILLER_0_28_139 vssd1 vssd1 vccd1 vccd1 sky130_fd_sc_hd__fill_1
X_0750_ _1184_/A _1045_/B _1262_/B vssd1 vssd1 vccd1 vccd1 _0751_/B sky130_fd_sc_hd__nand3_1
XFILLER_0_10_44 vssd1 vssd1 vccd1 vccd1 sky130_fd_sc_hd__decap_4
XFILLER_0_10_99 vssd1 vssd1 vccd1 vccd1 sky130_fd_sc_hd__decap_8
X_1302_ _1302_/A _1302_/B vssd1 vssd1 vccd1 vccd1 _1303_/A sky130_fd_sc_hd__nand2_1
X_1233_ _1313_/A hold43/X vssd1 vssd1 vccd1 vccd1 _1241_/A sky130_fd_sc_hd__nand2_1
XFILLER_0_35_74 vssd1 vssd1 vccd1 vccd1 sky130_fd_sc_hd__fill_1
X_1164_ _1164_/A _1164_/B _1164_/C vssd1 vssd1 vccd1 vccd1 _1164_/Y sky130_fd_sc_hd__nand3_1
X_1095_ hold86/X input36/X _1117_/S vssd1 vssd1 vccd1 vccd1 _1096_/A sky130_fd_sc_hd__mux2_1
X_0948_ hold142/X hold39/X _0966_/S vssd1 vssd1 vccd1 vccd1 _0949_/A sky130_fd_sc_hd__mux2_1
XANTENNA_fanout123_A fanout126/X vssd1 vssd1 vccd1 vccd1 sky130_fd_sc_hd__diode_2
XFILLER_0_19_139 vssd1 vssd1 vccd1 vccd1 sky130_fd_sc_hd__fill_2
X_0879_ _1222_/A hold65/A _1351_/A hold89/A vssd1 vssd1 vccd1 vccd1 _0880_/B sky130_fd_sc_hd__a22oi_1
XFILLER_0_33_153 vssd1 vssd1 vccd1 vccd1 sky130_ef_sc_hd__decap_12
XFILLER_0_0_209 vssd1 vssd1 vccd1 vccd1 sky130_fd_sc_hd__decap_4
XANTENNA__1286__B hold41/X vssd1 vssd1 vccd1 vccd1 sky130_fd_sc_hd__diode_2
XFILLER_0_18_172 vssd1 vssd1 vccd1 vccd1 sky130_fd_sc_hd__fill_2
X_0802_ _0867_/A hold45/X vssd1 vssd1 vccd1 vccd1 _0802_/Y sky130_fd_sc_hd__nand2_1
XFILLER_0_21_21 vssd1 vssd1 vccd1 vccd1 sky130_ef_sc_hd__decap_12
X_0733_ _0733_/A vssd1 vssd1 vccd1 vccd1 _0733_/Y sky130_fd_sc_hd__inv_2
X_1216_ _1216_/A _1216_/B vssd1 vssd1 vccd1 vccd1 _1216_/X sky130_fd_sc_hd__and2_1
X_1147_ hold33/X _1140_/A vssd1 vssd1 vccd1 vccd1 _1152_/A sky130_fd_sc_hd__or2b_1
X_1078_ _1078_/A _1078_/B vssd1 vssd1 vccd1 vccd1 _1078_/Y sky130_fd_sc_hd__nand2_1
XANTENNA__1387__A _1401_/A vssd1 vssd1 vccd1 vccd1 sky130_fd_sc_hd__diode_2
XFILLER_0_30_189 vssd1 vssd1 vccd1 vccd1 sky130_fd_sc_hd__fill_2
XFILLER_0_30_156 vssd1 vssd1 vccd1 vccd1 sky130_ef_sc_hd__decap_12
Xhold11 hold11/A vssd1 vssd1 vccd1 vccd1 hold11/X sky130_fd_sc_hd__dlygate4sd3_1
Xhold22 hold22/A vssd1 vssd1 vccd1 vccd1 hold22/X sky130_fd_sc_hd__dlymetal6s2s_1
XANTENNA__1469__RESET_B fanout128/X vssd1 vssd1 vccd1 vccd1 sky130_fd_sc_hd__diode_2
Xhold55 hold55/A vssd1 vssd1 vccd1 vccd1 hold55/X sky130_fd_sc_hd__buf_1
Xhold66 hold66/A vssd1 vssd1 vccd1 vccd1 hold66/X sky130_fd_sc_hd__dlygate4sd3_1
Xhold33 hold33/A vssd1 vssd1 vccd1 vccd1 hold33/X sky130_fd_sc_hd__buf_1
Xhold88 hold88/A vssd1 vssd1 vccd1 vccd1 hold88/X sky130_fd_sc_hd__dlygate4sd3_1
Xhold77 hold77/A vssd1 vssd1 vccd1 vccd1 hold77/X sky130_fd_sc_hd__dlygate4sd3_1
Xhold44 hold44/A vssd1 vssd1 vccd1 vccd1 hold44/X sky130_fd_sc_hd__dlygate4sd3_1
Xhold99 hold99/A vssd1 vssd1 vccd1 vccd1 hold99/X sky130_fd_sc_hd__buf_1
XFILLER_0_38_234 vssd1 vssd1 vccd1 vccd1 sky130_ef_sc_hd__decap_12
XTAP_329 vssd1 vccd1 sky130_fd_sc_hd__tapvpwrvgnd_1
XTAP_318 vssd1 vccd1 sky130_fd_sc_hd__tapvpwrvgnd_1
XTAP_307 vssd1 vccd1 sky130_fd_sc_hd__tapvpwrvgnd_1
XFILLER_0_29_245 vssd1 vssd1 vccd1 vccd1 sky130_fd_sc_hd__fill_2
XFILLER_0_29_223 vssd1 vssd1 vccd1 vccd1 sky130_fd_sc_hd__fill_1
X_1001_ _1001_/A _1001_/B vssd1 vssd1 vccd1 vccd1 _1002_/B sky130_fd_sc_hd__nor2_1
XFILLER_0_12_101 vssd1 vssd1 vccd1 vccd1 sky130_fd_sc_hd__fill_1
XFILLER_0_12_112 vssd1 vssd1 vccd1 vccd1 sky130_ef_sc_hd__decap_12
XFILLER_0_12_156 vssd1 vssd1 vccd1 vccd1 sky130_fd_sc_hd__decap_4
X_0716_ hold1/X vssd1 vssd1 vccd1 vccd1 hold2/A sky130_fd_sc_hd__inv_2
XFILLER_0_32_3 vssd1 vssd1 vccd1 vccd1 sky130_fd_sc_hd__fill_2
XFILLER_0_43_281 vssd1 vssd1 vccd1 vccd1 sky130_ef_sc_hd__decap_12
Xclkbuf_4_2_0_clk_i clkbuf_0_clk_i/X vssd1 vssd1 vccd1 vccd1 _1515_/CLK sky130_fd_sc_hd__clkbuf_8
Xoutput89 _1449_/Q vssd1 vssd1 vccd1 vccd1 sport_o[10] sky130_fd_sc_hd__buf_12
Xoutput78 _0736_/X vssd1 vssd1 vccd1 vccd1 spi_dqsm_en_o sky130_fd_sc_hd__buf_12
XTAP_126 vssd1 vccd1 sky130_fd_sc_hd__tapvpwrvgnd_1
XTAP_115 vssd1 vccd1 sky130_fd_sc_hd__tapvpwrvgnd_1
XTAP_104 vssd1 vccd1 sky130_fd_sc_hd__tapvpwrvgnd_1
X_1481_ _1491_/CLK _1481_/D fanout122/X vssd1 vssd1 vccd1 vccd1 _1481_/Q sky130_fd_sc_hd__dfrtp_1
XTAP_137 vssd1 vccd1 sky130_fd_sc_hd__tapvpwrvgnd_1
XTAP_148 vssd1 vccd1 sky130_fd_sc_hd__tapvpwrvgnd_1
XTAP_159 vssd1 vccd1 sky130_fd_sc_hd__tapvpwrvgnd_1
XFILLER_0_17_204 vssd1 vssd1 vccd1 vccd1 sky130_fd_sc_hd__decap_8
XANTENNA__1384__B _1398_/B vssd1 vssd1 vccd1 vccd1 sky130_fd_sc_hd__diode_2
XANTENNA_clkbuf_4_0_0_clk_i_A clkbuf_0_clk_i/X vssd1 vssd1 vccd1 vccd1 sky130_fd_sc_hd__diode_2
XANTENNA__1475__SET_B fanout127/X vssd1 vssd1 vccd1 vccd1 sky130_fd_sc_hd__diode_2
XFILLER_0_23_218 vssd1 vssd1 vccd1 vccd1 sky130_fd_sc_hd__fill_2
XFILLER_0_31_295 vssd1 vssd1 vccd1 vccd1 sky130_fd_sc_hd__fill_1
XANTENNA__0877__B1 _1073_/B vssd1 vssd1 vccd1 vccd1 sky130_fd_sc_hd__diode_2
XFILLER_0_13_55 vssd1 vssd1 vccd1 vccd1 sky130_fd_sc_hd__fill_1
X_0981_ _0981_/A _0981_/B vssd1 vssd1 vccd1 vccd1 _0990_/A sky130_fd_sc_hd__nor2_1
XFILLER_0_22_251 vssd1 vssd1 vccd1 vccd1 sky130_fd_sc_hd__fill_1
X_1464_ _1537_/CLK _1464_/D fanout128/X vssd1 vssd1 vccd1 vccd1 _1464_/Q sky130_fd_sc_hd__dfrtp_1
X_1533_ _1541_/CLK hold90/X fanout126/X vssd1 vssd1 vccd1 vccd1 hold89/A sky130_fd_sc_hd__dfrtp_1
X_1395_ _1395_/A _1395_/B vssd1 vssd1 vccd1 vccd1 _1536_/D sky130_fd_sc_hd__nand2_1
XFILLER_0_1_167 vssd1 vssd1 vccd1 vccd1 sky130_fd_sc_hd__fill_1
XFILLER_0_9_223 vssd1 vssd1 vccd1 vccd1 sky130_fd_sc_hd__fill_1
Xhold141 _1470_/Q vssd1 vssd1 vccd1 vccd1 hold141/X sky130_fd_sc_hd__dlygate4sd3_1
Xhold163 _1446_/Q vssd1 vssd1 vccd1 vccd1 hold163/X sky130_fd_sc_hd__dlygate4sd3_1
Xhold152 _1447_/Q vssd1 vssd1 vccd1 vccd1 hold152/X sky130_fd_sc_hd__dlygate4sd3_1
Xhold185 _1512_/Q vssd1 vssd1 vccd1 vccd1 hold68/A sky130_fd_sc_hd__dlygate4sd3_1
Xhold130 hold189/X vssd1 vssd1 vccd1 vccd1 _1071_/B sky130_fd_sc_hd__buf_2
Xhold174 _1510_/Q vssd1 vssd1 vccd1 vccd1 hold23/A sky130_fd_sc_hd__dlygate4sd3_1
X_1180_ _1180_/A _1404_/B vssd1 vssd1 vccd1 vccd1 _1180_/Y sky130_fd_sc_hd__nand2_1
XFILLER_0_24_21 vssd1 vssd1 vccd1 vccd1 sky130_fd_sc_hd__decap_6
X_0964_ hold138/X hold14/X _0966_/S vssd1 vssd1 vccd1 vccd1 _0965_/A sky130_fd_sc_hd__mux2_1
XFILLER_0_6_237 vssd1 vssd1 vccd1 vccd1 sky130_ef_sc_hd__decap_12
XFILLER_0_40_75 vssd1 vssd1 vccd1 vccd1 sky130_fd_sc_hd__fill_1
X_0895_ _0895_/A _0895_/B vssd1 vssd1 vccd1 vccd1 _0896_/C sky130_fd_sc_hd__nand2_1
X_1516_ _1525_/CLK hold58/X fanout127/X vssd1 vssd1 vccd1 vccd1 hold57/A sky130_fd_sc_hd__dfrtp_1
X_1447_ _1520_/CLK _1447_/D fanout124/X vssd1 vssd1 vccd1 vccd1 _1447_/Q sky130_fd_sc_hd__dfrtp_1
X_1378_ _1418_/A _1378_/B vssd1 vssd1 vccd1 vccd1 _1379_/B sky130_fd_sc_hd__nand2_1
XFILLER_0_5_281 vssd1 vssd1 vccd1 vccd1 sky130_fd_sc_hd__fill_2
XFILLER_0_36_184 vssd1 vssd1 vccd1 vccd1 sky130_fd_sc_hd__fill_2
X_1301_ _1418_/A _1301_/B vssd1 vssd1 vccd1 vccd1 _1302_/B sky130_fd_sc_hd__nand2_1
X_0777__2 _1471_/CLK vssd1 vssd1 vccd1 vccd1 _1430_/CLK sky130_fd_sc_hd__inv_2
X_1232_ _1232_/A _1232_/B vssd1 vssd1 vccd1 vccd1 hold37/A sky130_fd_sc_hd__nand2_1
X_1163_ _1163_/A hold19/X vssd1 vssd1 vccd1 vccd1 _1164_/C sky130_fd_sc_hd__nand2_1
X_1094_ _1094_/A vssd1 vssd1 vccd1 vccd1 _1481_/D sky130_fd_sc_hd__clkbuf_1
X_0947_ _0947_/A vssd1 vssd1 vccd1 vccd1 _1460_/D sky130_fd_sc_hd__clkbuf_1
XFILLER_0_27_140 vssd1 vssd1 vccd1 vccd1 sky130_fd_sc_hd__fill_1
X_0878_ _1404_/A hold48/X hold28/X _0867_/A vssd1 vssd1 vccd1 vccd1 _0880_/A sky130_fd_sc_hd__a22oi_1
XANTENNA__1516__RESET_B fanout127/X vssd1 vssd1 vccd1 vccd1 sky130_fd_sc_hd__diode_2
XFILLER_0_33_165 vssd1 vssd1 vccd1 vccd1 sky130_fd_sc_hd__decap_3
XFILLER_0_18_195 vssd1 vssd1 vccd1 vccd1 sky130_fd_sc_hd__fill_1
X_0801_ _1046_/A _1178_/B vssd1 vssd1 vccd1 vccd1 _0867_/A sky130_fd_sc_hd__nor2_2
XFILLER_0_21_33 vssd1 vssd1 vccd1 vccd1 sky130_fd_sc_hd__decap_3
X_0732_ _0979_/A _1033_/B vssd1 vssd1 vccd1 vccd1 _0733_/A sky130_fd_sc_hd__nor2_2
X_1146_ _1146_/A hold4/X vssd1 vssd1 vccd1 vccd1 hold5/A sky130_fd_sc_hd__nand2_1
X_1215_ _1433_/Q hold99/X _1252_/A vssd1 vssd1 vccd1 vccd1 _1215_/X sky130_fd_sc_hd__mux2_1
XFILLER_0_1_54 vssd1 vssd1 vccd1 vccd1 sky130_fd_sc_hd__fill_2
X_1077_ _1077_/A _1077_/B vssd1 vssd1 vccd1 vccd1 _1077_/Y sky130_fd_sc_hd__nand2_1
XANTENNA__1387__B _1426_/B vssd1 vssd1 vccd1 vccd1 sky130_fd_sc_hd__diode_2
XFILLER_0_15_110 vssd1 vssd1 vccd1 vccd1 sky130_fd_sc_hd__fill_2
Xhold12 hold12/A vssd1 vssd1 vccd1 vccd1 hold12/X sky130_fd_sc_hd__buf_1
Xhold45 hold45/A vssd1 vssd1 vccd1 vccd1 hold45/X sky130_fd_sc_hd__buf_1
Xhold34 hold34/A vssd1 vssd1 vccd1 vccd1 hold34/X sky130_fd_sc_hd__dlygate4sd3_1
Xhold23 hold23/A vssd1 vssd1 vccd1 vccd1 hold23/X sky130_fd_sc_hd__clkbuf_2
Xhold56 hold56/A vssd1 vssd1 vccd1 vccd1 hold56/X sky130_fd_sc_hd__clkbuf_2
Xhold67 hold67/A vssd1 vssd1 vccd1 vccd1 hold67/X sky130_fd_sc_hd__dlymetal6s2s_1
Xhold89 hold89/A vssd1 vssd1 vccd1 vccd1 hold89/X sky130_fd_sc_hd__buf_1
Xhold78 hold78/A vssd1 vssd1 vccd1 vccd1 hold78/X sky130_fd_sc_hd__buf_1
XANTENNA__1438__RESET_B fanout128/X vssd1 vssd1 vccd1 vccd1 sky130_fd_sc_hd__diode_2
XFILLER_0_38_246 vssd1 vssd1 vccd1 vccd1 sky130_fd_sc_hd__decap_6
XTAP_319 vssd1 vccd1 sky130_fd_sc_hd__tapvpwrvgnd_1
XTAP_308 vssd1 vccd1 sky130_fd_sc_hd__tapvpwrvgnd_1
XFILLER_0_16_22 vssd1 vssd1 vccd1 vccd1 sky130_fd_sc_hd__decap_6
X_1000_ _1000_/A _1000_/B vssd1 vssd1 vccd1 vccd1 _1002_/A sky130_fd_sc_hd__nor2_1
XFILLER_0_44_205 vssd1 vssd1 vccd1 vccd1 sky130_fd_sc_hd__decap_3
XFILLER_0_12_124 vssd1 vssd1 vccd1 vccd1 sky130_fd_sc_hd__decap_6
X_0715_ _0823_/C _0982_/B _0759_/B vssd1 vssd1 vccd1 vccd1 _0822_/A sky130_fd_sc_hd__o21ai_1
X_1129_ hold96/X _1026_/A _1129_/S vssd1 vssd1 vccd1 vccd1 hold97/A sky130_fd_sc_hd__mux2_1
XANTENNA__1531__RESET_B fanout125/X vssd1 vssd1 vccd1 vccd1 sky130_fd_sc_hd__diode_2
XFILLER_0_35_238 vssd1 vssd1 vccd1 vccd1 sky130_ef_sc_hd__decap_12
XFILLER_0_28_290 vssd1 vssd1 vccd1 vccd1 sky130_fd_sc_hd__decap_8
XFILLER_0_7_173 vssd1 vssd1 vccd1 vccd1 sky130_fd_sc_hd__fill_1
XFILLER_0_43_293 vssd1 vssd1 vccd1 vccd1 sky130_fd_sc_hd__decap_6
Xoutput79 _0756_/Y vssd1 vssd1 vccd1 vccd1 spi_dqsm_o sky130_fd_sc_hd__buf_12
XFILLER_0_26_238 vssd1 vssd1 vccd1 vccd1 sky130_fd_sc_hd__fill_2
XFILLER_0_26_205 vssd1 vssd1 vccd1 vccd1 sky130_ef_sc_hd__decap_12
XTAP_127 vssd1 vccd1 sky130_fd_sc_hd__tapvpwrvgnd_1
X_1480_ _1491_/CLK _1480_/D fanout122/X vssd1 vssd1 vccd1 vccd1 _1480_/Q sky130_fd_sc_hd__dfrtp_1
XTAP_116 vssd1 vccd1 sky130_fd_sc_hd__tapvpwrvgnd_1
XTAP_105 vssd1 vccd1 sky130_fd_sc_hd__tapvpwrvgnd_1
XTAP_138 vssd1 vccd1 sky130_fd_sc_hd__tapvpwrvgnd_1
XTAP_149 vssd1 vccd1 sky130_fd_sc_hd__tapvpwrvgnd_1
XFILLER_0_27_65 vssd1 vssd1 vccd1 vccd1 sky130_ef_sc_hd__decap_12
XFILLER_0_27_54 vssd1 vssd1 vccd1 vccd1 sky130_fd_sc_hd__fill_2
XFILLER_0_7_53 vssd1 vssd1 vccd1 vccd1 sky130_fd_sc_hd__decap_3
XANTENNA_clkbuf_4_4_0_clk_i_A clkbuf_0_clk_i/X vssd1 vssd1 vccd1 vccd1 sky130_fd_sc_hd__diode_2
XANTENNA__1366__A2 input21/X vssd1 vssd1 vccd1 vccd1 sky130_fd_sc_hd__diode_2
XANTENNA__1453__RESET_B fanout128/X vssd1 vssd1 vccd1 vccd1 sky130_fd_sc_hd__diode_2
XFILLER_0_13_12 vssd1 vssd1 vccd1 vccd1 sky130_fd_sc_hd__decap_8
X_0980_ _0980_/A _0980_/B vssd1 vssd1 vccd1 vccd1 _0981_/B sky130_fd_sc_hd__nand2_1
X_1532_ _1539_/CLK hold40/X fanout126/X vssd1 vssd1 vccd1 vccd1 _1532_/Q sky130_fd_sc_hd__dfrtp_1
XFILLER_0_1_113 vssd1 vssd1 vccd1 vccd1 sky130_ef_sc_hd__decap_12
X_1463_ _1537_/CLK _1463_/D fanout128/X vssd1 vssd1 vccd1 vccd1 _1463_/Q sky130_fd_sc_hd__dfrtp_2
X_1394_ _1401_/A _1426_/B _1394_/C vssd1 vssd1 vccd1 vccd1 _1395_/B sky130_fd_sc_hd__nand3_1
XFILLER_0_9_202 vssd1 vssd1 vccd1 vccd1 sky130_ef_sc_hd__decap_12
Xhold153 _1467_/Q vssd1 vssd1 vccd1 vccd1 hold153/X sky130_fd_sc_hd__dlygate4sd3_1
Xhold142 _1461_/Q vssd1 vssd1 vccd1 vccd1 hold142/X sky130_fd_sc_hd__dlygate4sd3_1
Xhold175 _1537_/Q vssd1 vssd1 vccd1 vccd1 hold28/A sky130_fd_sc_hd__dlygate4sd3_1
Xhold164 _1454_/Q vssd1 vssd1 vccd1 vccd1 hold164/X sky130_fd_sc_hd__dlygate4sd3_1
Xhold120 _1476_/Q vssd1 vssd1 vccd1 vccd1 _0794_/A sky130_fd_sc_hd__buf_1
Xhold131 _1063_/X vssd1 vssd1 vccd1 vccd1 _1064_/C sky130_fd_sc_hd__dlygate4sd3_1
XFILLER_0_13_285 vssd1 vssd1 vccd1 vccd1 sky130_fd_sc_hd__decap_4
Xhold186 _1518_/Q vssd1 vssd1 vccd1 vccd1 hold22/A sky130_fd_sc_hd__dlygate4sd3_1
X_0963_ _0963_/A vssd1 vssd1 vccd1 vccd1 _1468_/D sky130_fd_sc_hd__clkbuf_1
XFILLER_0_6_249 vssd1 vssd1 vccd1 vccd1 sky130_fd_sc_hd__decap_3
X_0894_ _0894_/A _0894_/B vssd1 vssd1 vccd1 vccd1 _0895_/A sky130_fd_sc_hd__nand2_1
XFILLER_0_24_88 vssd1 vssd1 vccd1 vccd1 sky130_fd_sc_hd__fill_2
XFILLER_0_24_99 vssd1 vssd1 vccd1 vccd1 sky130_fd_sc_hd__fill_2
X_1515_ _1515_/CLK hold44/X fanout123/X vssd1 vssd1 vccd1 vccd1 _1515_/Q sky130_fd_sc_hd__dfrtp_1
X_1446_ _1540_/CLK _1446_/D fanout128/X vssd1 vssd1 vccd1 vccd1 _1446_/Q sky130_fd_sc_hd__dfrtp_2
X_1377_ _1377_/A _1398_/B vssd1 vssd1 vccd1 vccd1 _1379_/A sky130_fd_sc_hd__nand2_1
XFILLER_0_4_65 vssd1 vssd1 vccd1 vccd1 sky130_fd_sc_hd__decap_4
XFILLER_0_5_260 vssd1 vssd1 vccd1 vccd1 sky130_fd_sc_hd__decap_3
XFILLER_0_36_141 vssd1 vssd1 vccd1 vccd1 sky130_fd_sc_hd__fill_2
XFILLER_0_10_79 vssd1 vssd1 vccd1 vccd1 sky130_fd_sc_hd__decap_4
X_1162_ _1162_/A _1162_/B vssd1 vssd1 vccd1 vccd1 _1164_/A sky130_fd_sc_hd__nand2_1
X_1231_ _1231_/A _1426_/A _1334_/C vssd1 vssd1 vccd1 vccd1 _1232_/B sky130_fd_sc_hd__nand3_1
XFILLER_0_19_77 vssd1 vssd1 vccd1 vccd1 sky130_fd_sc_hd__fill_2
X_1300_ _1298_/X _1299_/Y _1398_/B vssd1 vssd1 vccd1 vccd1 _1302_/A sky130_fd_sc_hd__o21ai_1
XFILLER_0_35_87 vssd1 vssd1 vccd1 vccd1 sky130_fd_sc_hd__fill_2
X_1093_ hold103/X input35/X _1117_/S vssd1 vssd1 vccd1 vccd1 _1094_/A sky130_fd_sc_hd__mux2_1
X_0946_ hold169/X _1358_/B _0966_/S vssd1 vssd1 vccd1 vccd1 _0947_/A sky130_fd_sc_hd__mux2_1
XFILLER_0_42_166 vssd1 vssd1 vccd1 vccd1 sky130_fd_sc_hd__fill_2
X_0877_ _1256_/B _0872_/A _1073_/B _0821_/B vssd1 vssd1 vccd1 vccd1 _0896_/A sky130_fd_sc_hd__o2bb2a_1
X_1429_ _1429_/CLK hold2/X fanout127/X vssd1 vssd1 vccd1 vccd1 hold1/A sky130_fd_sc_hd__dfrtp_1
XFILLER_0_33_111 vssd1 vssd1 vccd1 vccd1 sky130_fd_sc_hd__fill_1
XFILLER_0_33_199 vssd1 vssd1 vccd1 vccd1 sky130_fd_sc_hd__fill_2
X_0800_ _1176_/B vssd1 vssd1 vccd1 vccd1 _1178_/B sky130_fd_sc_hd__inv_2
X_0731_ _0784_/B _0982_/A vssd1 vssd1 vccd1 vccd1 _1033_/B sky130_fd_sc_hd__nor2_1
XFILLER_0_21_67 vssd1 vssd1 vccd1 vccd1 sky130_fd_sc_hd__fill_1
XFILLER_0_21_89 vssd1 vssd1 vccd1 vccd1 sky130_fd_sc_hd__decap_6
X_1145_ _1165_/A hold3/X vssd1 vssd1 vccd1 vccd1 hold4/A sky130_fd_sc_hd__nand2_1
X_1214_ _1313_/A hold99/X vssd1 vssd1 vccd1 vccd1 _1219_/A sky130_fd_sc_hd__nand2_1
X_1076_ _1076_/A _1426_/B _1076_/C vssd1 vssd1 vccd1 vccd1 _1078_/A sky130_fd_sc_hd__nand3_1
X_0929_ hold155/X hold76/X _0933_/S vssd1 vssd1 vccd1 vccd1 _0930_/A sky130_fd_sc_hd__mux2_1
XFILLER_0_30_136 vssd1 vssd1 vccd1 vccd1 sky130_fd_sc_hd__decap_4
XFILLER_0_15_177 vssd1 vssd1 vccd1 vccd1 sky130_fd_sc_hd__fill_2
Xhold13 hold13/A vssd1 vssd1 vccd1 vccd1 hold13/X sky130_fd_sc_hd__dlygate4sd3_1
Xhold46 hold46/A vssd1 vssd1 vccd1 vccd1 hold46/X sky130_fd_sc_hd__buf_1
Xhold68 hold68/A vssd1 vssd1 vccd1 vccd1 hold68/X sky130_fd_sc_hd__buf_1
Xhold35 hold35/A vssd1 vssd1 vccd1 vccd1 hold35/X sky130_fd_sc_hd__dlygate4sd3_1
Xhold79 hold79/A vssd1 vssd1 vccd1 vccd1 hold79/X sky130_fd_sc_hd__dlygate4sd3_1
Xhold24 hold24/A vssd1 vssd1 vccd1 vccd1 hold24/X sky130_fd_sc_hd__buf_2
Xhold57 hold57/A vssd1 vssd1 vccd1 vccd1 hold57/X sky130_fd_sc_hd__dlymetal6s2s_1
XFILLER_0_38_214 vssd1 vssd1 vccd1 vccd1 sky130_fd_sc_hd__fill_2
XTAP_309 vssd1 vccd1 sky130_fd_sc_hd__tapvpwrvgnd_1
XFILLER_0_44_228 vssd1 vssd1 vccd1 vccd1 sky130_ef_sc_hd__decap_12
X_0714_ hold24/X _1061_/B vssd1 vssd1 vccd1 vccd1 _0759_/B sky130_fd_sc_hd__nor2_2
X_1128_ _1128_/A vssd1 vssd1 vccd1 vccd1 _1498_/D sky130_fd_sc_hd__clkbuf_1
X_1059_ _1187_/A vssd1 vssd1 vccd1 vccd1 _1060_/C sky130_fd_sc_hd__inv_2
XFILLER_0_43_261 vssd1 vssd1 vccd1 vccd1 sky130_ef_sc_hd__decap_12
XANTENNA__1398__B _1398_/B vssd1 vssd1 vccd1 vccd1 sky130_fd_sc_hd__diode_2
XANTENNA__1500__RESET_B fanout127/X vssd1 vssd1 vccd1 vccd1 sky130_fd_sc_hd__diode_2
XFILLER_0_9_6 vssd1 vssd1 vccd1 vccd1 sky130_fd_sc_hd__fill_2
XFILLER_0_26_228 vssd1 vssd1 vccd1 vccd1 sky130_fd_sc_hd__fill_1
XFILLER_0_26_217 vssd1 vssd1 vccd1 vccd1 sky130_fd_sc_hd__fill_1
XTAP_128 vssd1 vccd1 sky130_fd_sc_hd__tapvpwrvgnd_1
XTAP_117 vssd1 vccd1 sky130_fd_sc_hd__tapvpwrvgnd_1
XTAP_106 vssd1 vccd1 sky130_fd_sc_hd__tapvpwrvgnd_1
XTAP_139 vssd1 vccd1 sky130_fd_sc_hd__tapvpwrvgnd_1
XFILLER_0_27_88 vssd1 vssd1 vccd1 vccd1 sky130_fd_sc_hd__fill_2
XPHY_0 vssd1 vssd1 vccd1 vccd1 sky130_fd_sc_hd__decap_3
XANTENNA_clkbuf_4_11_0_clk_i_A clkbuf_0_clk_i/X vssd1 vssd1 vccd1 vccd1 sky130_fd_sc_hd__diode_2
XFILLER_0_17_228 vssd1 vssd1 vccd1 vccd1 sky130_ef_sc_hd__decap_12
XFILLER_0_40_297 vssd1 vssd1 vccd1 vccd1 sky130_fd_sc_hd__fill_2
XFILLER_0_40_253 vssd1 vssd1 vccd1 vccd1 sky130_ef_sc_hd__decap_12
XANTENNA_clkbuf_4_8_0_clk_i_A clkbuf_0_clk_i/X vssd1 vssd1 vccd1 vccd1 sky130_fd_sc_hd__diode_2
X_1462_ _1531_/CLK _1462_/D fanout125/X vssd1 vssd1 vccd1 vccd1 _1462_/Q sky130_fd_sc_hd__dfrtp_2
X_1531_ _1531_/CLK _1531_/D fanout125/X vssd1 vssd1 vccd1 vccd1 _1531_/Q sky130_fd_sc_hd__dfrtp_1
XFILLER_0_1_125 vssd1 vssd1 vccd1 vccd1 sky130_ef_sc_hd__decap_12
XFILLER_0_1_169 vssd1 vssd1 vccd1 vccd1 sky130_ef_sc_hd__decap_12
XFILLER_0_22_253 vssd1 vssd1 vccd1 vccd1 sky130_ef_sc_hd__decap_12
X_1393_ _1393_/A _1393_/B vssd1 vssd1 vccd1 vccd1 _1394_/C sky130_fd_sc_hd__nand2_1
XFILLER_0_9_214 vssd1 vssd1 vccd1 vccd1 sky130_fd_sc_hd__decap_6
XFILLER_0_9_225 vssd1 vssd1 vccd1 vccd1 sky130_fd_sc_hd__decap_4
Xhold110 _1121_/X vssd1 vssd1 vccd1 vccd1 _1122_/A sky130_fd_sc_hd__dlygate4sd3_1
Xhold165 _1455_/Q vssd1 vssd1 vccd1 vccd1 hold165/X sky130_fd_sc_hd__dlygate4sd3_1
Xhold154 _1445_/Q vssd1 vssd1 vccd1 vccd1 hold154/X sky130_fd_sc_hd__dlygate4sd3_1
Xhold143 _1444_/Q vssd1 vssd1 vccd1 vccd1 hold143/X sky130_fd_sc_hd__dlygate4sd3_1
Xhold121 _1083_/X vssd1 vssd1 vccd1 vccd1 _1476_/D sky130_fd_sc_hd__dlygate4sd3_1
Xhold132 _1064_/Y vssd1 vssd1 vccd1 vccd1 _1066_/A sky130_fd_sc_hd__dlygate4sd3_1
XFILLER_0_13_297 vssd1 vssd1 vccd1 vccd1 sky130_fd_sc_hd__fill_2
Xhold187 _1522_/Q vssd1 vssd1 vccd1 vccd1 hold41/A sky130_fd_sc_hd__dlygate4sd3_1
Xhold176 _1521_/Q vssd1 vssd1 vccd1 vccd1 hold56/A sky130_fd_sc_hd__dlygate4sd3_1
XFILLER_0_8_291 vssd1 vssd1 vccd1 vccd1 sky130_fd_sc_hd__decap_4
XFILLER_0_39_161 vssd1 vssd1 vccd1 vccd1 sky130_fd_sc_hd__fill_1
X_0962_ hold156/X hold63/X _0966_/S vssd1 vssd1 vccd1 vccd1 _0963_/A sky130_fd_sc_hd__mux2_1
X_0893_ _0893_/A _1167_/B vssd1 vssd1 vccd1 vccd1 _0894_/B sky130_fd_sc_hd__nand2_1
X_1445_ _1540_/CLK _1445_/D fanout128/X vssd1 vssd1 vccd1 vccd1 _1445_/Q sky130_fd_sc_hd__dfrtp_2
XFILLER_0_10_223 vssd1 vssd1 vccd1 vccd1 sky130_fd_sc_hd__fill_2
XFILLER_0_10_234 vssd1 vssd1 vccd1 vccd1 sky130_fd_sc_hd__fill_2
XFILLER_0_10_289 vssd1 vssd1 vccd1 vccd1 sky130_fd_sc_hd__decap_8
X_1514_ _1525_/CLK hold37/X fanout123/X vssd1 vssd1 vccd1 vccd1 _1514_/Q sky130_fd_sc_hd__dfrtp_1
X_1376_ _1430_/Q hold45/X _1397_/S vssd1 vssd1 vccd1 vccd1 _1377_/A sky130_fd_sc_hd__mux2_1
XFILLER_0_28_109 vssd1 vssd1 vccd1 vccd1 sky130_ef_sc_hd__decap_12
XFILLER_0_36_197 vssd1 vssd1 vccd1 vccd1 sky130_fd_sc_hd__decap_3
XFILLER_0_10_36 vssd1 vssd1 vccd1 vccd1 sky130_fd_sc_hd__fill_1
X_1092_ _1092_/A vssd1 vssd1 vccd1 vccd1 _1480_/D sky130_fd_sc_hd__clkbuf_1
X_1161_ _1159_/X _1165_/A hold7/X vssd1 vssd1 vccd1 vccd1 hold8/A sky130_fd_sc_hd__o21ai_1
X_1230_ _1230_/A _1230_/B vssd1 vssd1 vccd1 vccd1 _1231_/A sky130_fd_sc_hd__nand2_1
XFILLER_0_19_89 vssd1 vssd1 vccd1 vccd1 sky130_fd_sc_hd__fill_2
X_0945_ _0945_/A vssd1 vssd1 vccd1 vccd1 _1459_/D sky130_fd_sc_hd__clkbuf_1
XFILLER_0_42_178 vssd1 vssd1 vccd1 vccd1 sky130_fd_sc_hd__fill_2
XFILLER_0_2_253 vssd1 vssd1 vccd1 vccd1 sky130_fd_sc_hd__fill_2
X_0876_ _0876_/A hold84/X vssd1 vssd1 vccd1 vccd1 hold85/A sky130_fd_sc_hd__nand2_1
X_1428_ _1507_/CLK hold18/X fanout128/X vssd1 vssd1 vccd1 vccd1 _1428_/Q sky130_fd_sc_hd__dfrtp_1
X_1359_ _1330_/Y _1370_/A _1358_/Y vssd1 vssd1 vccd1 vccd1 _1359_/Y sky130_fd_sc_hd__o21ai_1
XANTENNA__1525__RESET_B fanout127/X vssd1 vssd1 vccd1 vccd1 sky130_fd_sc_hd__diode_2
XFILLER_0_18_131 vssd1 vssd1 vccd1 vccd1 sky130_fd_sc_hd__decap_8
XFILLER_0_18_153 vssd1 vssd1 vccd1 vccd1 sky130_ef_sc_hd__decap_12
XFILLER_0_18_197 vssd1 vssd1 vccd1 vccd1 sky130_ef_sc_hd__decap_12
XFILLER_0_24_123 vssd1 vssd1 vccd1 vccd1 sky130_fd_sc_hd__fill_2
X_0730_ _0759_/B vssd1 vssd1 vccd1 vccd1 _0982_/A sky130_fd_sc_hd__inv_2
XFILLER_0_21_57 vssd1 vssd1 vccd1 vccd1 sky130_fd_sc_hd__decap_3
X_1213_ _1213_/A _1213_/B vssd1 vssd1 vccd1 vccd1 _1512_/D sky130_fd_sc_hd__nand2_1
XFILLER_0_46_54 vssd1 vssd1 vccd1 vccd1 sky130_fd_sc_hd__fill_2
X_1144_ _1165_/A _1143_/X vssd1 vssd1 vccd1 vccd1 _1146_/A sky130_fd_sc_hd__or2b_1
XFILLER_0_1_12 vssd1 vssd1 vccd1 vccd1 sky130_fd_sc_hd__fill_2
XFILLER_0_1_34 vssd1 vssd1 vccd1 vccd1 sky130_ef_sc_hd__decap_12
X_1075_ _1075_/A _1075_/B vssd1 vssd1 vccd1 vccd1 _1076_/C sky130_fd_sc_hd__nand2_1
X_0928_ _0928_/A vssd1 vssd1 vccd1 vccd1 _1451_/D sky130_fd_sc_hd__clkbuf_1
XFILLER_0_30_115 vssd1 vssd1 vccd1 vccd1 sky130_fd_sc_hd__fill_2
X_0859_ _1483_/Q _1167_/C _0858_/X vssd1 vssd1 vccd1 vccd1 _0859_/X sky130_fd_sc_hd__a21o_1
XFILLER_0_15_167 vssd1 vssd1 vccd1 vccd1 sky130_fd_sc_hd__fill_1
Xhold14 hold14/A vssd1 vssd1 vccd1 vccd1 hold14/X sky130_fd_sc_hd__buf_1
Xhold47 hold47/A vssd1 vssd1 vccd1 vccd1 hold47/X sky130_fd_sc_hd__dlygate4sd3_1
Xhold36 hold36/A vssd1 vssd1 vccd1 vccd1 hold36/X sky130_fd_sc_hd__clkbuf_2
Xhold25 hold25/A vssd1 vssd1 vccd1 vccd1 hold25/X sky130_fd_sc_hd__dlygate4sd3_1
Xhold69 hold69/A vssd1 vssd1 vccd1 vccd1 hold69/X sky130_fd_sc_hd__dlygate4sd3_1
Xhold58 hold58/A vssd1 vssd1 vccd1 vccd1 hold58/X sky130_fd_sc_hd__dlygate4sd3_1
XFILLER_0_46_281 vssd1 vssd1 vccd1 vccd1 sky130_fd_sc_hd__fill_2
XFILLER_0_37_281 vssd1 vssd1 vccd1 vccd1 sky130_fd_sc_hd__fill_2
XFILLER_0_32_89 vssd1 vssd1 vccd1 vccd1 sky130_fd_sc_hd__fill_2
XFILLER_0_29_237 vssd1 vssd1 vccd1 vccd1 sky130_fd_sc_hd__decap_8
XFILLER_0_12_104 vssd1 vssd1 vccd1 vccd1 sky130_fd_sc_hd__decap_4
X_0713_ _0817_/A vssd1 vssd1 vccd1 vccd1 _0982_/B sky130_fd_sc_hd__inv_2
X_1127_ hold124/X _1027_/A _1129_/S vssd1 vssd1 vccd1 vccd1 _1127_/X sky130_fd_sc_hd__mux2_1
X_1058_ _1058_/A _1058_/B vssd1 vssd1 vccd1 vccd1 _1060_/A sky130_fd_sc_hd__nor2_1
XFILLER_0_43_273 vssd1 vssd1 vccd1 vccd1 sky130_fd_sc_hd__decap_6
XFILLER_0_35_218 vssd1 vssd1 vccd1 vccd1 sky130_fd_sc_hd__fill_2
XFILLER_0_35_207 vssd1 vssd1 vccd1 vccd1 sky130_fd_sc_hd__decap_3
XFILLER_0_7_142 vssd1 vssd1 vccd1 vccd1 sky130_fd_sc_hd__decap_4
XANTENNA__1540__RESET_B fanout128/X vssd1 vssd1 vccd1 vccd1 sky130_fd_sc_hd__diode_2
XFILLER_0_11_181 vssd1 vssd1 vccd1 vccd1 sky130_fd_sc_hd__decap_4
XFILLER_0_19_281 vssd1 vssd1 vccd1 vccd1 sky130_fd_sc_hd__fill_2
XFILLER_0_34_251 vssd1 vssd1 vccd1 vccd1 sky130_fd_sc_hd__fill_1
XTAP_129 vssd1 vccd1 sky130_fd_sc_hd__tapvpwrvgnd_1
XTAP_118 vssd1 vccd1 sky130_fd_sc_hd__tapvpwrvgnd_1
XTAP_107 vssd1 vccd1 sky130_fd_sc_hd__tapvpwrvgnd_1
XFILLER_0_43_55 vssd1 vssd1 vccd1 vccd1 sky130_fd_sc_hd__fill_1
XPHY_1 vssd1 vssd1 vccd1 vccd1 sky130_fd_sc_hd__decap_3
XANTENNA_clkbuf_4_15_0_clk_i_A clkbuf_0_clk_i/X vssd1 vssd1 vccd1 vccd1 sky130_fd_sc_hd__diode_2
XFILLER_0_25_295 vssd1 vssd1 vccd1 vccd1 sky130_fd_sc_hd__fill_1
XFILLER_0_4_167 vssd1 vssd1 vccd1 vccd1 sky130_fd_sc_hd__fill_2
XFILLER_0_40_265 vssd1 vssd1 vccd1 vccd1 sky130_ef_sc_hd__decap_12
XFILLER_0_31_210 vssd1 vssd1 vccd1 vccd1 sky130_fd_sc_hd__decap_3
X_1461_ _1531_/CLK _1461_/D fanout125/X vssd1 vssd1 vccd1 vccd1 _1461_/Q sky130_fd_sc_hd__dfrtp_1
X_1530_ _1531_/CLK _1530_/D fanout125/X vssd1 vssd1 vccd1 vccd1 _1530_/Q sky130_fd_sc_hd__dfrtp_1
XANTENNA__1462__RESET_B fanout125/X vssd1 vssd1 vccd1 vccd1 sky130_fd_sc_hd__diode_2
XFILLER_0_1_104 vssd1 vssd1 vccd1 vccd1 sky130_fd_sc_hd__decap_8
XFILLER_0_1_137 vssd1 vssd1 vccd1 vccd1 sky130_ef_sc_hd__decap_12
X_1392_ _1418_/A _1392_/B vssd1 vssd1 vccd1 vccd1 _1393_/B sky130_fd_sc_hd__nand2_1
XFILLER_0_22_232 vssd1 vssd1 vccd1 vccd1 sky130_fd_sc_hd__fill_2
XFILLER_0_22_265 vssd1 vssd1 vccd1 vccd1 sky130_fd_sc_hd__decap_6
Xhold111 _1531_/Q vssd1 vssd1 vccd1 vccd1 _1358_/B sky130_fd_sc_hd__buf_1
Xhold100 _1219_/Y vssd1 vssd1 vccd1 vccd1 _1513_/D sky130_fd_sc_hd__dlygate4sd3_1
Xhold144 _1507_/Q vssd1 vssd1 vccd1 vccd1 _0748_/A sky130_fd_sc_hd__dlygate4sd3_1
Xhold133 _1066_/Y vssd1 vssd1 vccd1 vccd1 _1472_/D sky130_fd_sc_hd__dlygate4sd3_1
XFILLER_0_13_210 vssd1 vssd1 vccd1 vccd1 sky130_fd_sc_hd__fill_1
Xhold122 _1494_/Q vssd1 vssd1 vccd1 vccd1 hold122/X sky130_fd_sc_hd__dlygate4sd3_1
Xhold188 _1532_/Q vssd1 vssd1 vccd1 vccd1 hold39/A sky130_fd_sc_hd__dlygate4sd3_1
Xhold155 _1452_/Q vssd1 vssd1 vccd1 vccd1 hold155/X sky130_fd_sc_hd__dlygate4sd3_1
Xhold166 _1457_/Q vssd1 vssd1 vccd1 vccd1 hold166/X sky130_fd_sc_hd__dlygate4sd3_1
Xhold177 _1428_/Q vssd1 vssd1 vccd1 vccd1 hold16/A sky130_fd_sc_hd__dlygate4sd3_1
XFILLER_0_0_181 vssd1 vssd1 vccd1 vccd1 sky130_ef_sc_hd__decap_12
X_0961_ _0961_/A vssd1 vssd1 vccd1 vccd1 _1467_/D sky130_fd_sc_hd__clkbuf_1
X_0892_ _1082_/A _1480_/Q _1484_/Q _1167_/C vssd1 vssd1 vccd1 vccd1 _0893_/A sky130_fd_sc_hd__a22o_1
X_1375_ _1422_/A hold45/X vssd1 vssd1 vccd1 vccd1 _1381_/A sky130_fd_sc_hd__nand2_1
X_1444_ _1520_/CLK _1444_/D fanout124/X vssd1 vssd1 vccd1 vccd1 _1444_/Q sky130_fd_sc_hd__dfrtp_1
X_1513_ _1520_/CLK _1513_/D fanout125/X vssd1 vssd1 vccd1 vccd1 hold99/A sky130_fd_sc_hd__dfrtp_1
XTAP_290 vssd1 vccd1 sky130_fd_sc_hd__tapvpwrvgnd_1
XFILLER_0_10_48 vssd1 vssd1 vccd1 vccd1 sky130_fd_sc_hd__fill_1
X_1091_ hold104/X input34/X _1117_/S vssd1 vssd1 vccd1 vccd1 _1092_/A sky130_fd_sc_hd__mux2_1
X_1160_ _1165_/A hold6/X vssd1 vssd1 vccd1 vccd1 hold7/A sky130_fd_sc_hd__nand2_1
X_0944_ hold162/X _1352_/B _0966_/S vssd1 vssd1 vccd1 vccd1 _0945_/A sky130_fd_sc_hd__mux2_1
XFILLER_0_2_243 vssd1 vssd1 vccd1 vccd1 sky130_fd_sc_hd__fill_2
X_0875_ _0898_/A hold83/X vssd1 vssd1 vccd1 vccd1 hold84/A sky130_fd_sc_hd__nand2_1
X_1427_ _1427_/A _1427_/B vssd1 vssd1 vccd1 vccd1 hold49/A sky130_fd_sc_hd__nand2_1
X_1358_ _1370_/A _1358_/B vssd1 vssd1 vccd1 vccd1 _1358_/Y sky130_fd_sc_hd__nand2_1
X_1289_ _1289_/A _1404_/B vssd1 vssd1 vccd1 vccd1 _1289_/Y sky130_fd_sc_hd__nand2_1
XFILLER_0_33_146 vssd1 vssd1 vccd1 vccd1 sky130_fd_sc_hd__decap_4
XFILLER_0_33_113 vssd1 vssd1 vccd1 vccd1 sky130_fd_sc_hd__fill_2
XFILLER_0_18_165 vssd1 vssd1 vccd1 vccd1 sky130_fd_sc_hd__decap_4
XFILLER_0_18_176 vssd1 vssd1 vccd1 vccd1 sky130_fd_sc_hd__fill_2
XANTENNA__1401__A _1401_/A vssd1 vssd1 vccd1 vccd1 sky130_fd_sc_hd__diode_2
XFILLER_0_24_135 vssd1 vssd1 vccd1 vccd1 sky130_fd_sc_hd__fill_1
X_1212_ _1212_/A _1426_/A _1334_/C vssd1 vssd1 vccd1 vccd1 _1213_/B sky130_fd_sc_hd__nand3_1
XFILLER_0_1_46 vssd1 vssd1 vccd1 vccd1 sky130_fd_sc_hd__decap_8
XFILLER_0_1_57 vssd1 vssd1 vccd1 vccd1 sky130_fd_sc_hd__decap_6
X_1143_ _1164_/B _1142_/Y _1131_/Y vssd1 vssd1 vccd1 vccd1 _1143_/X sky130_fd_sc_hd__a21o_1
X_1074_ _1193_/A _1074_/B _1074_/C vssd1 vssd1 vccd1 vccd1 _1075_/A sky130_fd_sc_hd__and3_1
X_0927_ hold146/X hold41/X _0933_/S vssd1 vssd1 vccd1 vccd1 _0928_/A sky130_fd_sc_hd__mux2_1
XFILLER_0_15_113 vssd1 vssd1 vccd1 vccd1 sky130_fd_sc_hd__decap_4
XFILLER_0_30_105 vssd1 vssd1 vccd1 vccd1 sky130_fd_sc_hd__fill_2
X_0789_ _0794_/B _1495_/Q vssd1 vssd1 vccd1 vccd1 _0789_/Y sky130_fd_sc_hd__nand2_1
X_0858_ _1082_/A hold91/A hold78/X vssd1 vssd1 vccd1 vccd1 _0858_/X sky130_fd_sc_hd__a21o_1
Xhold48 hold48/A vssd1 vssd1 vccd1 vccd1 hold48/X sky130_fd_sc_hd__dlymetal6s2s_1
Xhold15 hold15/A vssd1 vssd1 vccd1 vccd1 hold15/X sky130_fd_sc_hd__dlygate4sd3_1
Xhold26 hold26/A vssd1 vssd1 vccd1 vccd1 hold26/X sky130_fd_sc_hd__dlygate4sd3_1
Xhold37 hold37/A vssd1 vssd1 vccd1 vccd1 hold37/X sky130_fd_sc_hd__dlygate4sd3_1
Xhold59 hold59/A vssd1 vssd1 vccd1 vccd1 hold59/X sky130_fd_sc_hd__dlygate4sd3_1
XFILLER_0_21_116 vssd1 vssd1 vccd1 vccd1 sky130_fd_sc_hd__fill_2
XFILLER_0_29_216 vssd1 vssd1 vccd1 vccd1 sky130_fd_sc_hd__fill_1
XFILLER_0_32_79 vssd1 vssd1 vccd1 vccd1 sky130_fd_sc_hd__fill_2
XFILLER_0_32_57 vssd1 vssd1 vccd1 vccd1 sky130_fd_sc_hd__fill_2
X_0712_ _1071_/B _1077_/B vssd1 vssd1 vccd1 vccd1 _0817_/A sky130_fd_sc_hd__nand2_2
X_1126_ hold93/X vssd1 vssd1 vccd1 vccd1 _1497_/D sky130_fd_sc_hd__clkbuf_1
X_1057_ _1076_/A _1426_/B _1057_/C vssd1 vssd1 vccd1 vccd1 _1062_/A sky130_fd_sc_hd__nand3_1
XTAP_119 vssd1 vccd1 sky130_fd_sc_hd__tapvpwrvgnd_1
XTAP_108 vssd1 vccd1 sky130_fd_sc_hd__tapvpwrvgnd_1
XFILLER_0_27_57 vssd1 vssd1 vccd1 vccd1 sky130_fd_sc_hd__decap_6
XFILLER_0_27_46 vssd1 vssd1 vccd1 vccd1 sky130_fd_sc_hd__decap_8
XPHY_2 vssd1 vssd1 vccd1 vccd1 sky130_fd_sc_hd__decap_3
XFILLER_0_40_244 vssd1 vssd1 vccd1 vccd1 sky130_fd_sc_hd__decap_8
XFILLER_0_7_45 vssd1 vssd1 vccd1 vccd1 sky130_fd_sc_hd__fill_1
XFILLER_0_40_277 vssd1 vssd1 vccd1 vccd1 sky130_ef_sc_hd__decap_12
X_1109_ hold102/X _0991_/A _1117_/S vssd1 vssd1 vccd1 vccd1 _1110_/A sky130_fd_sc_hd__mux2_1
XFILLER_0_31_277 vssd1 vssd1 vccd1 vccd1 sky130_fd_sc_hd__decap_3
XFILLER_0_31_222 vssd1 vssd1 vccd1 vccd1 sky130_fd_sc_hd__fill_2
XFILLER_0_16_274 vssd1 vssd1 vccd1 vccd1 sky130_fd_sc_hd__fill_1
X_1460_ _1531_/CLK _1460_/D fanout125/X vssd1 vssd1 vccd1 vccd1 _1460_/Q sky130_fd_sc_hd__dfrtp_1
XFILLER_0_38_56 vssd1 vssd1 vccd1 vccd1 sky130_fd_sc_hd__decap_3
X_1391_ _1391_/A _1398_/B vssd1 vssd1 vccd1 vccd1 _1393_/A sky130_fd_sc_hd__nand2_1
XFILLER_0_1_149 vssd1 vssd1 vccd1 vccd1 sky130_ef_sc_hd__decap_12
XANTENNA__1303__B _1426_/A vssd1 vssd1 vccd1 vccd1 sky130_fd_sc_hd__diode_2
XANTENNA__1431__RESET_B fanout129/X vssd1 vssd1 vccd1 vccd1 sky130_fd_sc_hd__diode_2
Xhold156 _1468_/Q vssd1 vssd1 vccd1 vccd1 hold156/X sky130_fd_sc_hd__dlygate4sd3_1
Xhold112 _1362_/Y vssd1 vssd1 vccd1 vccd1 _1531_/D sky130_fd_sc_hd__dlygate4sd3_1
Xhold134 _1466_/Q vssd1 vssd1 vccd1 vccd1 hold134/X sky130_fd_sc_hd__dlygate4sd3_1
Xhold145 _1458_/Q vssd1 vssd1 vccd1 vccd1 hold145/X sky130_fd_sc_hd__dlygate4sd3_1
Xhold167 _1442_/Q vssd1 vssd1 vccd1 vccd1 hold167/X sky130_fd_sc_hd__dlygate4sd3_1
Xhold101 _1483_/Q vssd1 vssd1 vccd1 vccd1 hold101/X sky130_fd_sc_hd__dlygate4sd3_1
XFILLER_0_13_222 vssd1 vssd1 vccd1 vccd1 sky130_fd_sc_hd__fill_2
Xhold123 _1119_/X vssd1 vssd1 vccd1 vccd1 _1120_/A sky130_fd_sc_hd__dlygate4sd3_1
XFILLER_0_0_193 vssd1 vssd1 vccd1 vccd1 sky130_fd_sc_hd__decap_3
Xhold189 _1473_/Q vssd1 vssd1 vccd1 vccd1 hold189/X sky130_fd_sc_hd__dlygate4sd3_1
Xhold178 _1519_/Q vssd1 vssd1 vccd1 vccd1 hold62/A sky130_fd_sc_hd__dlygate4sd3_1
XANTENNA_output113_A _0733_/A vssd1 vssd1 vccd1 vccd1 sky130_fd_sc_hd__diode_2
X_0960_ hold153/X hold12/X _0966_/S vssd1 vssd1 vccd1 vccd1 _0961_/A sky130_fd_sc_hd__mux2_1
XFILLER_0_6_208 vssd1 vssd1 vccd1 vccd1 sky130_fd_sc_hd__decap_6
X_1512_ _1539_/CLK _1512_/D fanout125/X vssd1 vssd1 vccd1 vccd1 _1512_/Q sky130_fd_sc_hd__dfrtp_1
X_0891_ _0888_/Y _0889_/Y _0890_/Y _1167_/B vssd1 vssd1 vccd1 vccd1 _0894_/A sky130_fd_sc_hd__a31o_1
X_1374_ _1374_/A _1374_/B vssd1 vssd1 vccd1 vccd1 hold90/A sky130_fd_sc_hd__nand2_1
X_1443_ _1520_/CLK _1443_/D fanout124/X vssd1 vssd1 vccd1 vccd1 _1443_/Q sky130_fd_sc_hd__dfrtp_1
XFILLER_0_45_111 vssd1 vssd1 vccd1 vccd1 sky130_fd_sc_hd__fill_1
XFILLER_0_5_252 vssd1 vssd1 vccd1 vccd1 sky130_fd_sc_hd__fill_1
XTAP_291 vssd1 vccd1 sky130_fd_sc_hd__tapvpwrvgnd_1
XTAP_280 vssd1 vccd1 sky130_fd_sc_hd__tapvpwrvgnd_1
XFILLER_0_36_188 vssd1 vssd1 vccd1 vccd1 sky130_fd_sc_hd__fill_2
XFILLER_0_19_47 vssd1 vssd1 vccd1 vccd1 sky130_fd_sc_hd__fill_2
X_1090_ _1090_/A vssd1 vssd1 vccd1 vccd1 _1479_/D sky130_fd_sc_hd__clkbuf_1
X_0943_ _0943_/A vssd1 vssd1 vccd1 vccd1 _1458_/D sky130_fd_sc_hd__clkbuf_1
XFILLER_0_27_122 vssd1 vssd1 vccd1 vccd1 sky130_fd_sc_hd__fill_1
X_0874_ _0874_/A _0897_/B vssd1 vssd1 vccd1 vccd1 _0876_/A sky130_fd_sc_hd__nand2_1
X_1357_ _1422_/A _1358_/B vssd1 vssd1 vccd1 vccd1 _1362_/A sky130_fd_sc_hd__nand2_1
X_1426_ _1426_/A _1426_/B _1426_/C vssd1 vssd1 vccd1 vccd1 _1427_/B sky130_fd_sc_hd__nand3_1
X_1288_ _1288_/A _1306_/B vssd1 vssd1 vccd1 vccd1 _1288_/Y sky130_fd_sc_hd__nor2_1
XANTENNA__1534__RESET_B fanout128/X vssd1 vssd1 vccd1 vccd1 sky130_fd_sc_hd__diode_2
XFILLER_0_33_169 vssd1 vssd1 vccd1 vccd1 sky130_fd_sc_hd__decap_3
XFILLER_0_33_103 vssd1 vssd1 vccd1 vccd1 sky130_fd_sc_hd__fill_2
XANTENNA__1401__B _1426_/B vssd1 vssd1 vccd1 vccd1 sky130_fd_sc_hd__diode_2
XFILLER_0_24_103 vssd1 vssd1 vccd1 vccd1 sky130_fd_sc_hd__fill_1
XFILLER_0_32_191 vssd1 vssd1 vccd1 vccd1 sky130_fd_sc_hd__decap_4
X_1211_ _1420_/C vssd1 vssd1 vccd1 vccd1 _1334_/C sky130_fd_sc_hd__buf_6
X_1142_ _1148_/A _1142_/B vssd1 vssd1 vccd1 vccd1 _1142_/Y sky130_fd_sc_hd__nand2_1
XANTENNA__0907__S _0933_/S vssd1 vssd1 vccd1 vccd1 sky130_fd_sc_hd__diode_2
X_1073_ _1167_/A _1073_/B vssd1 vssd1 vccd1 vccd1 _1074_/C sky130_fd_sc_hd__nand2_1
XANTENNA__1311__B _1426_/A vssd1 vssd1 vccd1 vccd1 sky130_fd_sc_hd__diode_2
X_0926_ _0926_/A vssd1 vssd1 vccd1 vccd1 _1450_/D sky130_fd_sc_hd__clkbuf_1
X_0857_ _1084_/B _1489_/Q _1082_/A _1493_/Q vssd1 vssd1 vccd1 vccd1 _0857_/X sky130_fd_sc_hd__a22o_1
XFILLER_0_15_169 vssd1 vssd1 vccd1 vccd1 sky130_fd_sc_hd__decap_4
X_1409_ _1409_/A _1409_/B vssd1 vssd1 vccd1 vccd1 hold13/A sky130_fd_sc_hd__nand2_1
Xhold27 hold27/A vssd1 vssd1 vccd1 vccd1 hold27/X sky130_fd_sc_hd__dlygate4sd3_1
Xhold16 hold16/A vssd1 vssd1 vccd1 vccd1 hold16/X sky130_fd_sc_hd__buf_1
X_0788_ _1079_/B _1054_/C vssd1 vssd1 vccd1 vccd1 _0895_/B sky130_fd_sc_hd__nand2_1
Xhold38 hold38/A vssd1 vssd1 vccd1 vccd1 hold38/X sky130_fd_sc_hd__buf_1
Xhold49 hold49/A vssd1 vssd1 vccd1 vccd1 hold49/X sky130_fd_sc_hd__dlygate4sd3_1
XFILLER_0_21_128 vssd1 vssd1 vccd1 vccd1 sky130_fd_sc_hd__decap_3
XFILLER_0_16_48 vssd1 vssd1 vccd1 vccd1 sky130_fd_sc_hd__fill_2
X_0711_ _1473_/Q _1474_/Q vssd1 vssd1 vccd1 vccd1 _0823_/C sky130_fd_sc_hd__nor2_1
X_1125_ hold92/X _1000_/A _1129_/S vssd1 vssd1 vccd1 vccd1 hold93/A sky130_fd_sc_hd__mux2_1
X_1056_ _1056_/A _1056_/B _1170_/A vssd1 vssd1 vccd1 vccd1 _1057_/C sky130_fd_sc_hd__nand3_1
X_0909_ hold167/X hold99/X _0933_/S vssd1 vssd1 vccd1 vccd1 _0910_/A sky130_fd_sc_hd__mux2_1
XFILLER_0_34_253 vssd1 vssd1 vccd1 vccd1 sky130_ef_sc_hd__decap_12
XFILLER_0_34_297 vssd1 vssd1 vccd1 vccd1 sky130_fd_sc_hd__fill_2
XTAP_109 vssd1 vccd1 sky130_fd_sc_hd__tapvpwrvgnd_1
XPHY_3 vssd1 vssd1 vccd1 vccd1 sky130_fd_sc_hd__decap_3
XFILLER_0_7_57 vssd1 vssd1 vccd1 vccd1 sky130_ef_sc_hd__decap_12
XFILLER_0_40_289 vssd1 vssd1 vccd1 vccd1 sky130_fd_sc_hd__decap_8
X_1039_ _1046_/A _1045_/B vssd1 vssd1 vccd1 vccd1 _1040_/B sky130_fd_sc_hd__nor2_1
X_1108_ _1108_/A vssd1 vssd1 vccd1 vccd1 _1488_/D sky130_fd_sc_hd__clkbuf_1
XFILLER_0_17_91 vssd1 vssd1 vccd1 vccd1 sky130_fd_sc_hd__fill_2
XFILLER_0_16_253 vssd1 vssd1 vccd1 vccd1 sky130_ef_sc_hd__decap_12
XFILLER_0_13_49 vssd1 vssd1 vccd1 vccd1 sky130_fd_sc_hd__decap_6
XFILLER_0_22_201 vssd1 vssd1 vccd1 vccd1 sky130_fd_sc_hd__fill_2
XFILLER_0_22_212 vssd1 vssd1 vccd1 vccd1 sky130_fd_sc_hd__fill_1
XFILLER_0_22_223 vssd1 vssd1 vccd1 vccd1 sky130_fd_sc_hd__fill_1
XFILLER_0_22_245 vssd1 vssd1 vccd1 vccd1 sky130_fd_sc_hd__decap_6
XFILLER_0_38_24 vssd1 vssd1 vccd1 vccd1 sky130_fd_sc_hd__fill_1
X_1390_ _1432_/Q hold67/X _1397_/S vssd1 vssd1 vccd1 vccd1 _1391_/A sky130_fd_sc_hd__mux2_1
XANTENNA__0915__S _0933_/S vssd1 vssd1 vccd1 vccd1 sky130_fd_sc_hd__diode_2
XANTENNA__1471__RESET_B fanout127/X vssd1 vssd1 vccd1 vccd1 sky130_fd_sc_hd__diode_2
Xhold157 _1463_/Q vssd1 vssd1 vccd1 vccd1 hold157/X sky130_fd_sc_hd__dlygate4sd3_1
Xhold113 _1530_/Q vssd1 vssd1 vccd1 vccd1 _1352_/B sky130_fd_sc_hd__buf_1
Xhold146 _1451_/Q vssd1 vssd1 vccd1 vccd1 hold146/X sky130_fd_sc_hd__dlygate4sd3_1
Xhold168 _1508_/Q vssd1 vssd1 vccd1 vccd1 _1176_/B sky130_fd_sc_hd__dlymetal6s2s_1
Xhold135 _1474_/Q vssd1 vssd1 vccd1 vccd1 _1077_/B sky130_fd_sc_hd__buf_2
Xhold102 _1489_/Q vssd1 vssd1 vccd1 vccd1 hold102/X sky130_fd_sc_hd__dlygate4sd3_1
Xhold124 _1498_/Q vssd1 vssd1 vccd1 vccd1 hold124/X sky130_fd_sc_hd__dlygate4sd3_1
XFILLER_0_13_245 vssd1 vssd1 vccd1 vccd1 sky130_fd_sc_hd__fill_2
Xhold179 _1511_/Q vssd1 vssd1 vccd1 vccd1 hold38/A sky130_fd_sc_hd__dlygate4sd3_1
XANTENNA__1420__A _1426_/A vssd1 vssd1 vccd1 vccd1 sky130_fd_sc_hd__diode_2
X_0890_ _1084_/B _1490_/Q vssd1 vssd1 vccd1 vccd1 _0890_/Y sky130_fd_sc_hd__nand2_1
X_1442_ _1520_/CLK _1442_/D fanout124/X vssd1 vssd1 vccd1 vccd1 _1442_/Q sky130_fd_sc_hd__dfrtp_1
XFILLER_0_10_248 vssd1 vssd1 vccd1 vccd1 sky130_fd_sc_hd__fill_2
X_1511_ _1522_/CLK _1511_/D fanout123/X vssd1 vssd1 vccd1 vccd1 _1511_/Q sky130_fd_sc_hd__dfrtp_1
X_1373_ _1401_/A _1426_/B _1373_/C vssd1 vssd1 vccd1 vccd1 _1374_/B sky130_fd_sc_hd__nand3_1
Xclkbuf_4_15_0_clk_i clkbuf_0_clk_i/X vssd1 vssd1 vccd1 vccd1 _1509_/CLK sky130_fd_sc_hd__clkbuf_8
XANTENNA__1330__A _1431_/Q vssd1 vssd1 vccd1 vccd1 sky130_fd_sc_hd__diode_2
XFILLER_0_45_145 vssd1 vssd1 vccd1 vccd1 sky130_fd_sc_hd__decap_3
XTAP_292 vssd1 vccd1 sky130_fd_sc_hd__tapvpwrvgnd_1
XTAP_281 vssd1 vccd1 sky130_fd_sc_hd__tapvpwrvgnd_1
XTAP_270 vssd1 vccd1 sky130_fd_sc_hd__tapvpwrvgnd_1
XANTENNA__1224__B _1430_/Q vssd1 vssd1 vccd1 vccd1 sky130_fd_sc_hd__diode_2
XFILLER_0_36_145 vssd1 vssd1 vccd1 vccd1 sky130_fd_sc_hd__decap_3
XFILLER_0_36_112 vssd1 vssd1 vccd1 vccd1 sky130_fd_sc_hd__fill_2
XFILLER_0_27_101 vssd1 vssd1 vccd1 vccd1 sky130_fd_sc_hd__fill_2
X_0942_ hold145/X hold65/X _0966_/S vssd1 vssd1 vccd1 vccd1 _0943_/A sky130_fd_sc_hd__mux2_1
XFILLER_0_27_145 vssd1 vssd1 vccd1 vccd1 sky130_fd_sc_hd__decap_8
XFILLER_0_27_134 vssd1 vssd1 vccd1 vccd1 sky130_fd_sc_hd__decap_6
X_0873_ _0873_/A _0873_/B _0873_/C vssd1 vssd1 vccd1 vccd1 _0874_/A sky130_fd_sc_hd__nand3_1
X_1425_ _1424_/Y _1208_/X input31/X _1418_/A vssd1 vssd1 vccd1 vccd1 _1426_/C sky130_fd_sc_hd__a22o_1
X_1356_ _1356_/A _1356_/B vssd1 vssd1 vccd1 vccd1 _1356_/Y sky130_fd_sc_hd__nand2_1
X_1287_ _1404_/B _1287_/B vssd1 vssd1 vccd1 vccd1 _1306_/B sky130_fd_sc_hd__nor2_1
XFILLER_0_41_181 vssd1 vssd1 vccd1 vccd1 sky130_fd_sc_hd__fill_2
XFILLER_0_18_189 vssd1 vssd1 vccd1 vccd1 sky130_fd_sc_hd__decap_6
XANTENNA__1503__RESET_B fanout129/X vssd1 vssd1 vccd1 vccd1 sky130_fd_sc_hd__diode_2
XFILLER_0_21_38 vssd1 vssd1 vccd1 vccd1 sky130_fd_sc_hd__fill_2
XFILLER_0_24_115 vssd1 vssd1 vccd1 vccd1 sky130_fd_sc_hd__fill_2
XFILLER_0_32_181 vssd1 vssd1 vccd1 vccd1 sky130_fd_sc_hd__decap_3
X_1141_ hold3/X hold29/A vssd1 vssd1 vccd1 vccd1 _1142_/B sky130_fd_sc_hd__nand2_1
X_1072_ _1072_/A _1072_/B vssd1 vssd1 vccd1 vccd1 _1473_/D sky130_fd_sc_hd__nand2_1
X_1210_ _1207_/X _1208_/X _1209_/X vssd1 vssd1 vccd1 vccd1 _1212_/A sky130_fd_sc_hd__a21o_1
XANTENNA__0923__S _0933_/S vssd1 vssd1 vccd1 vccd1 sky130_fd_sc_hd__diode_2
X_0925_ hold147/X hold56/X _0933_/S vssd1 vssd1 vccd1 vccd1 _0926_/A sky130_fd_sc_hd__mux2_1
XFILLER_0_30_129 vssd1 vssd1 vccd1 vccd1 sky130_fd_sc_hd__decap_4
X_0856_ _1167_/C hold92/A _1167_/B vssd1 vssd1 vccd1 vccd1 _0856_/X sky130_fd_sc_hd__a21o_1
XFILLER_0_11_93 vssd1 vssd1 vccd1 vccd1 sky130_ef_sc_hd__decap_12
X_0787_ _0987_/B _0823_/C vssd1 vssd1 vccd1 vccd1 _1054_/C sky130_fd_sc_hd__nand2_1
XFILLER_0_15_159 vssd1 vssd1 vccd1 vccd1 sky130_fd_sc_hd__decap_8
Xhold39 hold39/A vssd1 vssd1 vccd1 vccd1 hold39/X sky130_fd_sc_hd__clkbuf_2
Xhold28 hold28/A vssd1 vssd1 vccd1 vccd1 hold28/X sky130_fd_sc_hd__clkbuf_2
X_1408_ _1426_/A _1408_/B _1420_/C vssd1 vssd1 vccd1 vccd1 _1409_/B sky130_fd_sc_hd__nand3_1
Xhold17 hold17/A vssd1 vssd1 vccd1 vccd1 hold17/X sky130_fd_sc_hd__dlygate4sd3_1
XFILLER_0_38_218 vssd1 vssd1 vccd1 vccd1 sky130_fd_sc_hd__fill_2
X_1339_ _1337_/Y _1345_/A _1338_/Y vssd1 vssd1 vccd1 vccd1 _1339_/Y sky130_fd_sc_hd__o21ai_1
X_1055_ _1164_/B vssd1 vssd1 vccd1 vccd1 _1170_/A sky130_fd_sc_hd__clkinv_4
X_1124_ _1124_/A vssd1 vssd1 vccd1 vccd1 _1496_/D sky130_fd_sc_hd__clkbuf_1
XFILLER_0_43_210 vssd1 vssd1 vccd1 vccd1 sky130_fd_sc_hd__fill_2
XFILLER_0_28_284 vssd1 vssd1 vccd1 vccd1 sky130_fd_sc_hd__decap_3
XFILLER_0_28_251 vssd1 vssd1 vccd1 vccd1 sky130_fd_sc_hd__fill_1
XFILLER_0_7_167 vssd1 vssd1 vccd1 vccd1 sky130_fd_sc_hd__fill_1
XFILLER_0_22_70 vssd1 vssd1 vccd1 vccd1 sky130_fd_sc_hd__fill_1
X_0908_ _0908_/A vssd1 vssd1 vccd1 vccd1 _1441_/D sky130_fd_sc_hd__clkbuf_1
X_0839_ _1082_/A _1492_/Q vssd1 vssd1 vccd1 vccd1 _0840_/C sky130_fd_sc_hd__nand2_1
XFILLER_0_34_265 vssd1 vssd1 vccd1 vccd1 sky130_ef_sc_hd__decap_12
XFILLER_0_34_221 vssd1 vssd1 vccd1 vccd1 sky130_fd_sc_hd__fill_2
XFILLER_0_43_25 vssd1 vssd1 vccd1 vccd1 sky130_fd_sc_hd__fill_2
XPHY_4 vssd1 vssd1 vccd1 vccd1 sky130_fd_sc_hd__decap_3
XFILLER_0_7_69 vssd1 vssd1 vccd1 vccd1 sky130_ef_sc_hd__decap_12
XFILLER_0_7_36 vssd1 vssd1 vccd1 vccd1 sky130_fd_sc_hd__decap_4
X_1038_ _1045_/A _1038_/B _1045_/B vssd1 vssd1 vccd1 vccd1 _1041_/A sky130_fd_sc_hd__nand3_1
X_1107_ hold107/X _0992_/A _1117_/S vssd1 vssd1 vccd1 vccd1 _1108_/A sky130_fd_sc_hd__mux2_1
XFILLER_0_17_81 vssd1 vssd1 vccd1 vccd1 sky130_fd_sc_hd__fill_1
XFILLER_0_33_91 vssd1 vssd1 vccd1 vccd1 sky130_fd_sc_hd__decap_4
XFILLER_0_16_210 vssd1 vssd1 vccd1 vccd1 sky130_ef_sc_hd__decap_12
XFILLER_0_16_265 vssd1 vssd1 vccd1 vccd1 sky130_fd_sc_hd__fill_1
XFILLER_0_16_298 vssd1 vssd1 vccd1 vccd1 sky130_fd_sc_hd__fill_1
XFILLER_0_3_181 vssd1 vssd1 vccd1 vccd1 sky130_fd_sc_hd__decap_4
XANTENNA__1227__B _1398_/B vssd1 vssd1 vccd1 vccd1 sky130_fd_sc_hd__diode_2
XANTENNA__0931__S _0933_/S vssd1 vssd1 vccd1 vccd1 sky130_fd_sc_hd__diode_2
XFILLER_0_13_213 vssd1 vssd1 vccd1 vccd1 sky130_fd_sc_hd__decap_6
Xhold114 _1356_/Y vssd1 vssd1 vccd1 vccd1 _1530_/D sky130_fd_sc_hd__dlygate4sd3_1
Xhold147 _1450_/Q vssd1 vssd1 vccd1 vccd1 hold147/X sky130_fd_sc_hd__dlygate4sd3_1
Xhold169 _1460_/Q vssd1 vssd1 vccd1 vccd1 hold169/X sky130_fd_sc_hd__dlygate4sd3_1
Xhold158 _1449_/Q vssd1 vssd1 vccd1 vccd1 hold158/X sky130_fd_sc_hd__dlygate4sd3_1
Xhold103 _1481_/Q vssd1 vssd1 vccd1 vccd1 hold103/X sky130_fd_sc_hd__dlygate4sd3_1
Xhold136 _1077_/Y vssd1 vssd1 vccd1 vccd1 _1078_/B sky130_fd_sc_hd__dlygate4sd3_1
Xclkbuf_4_11_0_clk_i clkbuf_0_clk_i/X vssd1 vssd1 vccd1 vccd1 _1471_/CLK sky130_fd_sc_hd__clkbuf_8
Xhold125 _1127_/X vssd1 vssd1 vccd1 vccd1 _1128_/A sky130_fd_sc_hd__dlygate4sd3_1
XANTENNA__1528__RESET_B fanout126/X vssd1 vssd1 vccd1 vccd1 sky130_fd_sc_hd__diode_2
XFILLER_0_8_295 vssd1 vssd1 vccd1 vccd1 sky130_fd_sc_hd__fill_1
XFILLER_0_39_110 vssd1 vssd1 vccd1 vccd1 sky130_fd_sc_hd__fill_2
XFILLER_0_24_27 vssd1 vssd1 vccd1 vccd1 sky130_fd_sc_hd__fill_1
XFILLER_0_39_165 vssd1 vssd1 vccd1 vccd1 sky130_fd_sc_hd__decap_3
X_1441_ _1520_/CLK _1441_/D fanout124/X vssd1 vssd1 vccd1 vccd1 _1441_/Q sky130_fd_sc_hd__dfrtp_1
XFILLER_0_10_227 vssd1 vssd1 vccd1 vccd1 sky130_fd_sc_hd__decap_4
X_1510_ _1522_/CLK _1510_/D fanout123/X vssd1 vssd1 vccd1 vccd1 _1510_/Q sky130_fd_sc_hd__dfrtp_1
XANTENNA__1196__A2 _1398_/B vssd1 vssd1 vccd1 vccd1 sky130_fd_sc_hd__diode_2
X_1372_ _1216_/A input22/X _1208_/X _1371_/Y vssd1 vssd1 vccd1 vccd1 _1373_/C sky130_fd_sc_hd__a22o_1
XTAP_293 vssd1 vccd1 sky130_fd_sc_hd__tapvpwrvgnd_1
XTAP_282 vssd1 vccd1 sky130_fd_sc_hd__tapvpwrvgnd_1
XTAP_271 vssd1 vccd1 sky130_fd_sc_hd__tapvpwrvgnd_1
XTAP_260 vssd1 vccd1 sky130_fd_sc_hd__tapvpwrvgnd_1
XANTENNA__1240__B _1426_/A vssd1 vssd1 vccd1 vccd1 sky130_fd_sc_hd__diode_2
XFILLER_0_36_168 vssd1 vssd1 vccd1 vccd1 sky130_fd_sc_hd__fill_1
XFILLER_0_44_190 vssd1 vssd1 vccd1 vccd1 sky130_fd_sc_hd__fill_1
XFILLER_0_19_27 vssd1 vssd1 vccd1 vccd1 sky130_ef_sc_hd__decap_12
X_0941_ _0941_/A vssd1 vssd1 vccd1 vccd1 _1457_/D sky130_fd_sc_hd__clkbuf_1
XFILLER_0_27_113 vssd1 vssd1 vccd1 vccd1 sky130_fd_sc_hd__decap_3
X_0872_ _0872_/A _1247_/B vssd1 vssd1 vccd1 vccd1 _0873_/C sky130_fd_sc_hd__nand2_1
X_1355_ _1401_/A _1426_/B _1355_/C vssd1 vssd1 vccd1 vccd1 _1356_/B sky130_fd_sc_hd__nand3_1
X_1424_ _1344_/Y _1423_/A _1423_/Y vssd1 vssd1 vccd1 vccd1 _1424_/Y sky130_fd_sc_hd__o21ai_1
XANTENNA__1341__A _1401_/A vssd1 vssd1 vccd1 vccd1 sky130_fd_sc_hd__diode_2
X_1286_ _1313_/A hold41/X vssd1 vssd1 vccd1 vccd1 _1296_/A sky130_fd_sc_hd__nand2_1
XFILLER_0_41_193 vssd1 vssd1 vccd1 vccd1 sky130_fd_sc_hd__fill_2
XFILLER_0_41_160 vssd1 vssd1 vccd1 vccd1 sky130_fd_sc_hd__fill_2
XFILLER_0_24_127 vssd1 vssd1 vccd1 vccd1 sky130_fd_sc_hd__decap_8
XFILLER_0_17_190 vssd1 vssd1 vccd1 vccd1 sky130_fd_sc_hd__fill_2
XANTENNA__1426__A _1426_/A vssd1 vssd1 vccd1 vccd1 sky130_fd_sc_hd__diode_2
X_1140_ _1140_/A vssd1 vssd1 vccd1 vccd1 _1148_/A sky130_fd_sc_hd__inv_2
X_1071_ _1077_/A _1071_/B vssd1 vssd1 vccd1 vccd1 _1072_/B sky130_fd_sc_hd__nand2_1
X_0924_ _0924_/A vssd1 vssd1 vccd1 vccd1 _1449_/D sky130_fd_sc_hd__clkbuf_1
X_0786_ _0786_/A vssd1 vssd1 vccd1 vccd1 _0987_/B sky130_fd_sc_hd__inv_2
X_0855_ _0855_/A hold70/X vssd1 vssd1 vccd1 vccd1 hold71/A sky130_fd_sc_hd__nand2_1
X_1338_ _1345_/A hold53/X vssd1 vssd1 vccd1 vccd1 _1338_/Y sky130_fd_sc_hd__nand2_1
X_1407_ _1056_/B _1405_/X _1406_/Y vssd1 vssd1 vccd1 vccd1 _1408_/B sky130_fd_sc_hd__o21ai_1
Xhold18 hold18/A vssd1 vssd1 vccd1 vccd1 hold18/X sky130_fd_sc_hd__dlygate4sd3_1
Xhold29 hold29/A vssd1 vssd1 vccd1 vccd1 hold29/X sky130_fd_sc_hd__dlygate4sd3_1
X_1269_ _1281_/A hold62/X vssd1 vssd1 vccd1 vccd1 _1269_/Y sky130_fd_sc_hd__nand2_1
XANTENNA__1069__A1 _1073_/B vssd1 vssd1 vccd1 vccd1 sky130_fd_sc_hd__diode_2
XFILLER_0_37_241 vssd1 vssd1 vccd1 vccd1 sky130_ef_sc_hd__decap_12
XFILLER_0_12_108 vssd1 vssd1 vccd1 vccd1 sky130_fd_sc_hd__fill_1
XFILLER_0_20_141 vssd1 vssd1 vccd1 vccd1 sky130_fd_sc_hd__decap_8
XANTENNA__0979__B _1012_/B vssd1 vssd1 vccd1 vccd1 sky130_fd_sc_hd__diode_2
XANTENNA__1465__RESET_B fanout128/X vssd1 vssd1 vccd1 vccd1 sky130_fd_sc_hd__diode_2
X_1054_ _1074_/B _1079_/A _1054_/C vssd1 vssd1 vccd1 vccd1 _1056_/A sky130_fd_sc_hd__and3_1
X_1123_ hold115/X _1000_/B _1129_/S vssd1 vssd1 vccd1 vccd1 _1123_/X sky130_fd_sc_hd__mux2_1
X_0907_ hold148/X hold68/X _0933_/S vssd1 vssd1 vccd1 vccd1 _0908_/A sky130_fd_sc_hd__mux2_1
XFILLER_0_7_146 vssd1 vssd1 vccd1 vccd1 sky130_fd_sc_hd__fill_1
XFILLER_0_7_102 vssd1 vssd1 vccd1 vccd1 sky130_fd_sc_hd__decap_6
XFILLER_0_22_82 vssd1 vssd1 vccd1 vccd1 sky130_fd_sc_hd__fill_2
X_0769_ hold6/X _1157_/A vssd1 vssd1 vccd1 vccd1 _1163_/A sky130_fd_sc_hd__nor2_1
X_0838_ _1167_/C _1496_/Q vssd1 vssd1 vccd1 vccd1 _0840_/B sky130_fd_sc_hd__nand2_1
XFILLER_0_11_141 vssd1 vssd1 vccd1 vccd1 sky130_fd_sc_hd__decap_8
XFILLER_0_11_185 vssd1 vssd1 vccd1 vccd1 sky130_fd_sc_hd__fill_1
XFILLER_0_19_263 vssd1 vssd1 vccd1 vccd1 sky130_fd_sc_hd__fill_1
XFILLER_0_34_277 vssd1 vssd1 vccd1 vccd1 sky130_ef_sc_hd__decap_12
XFILLER_0_34_233 vssd1 vssd1 vccd1 vccd1 sky130_ef_sc_hd__decap_12
XPHY_5 vssd1 vssd1 vccd1 vccd1 sky130_fd_sc_hd__decap_3
XFILLER_0_25_277 vssd1 vssd1 vccd1 vccd1 sky130_fd_sc_hd__decap_3
XFILLER_0_4_138 vssd1 vssd1 vccd1 vccd1 sky130_fd_sc_hd__fill_2
XFILLER_0_7_15 vssd1 vssd1 vccd1 vccd1 sky130_fd_sc_hd__fill_1
XANTENNA__0929__S _0933_/S vssd1 vssd1 vccd1 vccd1 sky130_fd_sc_hd__diode_2
XFILLER_0_30_7 vssd1 vssd1 vccd1 vccd1 sky130_fd_sc_hd__fill_1
X_1106_ _1106_/A vssd1 vssd1 vccd1 vccd1 _1487_/D sky130_fd_sc_hd__clkbuf_1
X_1037_ _1037_/A _1174_/A vssd1 vssd1 vccd1 vccd1 _1042_/A sky130_fd_sc_hd__nor2_1
XFILLER_0_31_269 vssd1 vssd1 vccd1 vccd1 sky130_fd_sc_hd__decap_8
XFILLER_0_31_236 vssd1 vssd1 vccd1 vccd1 sky130_fd_sc_hd__fill_1
XFILLER_0_31_225 vssd1 vssd1 vccd1 vccd1 sky130_fd_sc_hd__fill_2
Xhold126 _1439_/Q vssd1 vssd1 vccd1 vccd1 hold126/X sky130_fd_sc_hd__dlygate4sd3_1
Xhold104 _1480_/Q vssd1 vssd1 vccd1 vccd1 hold104/X sky130_fd_sc_hd__dlygate4sd3_1
Xhold115 _1496_/Q vssd1 vssd1 vccd1 vccd1 hold115/X sky130_fd_sc_hd__dlygate4sd3_1
Xhold159 _1453_/Q vssd1 vssd1 vccd1 vccd1 hold159/X sky130_fd_sc_hd__dlygate4sd3_1
XANTENNA__1344__A _1433_/Q vssd1 vssd1 vccd1 vccd1 sky130_fd_sc_hd__diode_2
Xhold148 _1441_/Q vssd1 vssd1 vccd1 vccd1 hold148/X sky130_fd_sc_hd__dlygate4sd3_1
XFILLER_0_0_141 vssd1 vssd1 vccd1 vccd1 sky130_ef_sc_hd__decap_12
Xhold137 _1078_/Y vssd1 vssd1 vccd1 vccd1 _1474_/D sky130_fd_sc_hd__dlygate4sd3_1
XFILLER_0_12_291 vssd1 vssd1 vccd1 vccd1 sky130_fd_sc_hd__decap_4
X_1371_ _1344_/Y _1370_/A _1370_/Y vssd1 vssd1 vccd1 vccd1 _1371_/Y sky130_fd_sc_hd__o21ai_1
X_1440_ _1520_/CLK _1440_/D fanout124/X vssd1 vssd1 vccd1 vccd1 _1440_/Q sky130_fd_sc_hd__dfrtp_1
XANTENNA__0942__S _0966_/S vssd1 vssd1 vccd1 vccd1 sky130_fd_sc_hd__diode_2
XFILLER_0_5_266 vssd1 vssd1 vccd1 vccd1 sky130_ef_sc_hd__decap_12
XTAP_294 vssd1 vccd1 sky130_fd_sc_hd__tapvpwrvgnd_1
XTAP_283 vssd1 vccd1 sky130_fd_sc_hd__tapvpwrvgnd_1
XTAP_272 vssd1 vccd1 sky130_fd_sc_hd__tapvpwrvgnd_1
XTAP_261 vssd1 vccd1 sky130_fd_sc_hd__tapvpwrvgnd_1
XTAP_250 vssd1 vccd1 sky130_fd_sc_hd__tapvpwrvgnd_1
Xclkbuf_4_9_0_clk_i clkbuf_0_clk_i/X vssd1 vssd1 vccd1 vccd1 _1525_/CLK sky130_fd_sc_hd__clkbuf_8
XFILLER_0_36_103 vssd1 vssd1 vccd1 vccd1 sky130_fd_sc_hd__fill_2
XFILLER_0_19_39 vssd1 vssd1 vccd1 vccd1 sky130_fd_sc_hd__decap_8
X_0940_ hold166/X hold53/X _0966_/S vssd1 vssd1 vccd1 vccd1 _0941_/A sky130_fd_sc_hd__mux2_1
XFILLER_0_27_169 vssd1 vssd1 vccd1 vccd1 sky130_ef_sc_hd__decap_12
XFILLER_0_42_139 vssd1 vssd1 vccd1 vccd1 sky130_fd_sc_hd__fill_1
X_0871_ _0871_/A _0871_/B _1045_/A vssd1 vssd1 vccd1 vccd1 _0873_/B sky130_fd_sc_hd__nand3_1
XFILLER_0_2_247 vssd1 vssd1 vccd1 vccd1 sky130_fd_sc_hd__fill_2
X_1423_ _1423_/A hold48/X vssd1 vssd1 vccd1 vccd1 _1423_/Y sky130_fd_sc_hd__nand2_1
X_1354_ _1216_/A input19/X _1208_/X _1353_/Y vssd1 vssd1 vccd1 vccd1 _1355_/C sky130_fd_sc_hd__a22o_1
X_1285_ _1285_/A _1285_/B vssd1 vssd1 vccd1 vccd1 _1521_/D sky130_fd_sc_hd__nand2_1
XFILLER_0_33_117 vssd1 vssd1 vccd1 vccd1 sky130_ef_sc_hd__decap_12
XANTENNA__1512__RESET_B fanout125/X vssd1 vssd1 vccd1 vccd1 sky130_fd_sc_hd__diode_2
XFILLER_0_24_139 vssd1 vssd1 vccd1 vccd1 sky130_fd_sc_hd__fill_1
XANTENNA__1426__B _1426_/B vssd1 vssd1 vccd1 vccd1 sky130_fd_sc_hd__diode_2
XANTENNA__1308__B1 _1398_/B vssd1 vssd1 vccd1 vccd1 sky130_fd_sc_hd__diode_2
X_1070_ _1076_/A _1426_/B _1070_/C vssd1 vssd1 vccd1 vccd1 _1072_/A sky130_fd_sc_hd__nand3_1
X_0923_ hold158/X hold32/X _0933_/S vssd1 vssd1 vccd1 vccd1 _0924_/A sky130_fd_sc_hd__mux2_1
XFILLER_0_15_117 vssd1 vssd1 vccd1 vccd1 sky130_fd_sc_hd__fill_1
X_0854_ _0898_/A hold69/X vssd1 vssd1 vccd1 vccd1 hold70/A sky130_fd_sc_hd__nand2_1
X_0785_ _1167_/A vssd1 vssd1 vccd1 vccd1 _1079_/B sky130_fd_sc_hd__inv_2
XFILLER_0_23_183 vssd1 vssd1 vccd1 vccd1 sky130_fd_sc_hd__fill_2
X_1337_ _1432_/Q vssd1 vssd1 vccd1 vccd1 _1337_/Y sky130_fd_sc_hd__inv_2
Xhold19 hold19/A vssd1 vssd1 vccd1 vccd1 hold19/X sky130_fd_sc_hd__buf_1
X_1406_ _1418_/A _1406_/B vssd1 vssd1 vccd1 vccd1 _1406_/Y sky130_fd_sc_hd__nand2_1
X_1268_ _1313_/A hold62/X vssd1 vssd1 vccd1 vccd1 _1273_/A sky130_fd_sc_hd__nand2_1
X_1199_ _1199_/A _1199_/B vssd1 vssd1 vccd1 vccd1 _1510_/D sky130_fd_sc_hd__nand2_1
XFILLER_0_46_253 vssd1 vssd1 vccd1 vccd1 sky130_ef_sc_hd__decap_12
XFILLER_0_14_194 vssd1 vssd1 vccd1 vccd1 sky130_fd_sc_hd__fill_2
XANTENNA__1246__B _1398_/B vssd1 vssd1 vccd1 vccd1 sky130_fd_sc_hd__diode_2
XFILLER_0_37_253 vssd1 vssd1 vccd1 vccd1 sky130_ef_sc_hd__decap_12
XFILLER_0_20_164 vssd1 vssd1 vccd1 vccd1 sky130_ef_sc_hd__decap_12
X_1122_ _1122_/A vssd1 vssd1 vccd1 vccd1 _1495_/D sky130_fd_sc_hd__clkbuf_1
XANTENNA__1434__RESET_B fanout127/X vssd1 vssd1 vccd1 vccd1 sky130_fd_sc_hd__diode_2
XFILLER_0_20_197 vssd1 vssd1 vccd1 vccd1 sky130_fd_sc_hd__decap_4
X_1053_ _1129_/S vssd1 vssd1 vccd1 vccd1 _1079_/A sky130_fd_sc_hd__inv_2
XFILLER_0_18_9 vssd1 vssd1 vccd1 vccd1 sky130_fd_sc_hd__fill_2
XANTENNA__0950__S _0966_/S vssd1 vssd1 vccd1 vccd1 sky130_fd_sc_hd__diode_2
XFILLER_0_28_253 vssd1 vssd1 vccd1 vccd1 sky130_fd_sc_hd__decap_3
X_0906_ _0906_/A vssd1 vssd1 vccd1 vccd1 _1440_/D sky130_fd_sc_hd__clkbuf_1
X_0837_ _1475_/Q _0837_/B vssd1 vssd1 vccd1 vccd1 _1167_/C sky130_fd_sc_hd__nor2_2
XFILLER_0_7_136 vssd1 vssd1 vccd1 vccd1 sky130_fd_sc_hd__decap_3
XFILLER_0_7_169 vssd1 vssd1 vccd1 vccd1 sky130_fd_sc_hd__decap_4
X_0768_ _1140_/A _0768_/B vssd1 vssd1 vccd1 vccd1 _1157_/A sky130_fd_sc_hd__nand2_1
XFILLER_0_34_289 vssd1 vssd1 vccd1 vccd1 sky130_fd_sc_hd__decap_8
XFILLER_0_34_245 vssd1 vssd1 vccd1 vccd1 sky130_fd_sc_hd__decap_6
XFILLER_0_6_180 vssd1 vssd1 vccd1 vccd1 sky130_fd_sc_hd__fill_2
XPHY_6 vssd1 vssd1 vccd1 vccd1 sky130_fd_sc_hd__decap_3
XFILLER_0_40_226 vssd1 vssd1 vccd1 vccd1 sky130_fd_sc_hd__fill_2
XFILLER_0_40_204 vssd1 vssd1 vccd1 vccd1 sky130_fd_sc_hd__fill_2
XFILLER_0_25_289 vssd1 vssd1 vccd1 vccd1 sky130_fd_sc_hd__decap_6
XFILLER_0_4_106 vssd1 vssd1 vccd1 vccd1 sky130_fd_sc_hd__decap_4
X_1105_ hold94/X _0994_/A _1117_/S vssd1 vssd1 vccd1 vccd1 _1106_/A sky130_fd_sc_hd__mux2_1
X_1036_ _1208_/A _1045_/A vssd1 vssd1 vccd1 vccd1 _1174_/A sky130_fd_sc_hd__nor2_2
XFILLER_0_16_201 vssd1 vssd1 vccd1 vccd1 sky130_fd_sc_hd__decap_6
Xhold138 _1469_/Q vssd1 vssd1 vccd1 vccd1 hold138/X sky130_fd_sc_hd__dlygate4sd3_1
Xhold149 _1448_/Q vssd1 vssd1 vccd1 vccd1 hold149/X sky130_fd_sc_hd__dlygate4sd3_1
Xhold105 _1490_/Q vssd1 vssd1 vccd1 vccd1 hold105/X sky130_fd_sc_hd__dlygate4sd3_1
XFILLER_0_13_204 vssd1 vssd1 vccd1 vccd1 sky130_fd_sc_hd__decap_6
Xhold127 _1471_/Q vssd1 vssd1 vccd1 vccd1 _1061_/B sky130_fd_sc_hd__clkbuf_2
Xhold116 _1123_/X vssd1 vssd1 vccd1 vccd1 _1124_/A sky130_fd_sc_hd__dlygate4sd3_1
XFILLER_0_28_71 vssd1 vssd1 vccd1 vccd1 sky130_ef_sc_hd__decap_12
XFILLER_0_0_153 vssd1 vssd1 vccd1 vccd1 sky130_ef_sc_hd__decap_12
XFILLER_0_0_197 vssd1 vssd1 vccd1 vccd1 sky130_fd_sc_hd__decap_8
X_1019_ _1019_/A vssd1 vssd1 vccd1 vccd1 _1021_/A sky130_fd_sc_hd__inv_2
XANTENNA__1537__RESET_B fanout129/X vssd1 vssd1 vccd1 vccd1 sky130_fd_sc_hd__diode_2
Xclkbuf_4_5_0_clk_i clkbuf_0_clk_i/X vssd1 vssd1 vccd1 vccd1 _1531_/CLK sky130_fd_sc_hd__clkbuf_8
XFILLER_0_5_6 vssd1 vssd1 vccd1 vccd1 sky130_fd_sc_hd__fill_2
XFILLER_0_12_270 vssd1 vssd1 vccd1 vccd1 sky130_fd_sc_hd__fill_1
XFILLER_0_24_29 vssd1 vssd1 vccd1 vccd1 sky130_ef_sc_hd__decap_12
X_1370_ _1370_/A hold89/X vssd1 vssd1 vccd1 vccd1 _1370_/Y sky130_fd_sc_hd__nand2_1
XFILLER_0_4_39 vssd1 vssd1 vccd1 vccd1 sky130_fd_sc_hd__fill_2
XFILLER_0_5_223 vssd1 vssd1 vccd1 vccd1 sky130_fd_sc_hd__fill_1
XANTENNA__1355__A _1401_/A vssd1 vssd1 vccd1 vccd1 sky130_fd_sc_hd__diode_2
XFILLER_0_5_278 vssd1 vssd1 vccd1 vccd1 sky130_fd_sc_hd__fill_2
XTAP_295 vssd1 vccd1 sky130_fd_sc_hd__tapvpwrvgnd_1
XTAP_284 vssd1 vccd1 sky130_fd_sc_hd__tapvpwrvgnd_1
XTAP_273 vssd1 vccd1 sky130_fd_sc_hd__tapvpwrvgnd_1
XTAP_262 vssd1 vccd1 sky130_fd_sc_hd__tapvpwrvgnd_1
XTAP_251 vssd1 vccd1 sky130_fd_sc_hd__tapvpwrvgnd_1
XTAP_240 vssd1 vccd1 sky130_fd_sc_hd__tapvpwrvgnd_1
X_1499_ _1515_/CLK _1499_/D fanout123/X vssd1 vssd1 vccd1 vccd1 hold96/A sky130_fd_sc_hd__dfrtp_1
XFILLER_0_36_137 vssd1 vssd1 vccd1 vccd1 sky130_fd_sc_hd__decap_3
XANTENNA__1249__B _1426_/A vssd1 vssd1 vccd1 vccd1 sky130_fd_sc_hd__diode_2
X_0870_ _1306_/A _1287_/B _0867_/Y _0868_/Y _0869_/Y vssd1 vssd1 vccd1 vccd1 _0871_/B
+ sky130_fd_sc_hd__o2111ai_1
X_1422_ _1422_/A hold48/X vssd1 vssd1 vccd1 vccd1 _1427_/A sky130_fd_sc_hd__nand2_1
X_1353_ _1323_/Y _1370_/A _1352_/Y vssd1 vssd1 vccd1 vccd1 _1353_/Y sky130_fd_sc_hd__o21ai_1
Xclkbuf_0_clk_i clk_i vssd1 vssd1 vccd1 vccd1 clkbuf_0_clk_i/X sky130_fd_sc_hd__clkbuf_16
X_1284_ _1401_/A _1284_/B _1334_/C vssd1 vssd1 vccd1 vccd1 _1285_/B sky130_fd_sc_hd__nand3_1
XFILLER_0_18_115 vssd1 vssd1 vccd1 vccd1 sky130_fd_sc_hd__fill_1
XFILLER_0_18_126 vssd1 vssd1 vccd1 vccd1 sky130_fd_sc_hd__decap_3
XFILLER_0_33_129 vssd1 vssd1 vccd1 vccd1 sky130_ef_sc_hd__decap_12
XFILLER_0_33_107 vssd1 vssd1 vccd1 vccd1 sky130_fd_sc_hd__fill_2
XFILLER_0_26_170 vssd1 vssd1 vccd1 vccd1 sky130_fd_sc_hd__fill_2
X_0999_ _0999_/A _0999_/B vssd1 vssd1 vccd1 vccd1 _1011_/A sky130_fd_sc_hd__nand2_1
XFILLER_0_41_173 vssd1 vssd1 vccd1 vccd1 sky130_fd_sc_hd__fill_2
XFILLER_0_24_107 vssd1 vssd1 vccd1 vccd1 sky130_fd_sc_hd__fill_1
XFILLER_0_32_195 vssd1 vssd1 vccd1 vccd1 sky130_fd_sc_hd__fill_1
X_0922_ _0922_/A vssd1 vssd1 vccd1 vccd1 _1448_/D sky130_fd_sc_hd__clkbuf_1
X_0853_ _0853_/A _0897_/B vssd1 vssd1 vccd1 vccd1 _0855_/A sky130_fd_sc_hd__nand2_1
XANTENNA__0948__S _0966_/S vssd1 vssd1 vccd1 vccd1 sky130_fd_sc_hd__diode_2
X_1405_ _1323_/Y _0798_/Y _1423_/A vssd1 vssd1 vccd1 vccd1 _1405_/X sky130_fd_sc_hd__mux2_1
X_0784_ _0900_/A _0784_/B vssd1 vssd1 vccd1 vccd1 _1167_/A sky130_fd_sc_hd__nor2_2
XFILLER_0_23_151 vssd1 vssd1 vccd1 vccd1 sky130_fd_sc_hd__fill_1
XFILLER_0_23_173 vssd1 vssd1 vccd1 vccd1 sky130_fd_sc_hd__fill_2
X_1336_ _1422_/A hold53/X vssd1 vssd1 vccd1 vccd1 _1342_/A sky130_fd_sc_hd__nand2_1
Xinput1 nrst_i vssd1 vssd1 vccd1 vccd1 input1/X sky130_fd_sc_hd__buf_1
X_1198_ _1198_/A _1426_/A _1426_/B vssd1 vssd1 vccd1 vccd1 _1199_/B sky130_fd_sc_hd__nand3_1
X_1267_ _1267_/A _1267_/B vssd1 vssd1 vccd1 vccd1 _1518_/D sky130_fd_sc_hd__nand2_1
XFILLER_0_46_265 vssd1 vssd1 vccd1 vccd1 sky130_ef_sc_hd__decap_12
XFILLER_0_37_265 vssd1 vssd1 vccd1 vccd1 sky130_ef_sc_hd__decap_12
XFILLER_0_37_221 vssd1 vssd1 vccd1 vccd1 sky130_fd_sc_hd__decap_3
XANTENNA__0752__A2 _1398_/B vssd1 vssd1 vccd1 vccd1 sky130_fd_sc_hd__diode_2
XFILLER_0_20_176 vssd1 vssd1 vccd1 vccd1 sky130_ef_sc_hd__decap_12
X_1121_ hold109/X _1001_/A _1129_/S vssd1 vssd1 vccd1 vccd1 _1121_/X sky130_fd_sc_hd__mux2_1
X_1052_ _1052_/A _1052_/B vssd1 vssd1 vccd1 vccd1 _1074_/B sky130_fd_sc_hd__nor2_1
XFILLER_0_28_276 vssd1 vssd1 vccd1 vccd1 sky130_fd_sc_hd__decap_8
XANTENNA__1474__RESET_B fanout129/X vssd1 vssd1 vccd1 vccd1 sky130_fd_sc_hd__diode_2
XFILLER_0_43_279 vssd1 vssd1 vccd1 vccd1 sky130_fd_sc_hd__fill_1
XFILLER_0_28_298 vssd1 vssd1 vccd1 vccd1 sky130_fd_sc_hd__fill_1
X_0905_ hold139/X hold38/X _0933_/S vssd1 vssd1 vccd1 vccd1 _0906_/A sky130_fd_sc_hd__mux2_1
X_0836_ _1084_/B _1488_/Q _1167_/B vssd1 vssd1 vccd1 vccd1 _0840_/A sky130_fd_sc_hd__a21oi_1
X_0767_ hold9/X hold33/X vssd1 vssd1 vccd1 vccd1 _0768_/B sky130_fd_sc_hd__nor2_1
XFILLER_0_44_3 vssd1 vssd1 vccd1 vccd1 sky130_fd_sc_hd__fill_1
X_1319_ _1319_/A _1426_/A _1334_/C vssd1 vssd1 vccd1 vccd1 _1320_/B sky130_fd_sc_hd__nand3_1
XPHY_7 vssd1 vssd1 vccd1 vccd1 sky130_fd_sc_hd__decap_3
XFILLER_0_4_118 vssd1 vssd1 vccd1 vccd1 sky130_ef_sc_hd__decap_12
X_1035_ _1035_/A _1035_/B vssd1 vssd1 vccd1 vccd1 _1037_/A sky130_fd_sc_hd__nand2_1
X_1104_ _1104_/A vssd1 vssd1 vccd1 vccd1 _1486_/D sky130_fd_sc_hd__clkbuf_1
XFILLER_0_17_73 vssd1 vssd1 vccd1 vccd1 sky130_fd_sc_hd__fill_2
XFILLER_0_17_84 vssd1 vssd1 vccd1 vccd1 sky130_fd_sc_hd__decap_4
XFILLER_0_33_83 vssd1 vssd1 vccd1 vccd1 sky130_fd_sc_hd__fill_2
XFILLER_0_33_72 vssd1 vssd1 vccd1 vccd1 sky130_fd_sc_hd__decap_4
Xinput70 sport_i[67] vssd1 vssd1 vccd1 vccd1 _1040_/C sky130_fd_sc_hd__clkbuf_2
XFILLER_0_3_140 vssd1 vssd1 vccd1 vccd1 sky130_ef_sc_hd__decap_12
X_0819_ hold24/X _1471_/Q _0823_/C vssd1 vssd1 vccd1 vccd1 _0820_/B sky130_fd_sc_hd__o21ai_1
Xclkbuf_4_1_0_clk_i clkbuf_0_clk_i/X vssd1 vssd1 vccd1 vccd1 _1521_/CLK sky130_fd_sc_hd__clkbuf_8
XFILLER_0_22_205 vssd1 vssd1 vccd1 vccd1 sky130_fd_sc_hd__fill_2
XFILLER_0_22_216 vssd1 vssd1 vccd1 vccd1 sky130_fd_sc_hd__fill_1
Xhold139 _1440_/Q vssd1 vssd1 vccd1 vccd1 hold139/X sky130_fd_sc_hd__dlygate4sd3_1
Xhold117 _1484_/Q vssd1 vssd1 vccd1 vccd1 hold117/X sky130_fd_sc_hd__dlygate4sd3_1
Xhold106 _1491_/Q vssd1 vssd1 vccd1 vccd1 hold106/X sky130_fd_sc_hd__dlygate4sd3_1
Xhold128 _1061_/Y vssd1 vssd1 vccd1 vccd1 _1062_/B sky130_fd_sc_hd__dlygate4sd3_1
XANTENNA__0956__S _0966_/S vssd1 vssd1 vccd1 vccd1 sky130_fd_sc_hd__diode_2
XFILLER_0_28_83 vssd1 vssd1 vccd1 vccd1 sky130_fd_sc_hd__fill_1
XFILLER_0_0_165 vssd1 vssd1 vccd1 vccd1 sky130_fd_sc_hd__decap_3
XFILLER_0_44_82 vssd1 vssd1 vccd1 vccd1 sky130_fd_sc_hd__fill_2
X_1018_ _1018_/A _1018_/B vssd1 vssd1 vccd1 vccd1 _1022_/A sky130_fd_sc_hd__nand2_1
XFILLER_0_8_243 vssd1 vssd1 vccd1 vccd1 sky130_fd_sc_hd__decap_6
XANTENNA__1506__RESET_B fanout127/X vssd1 vssd1 vccd1 vccd1 sky130_fd_sc_hd__diode_2
XFILLER_0_39_146 vssd1 vssd1 vccd1 vccd1 sky130_fd_sc_hd__fill_1
XFILLER_0_39_113 vssd1 vssd1 vccd1 vccd1 sky130_fd_sc_hd__decap_3
XFILLER_0_40_29 vssd1 vssd1 vccd1 vccd1 sky130_fd_sc_hd__fill_1
XFILLER_0_10_219 vssd1 vssd1 vccd1 vccd1 sky130_fd_sc_hd__fill_2
XFILLER_0_4_29 vssd1 vssd1 vccd1 vccd1 sky130_fd_sc_hd__fill_1
XFILLER_0_30_40 vssd1 vssd1 vccd1 vccd1 sky130_fd_sc_hd__decap_3
XFILLER_0_5_202 vssd1 vssd1 vccd1 vccd1 sky130_fd_sc_hd__fill_1
XANTENNA__1355__B _1426_/B vssd1 vssd1 vccd1 vccd1 sky130_fd_sc_hd__diode_2
XTAP_241 vssd1 vccd1 sky130_fd_sc_hd__tapvpwrvgnd_1
XTAP_230 vssd1 vccd1 sky130_fd_sc_hd__tapvpwrvgnd_1
XTAP_296 vssd1 vccd1 sky130_fd_sc_hd__tapvpwrvgnd_1
XTAP_285 vssd1 vccd1 sky130_fd_sc_hd__tapvpwrvgnd_1
XTAP_274 vssd1 vccd1 sky130_fd_sc_hd__tapvpwrvgnd_1
XTAP_263 vssd1 vccd1 sky130_fd_sc_hd__tapvpwrvgnd_1
XTAP_252 vssd1 vccd1 sky130_fd_sc_hd__tapvpwrvgnd_1
X_1498_ _1521_/CLK _1498_/D fanout123/X vssd1 vssd1 vccd1 vccd1 _1498_/Q sky130_fd_sc_hd__dfrtp_1
XFILLER_0_36_127 vssd1 vssd1 vccd1 vccd1 sky130_fd_sc_hd__fill_1
XFILLER_0_36_116 vssd1 vssd1 vccd1 vccd1 sky130_fd_sc_hd__fill_1
XFILLER_0_29_190 vssd1 vssd1 vccd1 vccd1 sky130_fd_sc_hd__decap_8
XFILLER_0_35_160 vssd1 vssd1 vccd1 vccd1 sky130_fd_sc_hd__decap_8
XFILLER_0_27_105 vssd1 vssd1 vccd1 vccd1 sky130_fd_sc_hd__fill_1
X_1421_ _1421_/A _1421_/B vssd1 vssd1 vccd1 vccd1 hold15/A sky130_fd_sc_hd__nand2_1
XANTENNA__1428__RESET_B fanout128/X vssd1 vssd1 vccd1 vccd1 sky130_fd_sc_hd__diode_2
X_1352_ _1370_/A _1352_/B vssd1 vssd1 vccd1 vccd1 _1352_/Y sky130_fd_sc_hd__nand2_1
X_1283_ _1216_/A input9/X _1282_/Y _1208_/X vssd1 vssd1 vccd1 vccd1 _1284_/B sky130_fd_sc_hd__a22o_1
XFILLER_0_41_152 vssd1 vssd1 vccd1 vccd1 sky130_fd_sc_hd__fill_1
X_0998_ _0998_/A _0998_/B _0998_/C vssd1 vssd1 vccd1 vccd1 _0999_/B sky130_fd_sc_hd__nor3_1
XANTENNA_fanout128_A fanout129/X vssd1 vssd1 vccd1 vccd1 sky130_fd_sc_hd__diode_2
X_0921_ hold149/X hold62/X _0933_/S vssd1 vssd1 vccd1 vccd1 _0922_/A sky130_fd_sc_hd__mux2_1
X_0783_ hold95/A _0794_/B _1476_/Q _0782_/X vssd1 vssd1 vccd1 vccd1 _0783_/X sky130_fd_sc_hd__o211a_1
X_0852_ _0831_/X _0852_/B _0852_/C vssd1 vssd1 vccd1 vccd1 _0853_/A sky130_fd_sc_hd__nand3b_1
XFILLER_0_23_163 vssd1 vssd1 vccd1 vccd1 sky130_fd_sc_hd__fill_2
X_1335_ _1335_/A _1335_/B vssd1 vssd1 vccd1 vccd1 _1527_/D sky130_fd_sc_hd__nand2_1
X_1404_ _1404_/A _1404_/B vssd1 vssd1 vccd1 vccd1 _1423_/A sky130_fd_sc_hd__nand2_2
XANTENNA__0964__S _0966_/S vssd1 vssd1 vccd1 vccd1 sky130_fd_sc_hd__diode_2
X_1197_ _1261_/A vssd1 vssd1 vccd1 vccd1 _1426_/A sky130_fd_sc_hd__buf_6
Xinput2 spi_dqsm_i vssd1 vssd1 vccd1 vccd1 input2/X sky130_fd_sc_hd__clkbuf_1
X_1266_ _1401_/A _1266_/B _1334_/C vssd1 vssd1 vccd1 vccd1 _1267_/B sky130_fd_sc_hd__nand3_1
XFILLER_0_46_277 vssd1 vssd1 vccd1 vccd1 sky130_fd_sc_hd__decap_3
XFILLER_0_46_211 vssd1 vssd1 vccd1 vccd1 sky130_ef_sc_hd__decap_12
XFILLER_0_14_174 vssd1 vssd1 vccd1 vccd1 sky130_fd_sc_hd__fill_1
XFILLER_0_37_200 vssd1 vssd1 vccd1 vccd1 sky130_fd_sc_hd__fill_2
XANTENNA_clkbuf_4_3_0_clk_i_A clkbuf_0_clk_i/X vssd1 vssd1 vccd1 vccd1 sky130_fd_sc_hd__diode_2
XFILLER_0_37_277 vssd1 vssd1 vccd1 vccd1 sky130_fd_sc_hd__decap_3
XFILLER_0_9_190 vssd1 vssd1 vccd1 vccd1 sky130_ef_sc_hd__decap_12
XFILLER_0_20_155 vssd1 vssd1 vccd1 vccd1 sky130_fd_sc_hd__decap_6
XFILLER_0_20_188 vssd1 vssd1 vccd1 vccd1 sky130_fd_sc_hd__decap_8
X_1051_ _1420_/C vssd1 vssd1 vccd1 vccd1 _1426_/B sky130_fd_sc_hd__buf_6
X_1120_ _1120_/A vssd1 vssd1 vccd1 vccd1 _1494_/D sky130_fd_sc_hd__clkbuf_1
XFILLER_0_43_225 vssd1 vssd1 vccd1 vccd1 sky130_ef_sc_hd__decap_12
XFILLER_0_43_214 vssd1 vssd1 vccd1 vccd1 sky130_fd_sc_hd__fill_2
XFILLER_0_28_266 vssd1 vssd1 vccd1 vccd1 sky130_fd_sc_hd__fill_2
X_0904_ _0904_/A vssd1 vssd1 vccd1 vccd1 _1439_/D sky130_fd_sc_hd__clkbuf_1
XFILLER_0_22_85 vssd1 vssd1 vccd1 vccd1 sky130_ef_sc_hd__decap_12
X_0766_ hold3/X hold29/X vssd1 vssd1 vccd1 vccd1 _1140_/A sky130_fd_sc_hd__nor2_1
X_0835_ hold78/X vssd1 vssd1 vccd1 vccd1 _1167_/B sky130_fd_sc_hd__inv_2
XFILLER_0_11_111 vssd1 vssd1 vccd1 vccd1 sky130_fd_sc_hd__fill_1
X_1318_ _1318_/A _1318_/B vssd1 vssd1 vccd1 vccd1 _1319_/A sky130_fd_sc_hd__nand2_1
XFILLER_0_19_233 vssd1 vssd1 vccd1 vccd1 sky130_fd_sc_hd__fill_2
X_1249_ _1249_/A _1426_/A _1334_/C vssd1 vssd1 vccd1 vccd1 _1250_/B sky130_fd_sc_hd__nand3_1
XFILLER_0_34_225 vssd1 vssd1 vccd1 vccd1 sky130_fd_sc_hd__fill_2
XFILLER_0_43_29 vssd1 vssd1 vccd1 vccd1 sky130_fd_sc_hd__fill_2
XFILLER_0_25_225 vssd1 vssd1 vccd1 vccd1 sky130_ef_sc_hd__decap_12
XPHY_8 vssd1 vssd1 vccd1 vccd1 sky130_fd_sc_hd__decap_3
XANTENNA__1383__A0 _1431_/Q vssd1 vssd1 vccd1 vccd1 sky130_fd_sc_hd__diode_2
X_1034_ _1040_/C _1034_/B vssd1 vssd1 vccd1 vccd1 _1035_/B sky130_fd_sc_hd__nor2_1
XANTENNA__0808__A hold41/X vssd1 vssd1 vccd1 vccd1 sky130_fd_sc_hd__diode_2
X_1103_ hold118/X _0995_/A _1117_/S vssd1 vssd1 vccd1 vccd1 _1104_/A sky130_fd_sc_hd__mux2_1
XFILLER_0_17_63 vssd1 vssd1 vccd1 vccd1 sky130_fd_sc_hd__decap_6
XFILLER_0_23_9 vssd1 vssd1 vccd1 vccd1 sky130_fd_sc_hd__fill_2
XFILLER_0_31_206 vssd1 vssd1 vccd1 vccd1 sky130_fd_sc_hd__fill_2
XFILLER_0_16_225 vssd1 vssd1 vccd1 vccd1 sky130_fd_sc_hd__fill_1
XFILLER_0_16_236 vssd1 vssd1 vccd1 vccd1 sky130_ef_sc_hd__decap_12
Xinput71 sport_i[68] vssd1 vssd1 vccd1 vccd1 _1073_/B sky130_fd_sc_hd__clkbuf_2
X_0749_ _1046_/A vssd1 vssd1 vccd1 vccd1 _1262_/B sky130_fd_sc_hd__inv_6
Xinput60 sport_i[58] vssd1 vssd1 vccd1 vccd1 _1017_/A sky130_fd_sc_hd__clkbuf_1
XFILLER_0_3_152 vssd1 vssd1 vccd1 vccd1 sky130_ef_sc_hd__decap_12
X_0818_ _1045_/A _0872_/A vssd1 vssd1 vccd1 vccd1 _1193_/A sky130_fd_sc_hd__nor2_1
XANTENNA__1284__A _1401_/A vssd1 vssd1 vccd1 vccd1 sky130_fd_sc_hd__diode_2
Xhold118 _1486_/Q vssd1 vssd1 vccd1 vccd1 hold118/X sky130_fd_sc_hd__dlygate4sd3_1
Xhold107 _1488_/Q vssd1 vssd1 vccd1 vccd1 hold107/X sky130_fd_sc_hd__dlygate4sd3_1
Xhold129 _1062_/Y vssd1 vssd1 vccd1 vccd1 _1471_/D sky130_fd_sc_hd__dlygate4sd3_1
XFILLER_0_21_261 vssd1 vssd1 vccd1 vccd1 sky130_fd_sc_hd__decap_3
X_1017_ _1017_/A vssd1 vssd1 vccd1 vccd1 _1018_/B sky130_fd_sc_hd__inv_2
XFILLER_0_39_169 vssd1 vssd1 vccd1 vccd1 sky130_fd_sc_hd__decap_6
XANTENNA__0877__A1_N _1256_/B vssd1 vssd1 vccd1 vccd1 sky130_fd_sc_hd__diode_2
XFILLER_0_30_85 vssd1 vssd1 vccd1 vccd1 sky130_fd_sc_hd__decap_6
XTAP_275 vssd1 vccd1 sky130_fd_sc_hd__tapvpwrvgnd_1
XTAP_264 vssd1 vccd1 sky130_fd_sc_hd__tapvpwrvgnd_1
XTAP_253 vssd1 vccd1 sky130_fd_sc_hd__tapvpwrvgnd_1
XTAP_242 vssd1 vccd1 sky130_fd_sc_hd__tapvpwrvgnd_1
XTAP_231 vssd1 vccd1 sky130_fd_sc_hd__tapvpwrvgnd_1
X_1497_ _1515_/CLK _1497_/D fanout123/X vssd1 vssd1 vccd1 vccd1 hold92/A sky130_fd_sc_hd__dfrtp_1
XTAP_220 vssd1 vccd1 sky130_fd_sc_hd__tapvpwrvgnd_1
XTAP_297 vssd1 vccd1 sky130_fd_sc_hd__tapvpwrvgnd_1
XTAP_286 vssd1 vccd1 sky130_fd_sc_hd__tapvpwrvgnd_1
XFILLER_0_44_194 vssd1 vssd1 vccd1 vccd1 sky130_fd_sc_hd__fill_2
XANTENNA__1468__RESET_B fanout125/X vssd1 vssd1 vccd1 vccd1 sky130_fd_sc_hd__diode_2
X_1420_ _1426_/A _1420_/B _1420_/C vssd1 vssd1 vccd1 vccd1 _1421_/B sky130_fd_sc_hd__nand3_1
X_1351_ _1351_/A _1404_/B vssd1 vssd1 vccd1 vccd1 _1370_/A sky130_fd_sc_hd__nand2_2
X_1282_ _1281_/A _1253_/B _1281_/Y vssd1 vssd1 vccd1 vccd1 _1282_/Y sky130_fd_sc_hd__o21ai_1
XFILLER_0_41_51 vssd1 vssd1 vccd1 vccd1 sky130_fd_sc_hd__fill_2
XFILLER_0_18_139 vssd1 vssd1 vccd1 vccd1 sky130_fd_sc_hd__fill_1
XFILLER_0_41_197 vssd1 vssd1 vccd1 vccd1 sky130_fd_sc_hd__decap_3
XFILLER_0_41_164 vssd1 vssd1 vccd1 vccd1 sky130_fd_sc_hd__fill_2
XANTENNA__0773__A1 _1398_/B vssd1 vssd1 vccd1 vccd1 sky130_fd_sc_hd__diode_2
XFILLER_0_26_150 vssd1 vssd1 vccd1 vccd1 sky130_fd_sc_hd__fill_1
X_0997_ _0997_/A _0997_/B vssd1 vssd1 vccd1 vccd1 _0999_/A sky130_fd_sc_hd__nor2_1
XFILLER_0_5_84 vssd1 vssd1 vccd1 vccd1 sky130_ef_sc_hd__decap_12
XFILLER_0_17_194 vssd1 vssd1 vccd1 vccd1 sky130_fd_sc_hd__fill_1
XFILLER_0_32_197 vssd1 vssd1 vccd1 vccd1 sky130_fd_sc_hd__decap_8
XFILLER_0_32_164 vssd1 vssd1 vccd1 vccd1 sky130_fd_sc_hd__fill_2
XFILLER_0_46_29 vssd1 vssd1 vccd1 vccd1 sky130_fd_sc_hd__decap_4
X_0920_ _0920_/A vssd1 vssd1 vccd1 vccd1 _1447_/D sky130_fd_sc_hd__clkbuf_1
X_0851_ _0851_/A _0851_/B _1045_/A vssd1 vssd1 vccd1 vccd1 _0852_/C sky130_fd_sc_hd__nand3_1
X_0782_ _1475_/Q _1481_/Q vssd1 vssd1 vccd1 vccd1 _0782_/X sky130_fd_sc_hd__or2_1
XFILLER_0_11_54 vssd1 vssd1 vccd1 vccd1 sky130_fd_sc_hd__fill_2
X_1403_ _1422_/A hold12/X vssd1 vssd1 vccd1 vccd1 _1409_/A sky130_fd_sc_hd__nand2_1
X_1334_ _1401_/A _1334_/B _1334_/C vssd1 vssd1 vccd1 vccd1 _1335_/B sky130_fd_sc_hd__nand3_1
X_1265_ _1216_/A input74/X _1264_/Y _1208_/X vssd1 vssd1 vccd1 vccd1 _1266_/B sky130_fd_sc_hd__a22o_1
Xinput3 spi_miso_i[0] vssd1 vssd1 vccd1 vccd1 input3/X sky130_fd_sc_hd__clkbuf_1
X_1196_ _1192_/X _1398_/B _1195_/X vssd1 vssd1 vccd1 vccd1 _1198_/A sky130_fd_sc_hd__a21o_1
XFILLER_0_46_223 vssd1 vssd1 vccd1 vccd1 sky130_fd_sc_hd__fill_1
XANTENNA_clkbuf_4_10_0_clk_i_A clkbuf_0_clk_i/X vssd1 vssd1 vccd1 vccd1 sky130_fd_sc_hd__diode_2
XFILLER_0_14_153 vssd1 vssd1 vccd1 vccd1 sky130_fd_sc_hd__decap_8
XANTENNA_clkbuf_4_7_0_clk_i_A clkbuf_0_clk_i/X vssd1 vssd1 vccd1 vccd1 sky130_fd_sc_hd__diode_2
X_1050_ _1050_/A vssd1 vssd1 vccd1 vccd1 _1420_/C sky130_fd_sc_hd__inv_2
XFILLER_0_43_237 vssd1 vssd1 vccd1 vccd1 sky130_ef_sc_hd__decap_12
XFILLER_0_28_201 vssd1 vssd1 vccd1 vccd1 sky130_fd_sc_hd__fill_1
X_0903_ hold126/X hold23/X _0933_/S vssd1 vssd1 vccd1 vccd1 _0904_/A sky130_fd_sc_hd__mux2_1
X_0834_ _1486_/Q _0794_/B _1476_/Q _0833_/X vssd1 vssd1 vccd1 vccd1 _0834_/X sky130_fd_sc_hd__o211a_1
XFILLER_0_22_97 vssd1 vssd1 vccd1 vccd1 sky130_ef_sc_hd__decap_12
X_0765_ _0988_/A _1164_/B _1038_/B vssd1 vssd1 vccd1 vccd1 _0765_/X sky130_fd_sc_hd__or3b_1
XFILLER_0_11_167 vssd1 vssd1 vccd1 vccd1 sky130_fd_sc_hd__fill_1
X_1317_ _1418_/A _1317_/B vssd1 vssd1 vccd1 vccd1 _1318_/B sky130_fd_sc_hd__nand2_1
X_1248_ _1248_/A _1248_/B vssd1 vssd1 vccd1 vccd1 _1249_/A sky130_fd_sc_hd__nand2_1
X_1179_ _1184_/A _1262_/A _1175_/A vssd1 vssd1 vccd1 vccd1 _1179_/Y sky130_fd_sc_hd__o21ai_1
XPHY_9 vssd1 vssd1 vccd1 vccd1 sky130_fd_sc_hd__decap_3
XFILLER_0_25_237 vssd1 vssd1 vccd1 vccd1 sky130_fd_sc_hd__decap_3
XFILLER_0_33_281 vssd1 vssd1 vccd1 vccd1 sky130_ef_sc_hd__decap_12
X_1102_ _1102_/A vssd1 vssd1 vccd1 vccd1 _1485_/D sky130_fd_sc_hd__clkbuf_1
X_1033_ _1033_/A _1033_/B vssd1 vssd1 vccd1 vccd1 _1043_/A sky130_fd_sc_hd__nand2_1
XFILLER_0_31_229 vssd1 vssd1 vccd1 vccd1 sky130_fd_sc_hd__decap_4
Xinput61 sport_i[59] vssd1 vssd1 vccd1 vccd1 _1016_/A sky130_fd_sc_hd__clkbuf_1
Xinput72 sport_i[6] vssd1 vssd1 vccd1 vccd1 _1247_/B sky130_fd_sc_hd__buf_1
X_0817_ _0817_/A _0982_/A vssd1 vssd1 vccd1 vccd1 _1129_/S sky130_fd_sc_hd__nor2_4
XFILLER_0_16_248 vssd1 vssd1 vccd1 vccd1 sky130_fd_sc_hd__decap_4
Xinput50 sport_i[49] vssd1 vssd1 vccd1 vccd1 _1001_/A sky130_fd_sc_hd__buf_1
X_0748_ _0748_/A vssd1 vssd1 vccd1 vccd1 _1046_/A sky130_fd_sc_hd__buf_4
XFILLER_0_3_164 vssd1 vssd1 vccd1 vccd1 sky130_fd_sc_hd__decap_4
XFILLER_0_30_273 vssd1 vssd1 vccd1 vccd1 sky130_fd_sc_hd__decap_3
XFILLER_0_30_251 vssd1 vssd1 vccd1 vccd1 sky130_fd_sc_hd__fill_1
Xhold108 _1493_/Q vssd1 vssd1 vccd1 vccd1 hold108/X sky130_fd_sc_hd__dlygate4sd3_1
Xhold119 _1492_/Q vssd1 vssd1 vccd1 vccd1 hold119/X sky130_fd_sc_hd__dlygate4sd3_1
XFILLER_0_28_85 vssd1 vssd1 vccd1 vccd1 sky130_ef_sc_hd__decap_12
X_1016_ _1016_/A vssd1 vssd1 vccd1 vccd1 _1018_/A sky130_fd_sc_hd__inv_2
XFILLER_0_8_256 vssd1 vssd1 vccd1 vccd1 sky130_fd_sc_hd__fill_1
XANTENNA__1292__B1 _1398_/B vssd1 vssd1 vccd1 vccd1 sky130_fd_sc_hd__diode_2
XFILLER_0_12_295 vssd1 vssd1 vccd1 vccd1 sky130_fd_sc_hd__fill_1
XFILLER_0_38_192 vssd1 vssd1 vccd1 vccd1 sky130_fd_sc_hd__fill_2
XTAP_298 vssd1 vccd1 sky130_fd_sc_hd__tapvpwrvgnd_1
XTAP_287 vssd1 vccd1 sky130_fd_sc_hd__tapvpwrvgnd_1
XTAP_276 vssd1 vccd1 sky130_fd_sc_hd__tapvpwrvgnd_1
XTAP_265 vssd1 vccd1 sky130_fd_sc_hd__tapvpwrvgnd_1
XTAP_254 vssd1 vccd1 sky130_fd_sc_hd__tapvpwrvgnd_1
XTAP_243 vssd1 vccd1 sky130_fd_sc_hd__tapvpwrvgnd_1
XTAP_232 vssd1 vccd1 sky130_fd_sc_hd__tapvpwrvgnd_1
XTAP_221 vssd1 vccd1 sky130_fd_sc_hd__tapvpwrvgnd_1
X_1496_ _1522_/CLK _1496_/D fanout122/X vssd1 vssd1 vccd1 vccd1 _1496_/Q sky130_fd_sc_hd__dfrtp_1
XTAP_210 vssd1 vccd1 sky130_fd_sc_hd__tapvpwrvgnd_1
XFILLER_0_36_107 vssd1 vssd1 vccd1 vccd1 sky130_fd_sc_hd__fill_2
XFILLER_0_27_129 vssd1 vssd1 vccd1 vccd1 sky130_fd_sc_hd__fill_2
XFILLER_0_35_140 vssd1 vssd1 vccd1 vccd1 sky130_ef_sc_hd__decap_12
X_1350_ _1422_/A _1352_/B vssd1 vssd1 vccd1 vccd1 _1356_/A sky130_fd_sc_hd__nand2_1
X_1281_ _1281_/A hold56/X vssd1 vssd1 vccd1 vccd1 _1281_/Y sky130_fd_sc_hd__nand2_1
XANTENNA__1437__RESET_B fanout127/X vssd1 vssd1 vccd1 vccd1 sky130_fd_sc_hd__diode_2
X_0996_ _0996_/A _0996_/B vssd1 vssd1 vccd1 vccd1 _0997_/B sky130_fd_sc_hd__nand2_1
XFILLER_0_18_118 vssd1 vssd1 vccd1 vccd1 sky130_fd_sc_hd__decap_8
XFILLER_0_26_195 vssd1 vssd1 vccd1 vccd1 sky130_fd_sc_hd__fill_1
XFILLER_0_1_284 vssd1 vssd1 vccd1 vccd1 sky130_ef_sc_hd__decap_12
XFILLER_0_5_96 vssd1 vssd1 vccd1 vccd1 sky130_fd_sc_hd__decap_6
XFILLER_0_5_63 vssd1 vssd1 vccd1 vccd1 sky130_fd_sc_hd__fill_1
XFILLER_0_5_41 vssd1 vssd1 vccd1 vccd1 sky130_fd_sc_hd__fill_1
X_1479_ _1515_/CLK _1479_/D fanout122/X vssd1 vssd1 vccd1 vccd1 hold91/A sky130_fd_sc_hd__dfrtp_1
XFILLER_0_32_187 vssd1 vssd1 vccd1 vccd1 sky130_fd_sc_hd__fill_2
XANTENNA__1530__RESET_B fanout125/X vssd1 vssd1 vccd1 vccd1 sky130_fd_sc_hd__diode_2
X_0850_ _0847_/X _0850_/B _0850_/C vssd1 vssd1 vccd1 vccd1 _0851_/B sky130_fd_sc_hd__nand3b_1
X_1402_ _1402_/A _1402_/B vssd1 vssd1 vccd1 vccd1 _1537_/D sky130_fd_sc_hd__nand2_1
X_0781_ _1475_/Q vssd1 vssd1 vccd1 vccd1 _0794_/B sky130_fd_sc_hd__inv_2
XFILLER_0_23_143 vssd1 vssd1 vccd1 vccd1 sky130_fd_sc_hd__decap_4
X_1333_ _1216_/A input15/X _1208_/X _1332_/Y vssd1 vssd1 vccd1 vccd1 _1334_/B sky130_fd_sc_hd__a22o_1
X_1264_ _1281_/A _1225_/B _1263_/Y vssd1 vssd1 vccd1 vccd1 _1264_/Y sky130_fd_sc_hd__o21ai_1
Xinput4 spi_miso_i[1] vssd1 vssd1 vccd1 vccd1 input4/X sky130_fd_sc_hd__clkbuf_1
X_1195_ _1216_/A input7/X vssd1 vssd1 vccd1 vccd1 _1195_/X sky130_fd_sc_hd__and2_1
XANTENNA__1377__B _1398_/B vssd1 vssd1 vccd1 vccd1 sky130_fd_sc_hd__diode_2
X_0979_ _0979_/A _1012_/B vssd1 vssd1 vccd1 vccd1 _0980_/B sky130_fd_sc_hd__nand2_1
XANTENNA_clkbuf_4_14_0_clk_i_A clkbuf_0_clk_i/X vssd1 vssd1 vccd1 vccd1 sky130_fd_sc_hd__diode_2
XFILLER_0_37_213 vssd1 vssd1 vccd1 vccd1 sky130_fd_sc_hd__fill_1
XFILLER_0_28_213 vssd1 vssd1 vccd1 vccd1 sky130_fd_sc_hd__fill_1
XFILLER_0_43_249 vssd1 vssd1 vccd1 vccd1 sky130_ef_sc_hd__decap_12
X_0902_ _0935_/A vssd1 vssd1 vccd1 vccd1 _0933_/S sky130_fd_sc_hd__clkbuf_8
XFILLER_0_28_235 vssd1 vssd1 vccd1 vccd1 sky130_ef_sc_hd__decap_12
X_0833_ _1475_/Q hold86/A vssd1 vssd1 vccd1 vccd1 _0833_/X sky130_fd_sc_hd__or2_1
XANTENNA__1452__RESET_B fanout125/X vssd1 vssd1 vccd1 vccd1 sky130_fd_sc_hd__diode_2
X_0764_ _0985_/A _0764_/B vssd1 vssd1 vccd1 vccd1 _1038_/B sky130_fd_sc_hd__nor2_1
XFILLER_0_11_113 vssd1 vssd1 vccd1 vccd1 sky130_fd_sc_hd__fill_1
XFILLER_0_11_157 vssd1 vssd1 vccd1 vccd1 sky130_fd_sc_hd__decap_4
X_1178_ _1404_/B _1178_/B vssd1 vssd1 vccd1 vccd1 _1262_/A sky130_fd_sc_hd__nor2_1
X_1247_ _1418_/A _1247_/B vssd1 vssd1 vccd1 vccd1 _1248_/B sky130_fd_sc_hd__nand2_1
X_1316_ _1314_/X _1315_/Y _1398_/B vssd1 vssd1 vccd1 vccd1 _1318_/A sky130_fd_sc_hd__o21ai_1
XFILLER_0_34_216 vssd1 vssd1 vccd1 vccd1 sky130_fd_sc_hd__fill_2
XFILLER_0_19_257 vssd1 vssd1 vccd1 vccd1 sky130_fd_sc_hd__decap_6
XFILLER_0_6_184 vssd1 vssd1 vccd1 vccd1 sky130_fd_sc_hd__fill_1
XFILLER_0_33_293 vssd1 vssd1 vccd1 vccd1 sky130_fd_sc_hd__decap_6
X_1101_ hold95/X _0998_/A _1117_/S vssd1 vssd1 vccd1 vccd1 _1102_/A sky130_fd_sc_hd__mux2_1
X_1032_ _1032_/A _1032_/B vssd1 vssd1 vccd1 vccd1 _1033_/A sky130_fd_sc_hd__nand2_1
XFILLER_0_33_97 vssd1 vssd1 vccd1 vccd1 sky130_fd_sc_hd__decap_3
X_0747_ _0988_/A vssd1 vssd1 vccd1 vccd1 _1045_/B sky130_fd_sc_hd__inv_2
XFILLER_0_3_110 vssd1 vssd1 vccd1 vccd1 sky130_fd_sc_hd__fill_2
Xinput73 sport_i[7] vssd1 vssd1 vccd1 vccd1 _1256_/B sky130_fd_sc_hd__buf_1
Xinput62 sport_i[5] vssd1 vssd1 vccd1 vccd1 _1238_/B sky130_fd_sc_hd__buf_1
Xinput40 sport_i[3] vssd1 vssd1 vccd1 vccd1 _1216_/B sky130_fd_sc_hd__clkbuf_1
Xinput51 sport_i[4] vssd1 vssd1 vccd1 vccd1 _1229_/B sky130_fd_sc_hd__buf_1
X_0816_ _0816_/A _0816_/B _0816_/C vssd1 vssd1 vccd1 vccd1 _0828_/A sky130_fd_sc_hd__nand3_1
Xhold109 _1495_/Q vssd1 vssd1 vccd1 vccd1 hold109/X sky130_fd_sc_hd__dlygate4sd3_1
XFILLER_0_0_113 vssd1 vssd1 vccd1 vccd1 sky130_ef_sc_hd__decap_12
XFILLER_0_44_85 vssd1 vssd1 vccd1 vccd1 sky130_fd_sc_hd__fill_1
XFILLER_0_28_97 vssd1 vssd1 vccd1 vccd1 sky130_ef_sc_hd__decap_12
X_1015_ _1012_/Y _1015_/B _1015_/C vssd1 vssd1 vccd1 vccd1 _1031_/A sky130_fd_sc_hd__nand3b_1
XFILLER_0_8_268 vssd1 vssd1 vccd1 vccd1 sky130_fd_sc_hd__fill_2
XFILLER_0_8_279 vssd1 vssd1 vccd1 vccd1 sky130_ef_sc_hd__decap_12
XFILLER_0_7_290 vssd1 vssd1 vccd1 vccd1 sky130_fd_sc_hd__decap_8
XANTENNA__1295__B _1426_/A vssd1 vssd1 vccd1 vccd1 sky130_fd_sc_hd__diode_2
XTAP_299 vssd1 vccd1 sky130_fd_sc_hd__tapvpwrvgnd_1
XTAP_288 vssd1 vccd1 sky130_fd_sc_hd__tapvpwrvgnd_1
XTAP_277 vssd1 vccd1 sky130_fd_sc_hd__tapvpwrvgnd_1
XTAP_266 vssd1 vccd1 sky130_fd_sc_hd__tapvpwrvgnd_1
XTAP_255 vssd1 vccd1 sky130_fd_sc_hd__tapvpwrvgnd_1
XTAP_244 vssd1 vccd1 sky130_fd_sc_hd__tapvpwrvgnd_1
XTAP_233 vssd1 vccd1 sky130_fd_sc_hd__tapvpwrvgnd_1
XTAP_222 vssd1 vccd1 sky130_fd_sc_hd__tapvpwrvgnd_1
X_1495_ _1515_/CLK _1495_/D fanout123/X vssd1 vssd1 vccd1 vccd1 _1495_/Q sky130_fd_sc_hd__dfrtp_1
XTAP_200 vssd1 vccd1 sky130_fd_sc_hd__tapvpwrvgnd_1
XTAP_211 vssd1 vccd1 sky130_fd_sc_hd__tapvpwrvgnd_1
XFILLER_0_44_163 vssd1 vssd1 vccd1 vccd1 sky130_fd_sc_hd__fill_2
XFILLER_0_44_141 vssd1 vssd1 vccd1 vccd1 sky130_fd_sc_hd__fill_2
XFILLER_0_4_282 vssd1 vssd1 vccd1 vccd1 sky130_fd_sc_hd__fill_1
XFILLER_0_35_152 vssd1 vssd1 vccd1 vccd1 sky130_fd_sc_hd__decap_4
XANTENNA__1192__A0 _1430_/Q vssd1 vssd1 vccd1 vccd1 sky130_fd_sc_hd__diode_2
X_1280_ _1313_/A hold56/X vssd1 vssd1 vccd1 vccd1 _1285_/A sky130_fd_sc_hd__nand2_1
XFILLER_0_25_54 vssd1 vssd1 vccd1 vccd1 sky130_fd_sc_hd__fill_2
XFILLER_0_26_141 vssd1 vssd1 vccd1 vccd1 sky130_fd_sc_hd__fill_2
XFILLER_0_26_130 vssd1 vssd1 vccd1 vccd1 sky130_fd_sc_hd__decap_6
X_0995_ _0995_/A vssd1 vssd1 vccd1 vccd1 _0996_/B sky130_fd_sc_hd__inv_2
XFILLER_0_41_177 vssd1 vssd1 vccd1 vccd1 sky130_fd_sc_hd__fill_2
XFILLER_0_5_53 vssd1 vssd1 vccd1 vccd1 sky130_fd_sc_hd__decap_3
XFILLER_0_1_296 vssd1 vssd1 vccd1 vccd1 sky130_fd_sc_hd__decap_3
XFILLER_0_1_252 vssd1 vssd1 vccd1 vccd1 sky130_fd_sc_hd__fill_2
X_1478_ _1491_/CLK _1478_/D fanout122/X vssd1 vssd1 vccd1 vccd1 hold98/A sky130_fd_sc_hd__dfrtp_1
XFILLER_0_32_133 vssd1 vssd1 vccd1 vccd1 sky130_fd_sc_hd__decap_6
XFILLER_0_32_122 vssd1 vssd1 vccd1 vccd1 sky130_fd_sc_hd__fill_2
XFILLER_0_32_100 vssd1 vssd1 vccd1 vccd1 sky130_fd_sc_hd__fill_2
X_1401_ _1401_/A _1426_/B _1401_/C vssd1 vssd1 vccd1 vccd1 _1402_/B sky130_fd_sc_hd__nand3_1
Xinput5 spi_miso_i[2] vssd1 vssd1 vccd1 vccd1 input5/X sky130_fd_sc_hd__clkbuf_1
X_1332_ _1330_/Y _1345_/A _1331_/Y vssd1 vssd1 vccd1 vccd1 _1332_/Y sky130_fd_sc_hd__o21ai_1
X_1194_ _1228_/A vssd1 vssd1 vccd1 vccd1 _1216_/A sky130_fd_sc_hd__buf_4
X_1263_ _1281_/A hold22/X vssd1 vssd1 vccd1 vccd1 _1263_/Y sky130_fd_sc_hd__nand2_1
XFILLER_0_46_225 vssd1 vssd1 vccd1 vccd1 sky130_ef_sc_hd__decap_12
XFILLER_0_46_203 vssd1 vssd1 vccd1 vccd1 sky130_fd_sc_hd__fill_2
XTAP_94 vssd1 vccd1 sky130_fd_sc_hd__tapvpwrvgnd_1
X_0978_ _1208_/A _0978_/B vssd1 vssd1 vccd1 vccd1 _0980_/A sky130_fd_sc_hd__nand2_1
XFILLER_0_14_166 vssd1 vssd1 vccd1 vccd1 sky130_fd_sc_hd__decap_8
XFILLER_0_37_225 vssd1 vssd1 vccd1 vccd1 sky130_fd_sc_hd__decap_4
XFILLER_0_28_258 vssd1 vssd1 vccd1 vccd1 sky130_fd_sc_hd__decap_8
XFILLER_0_28_247 vssd1 vssd1 vccd1 vccd1 sky130_fd_sc_hd__decap_4
XFILLER_0_7_108 vssd1 vssd1 vccd1 vccd1 sky130_fd_sc_hd__fill_1
X_0763_ _1183_/A _1262_/B vssd1 vssd1 vccd1 vccd1 _0764_/B sky130_fd_sc_hd__nand2_1
X_0901_ _1208_/A hold16/X _1052_/A vssd1 vssd1 vccd1 vccd1 _0935_/A sky130_fd_sc_hd__a21o_1
X_0832_ _1082_/A hold98/A hold78/A vssd1 vssd1 vccd1 vccd1 _0832_/X sky130_fd_sc_hd__a21o_1
XFILLER_0_11_169 vssd1 vssd1 vccd1 vccd1 sky130_ef_sc_hd__decap_12
X_1315_ _1315_/A _1315_/B vssd1 vssd1 vccd1 vccd1 _1315_/Y sky130_fd_sc_hd__nor2_1
X_1177_ _1175_/Y _1180_/A _1176_/Y vssd1 vssd1 vccd1 vccd1 _1508_/D sky130_fd_sc_hd__o21ai_1
X_1246_ _1246_/A _1398_/B vssd1 vssd1 vccd1 vccd1 _1248_/A sky130_fd_sc_hd__nand2_1
XANTENNA__1477__SET_B fanout127/X vssd1 vssd1 vccd1 vccd1 sky130_fd_sc_hd__diode_2
XFILLER_0_19_225 vssd1 vssd1 vccd1 vccd1 sky130_fd_sc_hd__fill_1
XFILLER_0_42_250 vssd1 vssd1 vccd1 vccd1 sky130_fd_sc_hd__fill_2
XANTENNA__1509__RESET_B fanout129/X vssd1 vssd1 vccd1 vccd1 sky130_fd_sc_hd__diode_2
XFILLER_0_25_206 vssd1 vssd1 vccd1 vccd1 sky130_ef_sc_hd__decap_12
X_1100_ _1100_/A vssd1 vssd1 vccd1 vccd1 _1484_/D sky130_fd_sc_hd__clkbuf_1
XFILLER_0_17_77 vssd1 vssd1 vccd1 vccd1 sky130_fd_sc_hd__decap_4
XFILLER_0_17_88 vssd1 vssd1 vccd1 vccd1 sky130_fd_sc_hd__fill_1
X_1031_ _1031_/A _1031_/B vssd1 vssd1 vccd1 vccd1 _1032_/B sky130_fd_sc_hd__nor2_1
XFILLER_0_33_87 vssd1 vssd1 vccd1 vccd1 sky130_fd_sc_hd__fill_2
XFILLER_0_33_76 vssd1 vssd1 vccd1 vccd1 sky130_fd_sc_hd__fill_1
X_0746_ _0975_/A _1040_/C vssd1 vssd1 vccd1 vccd1 _0988_/A sky130_fd_sc_hd__nand2_1
Xinput63 sport_i[60] vssd1 vssd1 vccd1 vccd1 _1014_/B sky130_fd_sc_hd__clkbuf_1
XFILLER_0_24_250 vssd1 vssd1 vccd1 vccd1 sky130_fd_sc_hd__fill_2
Xinput74 sport_i[8] vssd1 vssd1 vccd1 vccd1 input74/X sky130_fd_sc_hd__buf_1
Xinput30 sport_i[30] vssd1 vssd1 vccd1 vccd1 _1418_/B sky130_fd_sc_hd__buf_1
X_0815_ _0872_/A _1229_/B vssd1 vssd1 vccd1 vccd1 _0816_/C sky130_fd_sc_hd__nand2_1
Xinput41 sport_i[40] vssd1 vssd1 vccd1 vccd1 _0995_/A sky130_fd_sc_hd__buf_1
Xinput52 sport_i[50] vssd1 vssd1 vccd1 vccd1 _1000_/B sky130_fd_sc_hd__buf_1
X_1229_ _1418_/A _1229_/B vssd1 vssd1 vccd1 vccd1 _1230_/B sky130_fd_sc_hd__nand2_1
XFILLER_0_0_125 vssd1 vssd1 vccd1 vccd1 sky130_ef_sc_hd__decap_12
XFILLER_0_21_220 vssd1 vssd1 vccd1 vccd1 sky130_fd_sc_hd__decap_4
XFILLER_0_21_231 vssd1 vssd1 vccd1 vccd1 sky130_ef_sc_hd__decap_12
XFILLER_0_28_21 vssd1 vssd1 vccd1 vccd1 sky130_fd_sc_hd__fill_1
XFILLER_0_0_169 vssd1 vssd1 vccd1 vccd1 sky130_ef_sc_hd__decap_12
XFILLER_0_21_297 vssd1 vssd1 vccd1 vccd1 sky130_fd_sc_hd__fill_2
X_1014_ _1014_/A _1014_/B vssd1 vssd1 vccd1 vccd1 _1015_/C sky130_fd_sc_hd__nor2_1
XFILLER_0_21_9 vssd1 vssd1 vccd1 vccd1 sky130_ef_sc_hd__decap_12
XFILLER_0_8_97 vssd1 vssd1 vccd1 vccd1 sky130_fd_sc_hd__decap_8
X_0729_ _0734_/B _0729_/B vssd1 vssd1 vccd1 vccd1 _0784_/B sky130_fd_sc_hd__nand2_1
XANTENNA__1524__RESET_B fanout128/X vssd1 vssd1 vccd1 vccd1 sky130_fd_sc_hd__diode_2
XFILLER_0_14_12 vssd1 vssd1 vccd1 vccd1 sky130_ef_sc_hd__decap_12
XFILLER_0_14_67 vssd1 vssd1 vccd1 vccd1 sky130_fd_sc_hd__decap_3
XTAP_223 vssd1 vccd1 sky130_fd_sc_hd__tapvpwrvgnd_1
X_1494_ _1521_/CLK _1494_/D fanout122/X vssd1 vssd1 vccd1 vccd1 _1494_/Q sky130_fd_sc_hd__dfrtp_1
XTAP_201 vssd1 vccd1 sky130_fd_sc_hd__tapvpwrvgnd_1
XTAP_212 vssd1 vccd1 sky130_fd_sc_hd__tapvpwrvgnd_1
XTAP_289 vssd1 vccd1 sky130_fd_sc_hd__tapvpwrvgnd_1
XTAP_278 vssd1 vccd1 sky130_fd_sc_hd__tapvpwrvgnd_1
XTAP_267 vssd1 vccd1 sky130_fd_sc_hd__tapvpwrvgnd_1
XTAP_256 vssd1 vccd1 sky130_fd_sc_hd__tapvpwrvgnd_1
XTAP_245 vssd1 vccd1 sky130_fd_sc_hd__tapvpwrvgnd_1
XTAP_234 vssd1 vccd1 sky130_fd_sc_hd__tapvpwrvgnd_1
XFILLER_0_25_77 vssd1 vssd1 vccd1 vccd1 sky130_fd_sc_hd__fill_1
XFILLER_0_25_33 vssd1 vssd1 vccd1 vccd1 sky130_ef_sc_hd__decap_12
XFILLER_0_18_109 vssd1 vssd1 vccd1 vccd1 sky130_fd_sc_hd__decap_6
XFILLER_0_41_156 vssd1 vssd1 vccd1 vccd1 sky130_fd_sc_hd__fill_2
XANTENNA__1446__RESET_B fanout128/X vssd1 vssd1 vccd1 vccd1 sky130_fd_sc_hd__diode_2
XFILLER_0_26_197 vssd1 vssd1 vccd1 vccd1 sky130_fd_sc_hd__decap_4
XFILLER_0_26_175 vssd1 vssd1 vccd1 vccd1 sky130_ef_sc_hd__decap_12
XFILLER_0_26_120 vssd1 vssd1 vccd1 vccd1 sky130_fd_sc_hd__fill_2
X_0994_ _0994_/A vssd1 vssd1 vccd1 vccd1 _0996_/A sky130_fd_sc_hd__inv_2
X_1477_ _1506_/CLK hold79/X fanout127/X vssd1 vssd1 vccd1 vccd1 hold78/A sky130_fd_sc_hd__dfstp_1
XFILLER_0_17_153 vssd1 vssd1 vccd1 vccd1 sky130_fd_sc_hd__decap_6
XFILLER_0_32_156 vssd1 vssd1 vccd1 vccd1 sky130_fd_sc_hd__decap_8
XFILLER_0_11_46 vssd1 vssd1 vccd1 vccd1 sky130_fd_sc_hd__decap_8
XFILLER_0_11_57 vssd1 vssd1 vccd1 vccd1 sky130_ef_sc_hd__decap_12
XFILLER_0_23_101 vssd1 vssd1 vccd1 vccd1 sky130_fd_sc_hd__decap_8
X_1400_ _1400_/A _1400_/B vssd1 vssd1 vccd1 vccd1 _1401_/C sky130_fd_sc_hd__nand2_1
X_1331_ _1345_/A hold80/X vssd1 vssd1 vccd1 vccd1 _1331_/Y sky130_fd_sc_hd__nand2_1
X_0778__3 _1507_/CLK vssd1 vssd1 vccd1 vccd1 _1431_/CLK sky130_fd_sc_hd__inv_2
Xinput6 spi_miso_i[3] vssd1 vssd1 vccd1 vccd1 input6/X sky130_fd_sc_hd__clkbuf_1
X_1262_ _1262_/A _1262_/B vssd1 vssd1 vccd1 vccd1 _1281_/A sky130_fd_sc_hd__nand2_4
X_1193_ _1193_/A vssd1 vssd1 vccd1 vccd1 _1228_/A sky130_fd_sc_hd__inv_2
XFILLER_0_46_237 vssd1 vssd1 vccd1 vccd1 sky130_ef_sc_hd__decap_12
XTAP_95 vssd1 vccd1 sky130_fd_sc_hd__tapvpwrvgnd_1
X_0977_ _0977_/A _1262_/B vssd1 vssd1 vccd1 vccd1 _0978_/B sky130_fd_sc_hd__nand2_1
XFILLER_0_14_101 vssd1 vssd1 vccd1 vccd1 sky130_fd_sc_hd__fill_2
XFILLER_0_14_145 vssd1 vssd1 vccd1 vccd1 sky130_fd_sc_hd__decap_6
X_1529_ _1541_/CLK hold66/X fanout126/X vssd1 vssd1 vccd1 vccd1 hold65/A sky130_fd_sc_hd__dfrtp_1
XFILLER_0_37_204 vssd1 vssd1 vccd1 vccd1 sky130_fd_sc_hd__fill_2
XFILLER_0_45_281 vssd1 vssd1 vccd1 vccd1 sky130_ef_sc_hd__decap_12
XPHY_90 vssd1 vssd1 vccd1 vccd1 sky130_fd_sc_hd__decap_3
X_0900_ _0900_/A _0900_/B vssd1 vssd1 vccd1 vccd1 _1052_/A sky130_fd_sc_hd__nor2_1
XFILLER_0_43_218 vssd1 vssd1 vccd1 vccd1 sky130_fd_sc_hd__decap_6
X_0762_ _0762_/A vssd1 vssd1 vccd1 vccd1 _1183_/A sky130_fd_sc_hd__inv_2
X_0831_ _1238_/B _0872_/A _1193_/A _0820_/B vssd1 vssd1 vccd1 vccd1 _0831_/X sky130_fd_sc_hd__a22o_1
X_1314_ _1404_/B _1287_/B hold74/X vssd1 vssd1 vccd1 vccd1 _1314_/X sky130_fd_sc_hd__o21a_1
X_1176_ _1180_/A _1176_/B vssd1 vssd1 vccd1 vccd1 _1176_/Y sky130_fd_sc_hd__nand2_1
X_1245_ hold57/X _1221_/Y _1223_/Y _1307_/A vssd1 vssd1 vccd1 vccd1 _1246_/A sky130_fd_sc_hd__o2bb2ai_1
XANTENNA__1461__RESET_B fanout125/X vssd1 vssd1 vccd1 vccd1 sky130_fd_sc_hd__diode_2
XFILLER_0_34_229 vssd1 vssd1 vccd1 vccd1 sky130_fd_sc_hd__fill_2
XFILLER_0_27_281 vssd1 vssd1 vccd1 vccd1 sky130_ef_sc_hd__decap_12
XFILLER_0_25_218 vssd1 vssd1 vccd1 vccd1 sky130_fd_sc_hd__fill_1
XFILLER_0_18_270 vssd1 vssd1 vccd1 vccd1 sky130_fd_sc_hd__fill_2
XFILLER_0_17_23 vssd1 vssd1 vccd1 vccd1 sky130_ef_sc_hd__decap_12
X_1030_ _1030_/A _1030_/B vssd1 vssd1 vccd1 vccd1 _1031_/B sky130_fd_sc_hd__nand2_1
XFILLER_0_33_55 vssd1 vssd1 vccd1 vccd1 sky130_fd_sc_hd__fill_1
Xinput20 sport_i[21] vssd1 vssd1 vccd1 vccd1 input20/X sky130_fd_sc_hd__buf_1
XFILLER_0_3_101 vssd1 vssd1 vccd1 vccd1 sky130_fd_sc_hd__fill_1
Xinput31 sport_i[31] vssd1 vssd1 vccd1 vccd1 input31/X sky130_fd_sc_hd__buf_1
X_0814_ _0814_/A _0982_/A vssd1 vssd1 vccd1 vccd1 _0872_/A sky130_fd_sc_hd__nor2_2
XFILLER_0_16_229 vssd1 vssd1 vccd1 vccd1 sky130_fd_sc_hd__decap_3
X_0745_ _1176_/B _1223_/B vssd1 vssd1 vccd1 vccd1 _1184_/A sky130_fd_sc_hd__nor2_2
Xinput64 sport_i[61] vssd1 vssd1 vccd1 vccd1 _1014_/A sky130_fd_sc_hd__clkbuf_1
XFILLER_0_24_262 vssd1 vssd1 vccd1 vccd1 sky130_fd_sc_hd__decap_4
Xinput75 sport_i[9] vssd1 vssd1 vccd1 vccd1 input75/X sky130_fd_sc_hd__buf_1
Xinput42 sport_i[41] vssd1 vssd1 vccd1 vccd1 _0994_/A sky130_fd_sc_hd__buf_1
Xinput53 sport_i[51] vssd1 vssd1 vccd1 vccd1 _1000_/A sky130_fd_sc_hd__buf_1
X_1228_ _1228_/A vssd1 vssd1 vccd1 vccd1 _1418_/A sky130_fd_sc_hd__buf_4
X_1159_ _1162_/A _1158_/B _1158_/Y _1170_/A vssd1 vssd1 vccd1 vccd1 _1159_/X sky130_fd_sc_hd__a211o_1
XFILLER_0_30_232 vssd1 vssd1 vccd1 vccd1 sky130_fd_sc_hd__decap_6
XFILLER_0_0_137 vssd1 vssd1 vccd1 vccd1 sky130_fd_sc_hd__decap_3
XFILLER_0_28_33 vssd1 vssd1 vccd1 vccd1 sky130_fd_sc_hd__fill_1
X_1013_ _1013_/A _1013_/B vssd1 vssd1 vccd1 vccd1 _1015_/B sky130_fd_sc_hd__nor2_1
XFILLER_0_8_215 vssd1 vssd1 vccd1 vccd1 sky130_fd_sc_hd__decap_4
XANTENNA__1012__B _1012_/B vssd1 vssd1 vccd1 vccd1 sky130_fd_sc_hd__diode_2
XFILLER_0_8_32 vssd1 vssd1 vccd1 vccd1 sky130_fd_sc_hd__decap_8
XFILLER_0_8_43 vssd1 vssd1 vccd1 vccd1 sky130_fd_sc_hd__fill_2
X_0728_ _0753_/A _0741_/B _0900_/B vssd1 vssd1 vccd1 vccd1 _1544_/A sky130_fd_sc_hd__a21oi_4
XANTENNA__1201__A0 _1431_/Q vssd1 vssd1 vccd1 vccd1 sky130_fd_sc_hd__diode_2
XFILLER_0_7_281 vssd1 vssd1 vccd1 vccd1 sky130_fd_sc_hd__decap_6
XFILLER_0_14_24 vssd1 vssd1 vccd1 vccd1 sky130_fd_sc_hd__fill_1
XFILLER_0_30_78 vssd1 vssd1 vccd1 vccd1 sky130_fd_sc_hd__decap_6
XFILLER_0_30_45 vssd1 vssd1 vccd1 vccd1 sky130_fd_sc_hd__decap_4
XTAP_257 vssd1 vccd1 sky130_fd_sc_hd__tapvpwrvgnd_1
XTAP_246 vssd1 vccd1 sky130_fd_sc_hd__tapvpwrvgnd_1
XTAP_235 vssd1 vccd1 sky130_fd_sc_hd__tapvpwrvgnd_1
XTAP_224 vssd1 vccd1 sky130_fd_sc_hd__tapvpwrvgnd_1
X_1493_ _1521_/CLK _1493_/D fanout122/X vssd1 vssd1 vccd1 vccd1 _1493_/Q sky130_fd_sc_hd__dfrtp_1
XTAP_202 vssd1 vccd1 sky130_fd_sc_hd__tapvpwrvgnd_1
XTAP_213 vssd1 vccd1 sky130_fd_sc_hd__tapvpwrvgnd_1
XTAP_279 vssd1 vccd1 sky130_fd_sc_hd__tapvpwrvgnd_1
XTAP_268 vssd1 vccd1 sky130_fd_sc_hd__tapvpwrvgnd_1
XFILLER_0_29_173 vssd1 vssd1 vccd1 vccd1 sky130_fd_sc_hd__fill_1
XFILLER_0_4_251 vssd1 vssd1 vccd1 vccd1 sky130_fd_sc_hd__fill_1
XFILLER_0_35_198 vssd1 vssd1 vccd1 vccd1 sky130_fd_sc_hd__fill_2
XFILLER_0_35_132 vssd1 vssd1 vccd1 vccd1 sky130_fd_sc_hd__fill_2
XFILLER_0_25_45 vssd1 vssd1 vccd1 vccd1 sky130_fd_sc_hd__decap_6
XFILLER_0_41_66 vssd1 vssd1 vccd1 vccd1 sky130_fd_sc_hd__fill_1
XFILLER_0_41_33 vssd1 vssd1 vccd1 vccd1 sky130_fd_sc_hd__fill_2
X_0993_ _0993_/A _0993_/B vssd1 vssd1 vccd1 vccd1 _0997_/A sky130_fd_sc_hd__nand2_1
XFILLER_0_41_113 vssd1 vssd1 vccd1 vccd1 sky130_fd_sc_hd__fill_2
XFILLER_0_26_187 vssd1 vssd1 vccd1 vccd1 sky130_fd_sc_hd__decap_8
Xclkbuf_4_14_0_clk_i clkbuf_0_clk_i/X vssd1 vssd1 vccd1 vccd1 _1507_/CLK sky130_fd_sc_hd__clkbuf_8
X_1476_ _1506_/CLK _1476_/D fanout123/X vssd1 vssd1 vccd1 vccd1 _1476_/Q sky130_fd_sc_hd__dfstp_1
XFILLER_0_17_132 vssd1 vssd1 vccd1 vccd1 sky130_fd_sc_hd__fill_1
XFILLER_0_11_69 vssd1 vssd1 vccd1 vccd1 sky130_fd_sc_hd__decap_4
X_1330_ _1431_/Q vssd1 vssd1 vccd1 vccd1 _1330_/Y sky130_fd_sc_hd__inv_2
X_1261_ _1261_/A vssd1 vssd1 vccd1 vccd1 _1401_/A sky130_fd_sc_hd__buf_6
XFILLER_0_36_99 vssd1 vssd1 vccd1 vccd1 sky130_fd_sc_hd__fill_1
Xinput7 sport_i[0] vssd1 vssd1 vccd1 vccd1 input7/X sky130_fd_sc_hd__clkbuf_1
X_1192_ _1430_/Q hold23/X _1252_/A vssd1 vssd1 vccd1 vccd1 _1192_/X sky130_fd_sc_hd__mux2_1
XFILLER_0_46_249 vssd1 vssd1 vccd1 vccd1 sky130_fd_sc_hd__decap_3
X_0976_ _1034_/B _1040_/C vssd1 vssd1 vccd1 vccd1 _0977_/A sky130_fd_sc_hd__nand2_1
XTAP_96 vssd1 vccd1 sky130_fd_sc_hd__tapvpwrvgnd_1
XFILLER_0_14_179 vssd1 vssd1 vccd1 vccd1 sky130_fd_sc_hd__fill_2
X_1459_ _1531_/CLK _1459_/D fanout124/X vssd1 vssd1 vccd1 vccd1 _1459_/Q sky130_fd_sc_hd__dfrtp_2
X_1528_ _1539_/CLK hold54/X fanout126/X vssd1 vssd1 vccd1 vccd1 hold53/A sky130_fd_sc_hd__dfrtp_1
XFILLER_0_45_293 vssd1 vssd1 vccd1 vccd1 sky130_fd_sc_hd__decap_6
XFILLER_0_20_116 vssd1 vssd1 vccd1 vccd1 sky130_fd_sc_hd__decap_3
XFILLER_0_20_149 vssd1 vssd1 vccd1 vccd1 sky130_fd_sc_hd__decap_3
XPHY_91 vssd1 vssd1 vccd1 vccd1 sky130_fd_sc_hd__decap_3
X_0780__5 _1509_/CLK vssd1 vssd1 vccd1 vccd1 _1433_/CLK sky130_fd_sc_hd__inv_2
XPHY_80 vssd1 vssd1 vccd1 vccd1 sky130_fd_sc_hd__decap_3
X_0830_ _0830_/A hold51/X vssd1 vssd1 vccd1 vccd1 hold52/A sky130_fd_sc_hd__nand2_1
XFILLER_0_22_57 vssd1 vssd1 vccd1 vccd1 sky130_fd_sc_hd__fill_1
X_0761_ _1404_/B _1508_/Q vssd1 vssd1 vccd1 vccd1 _0985_/A sky130_fd_sc_hd__nand2_1
XFILLER_0_11_105 vssd1 vssd1 vccd1 vccd1 sky130_fd_sc_hd__decap_6
XFILLER_0_11_149 vssd1 vssd1 vccd1 vccd1 sky130_fd_sc_hd__fill_2
X_1313_ _1313_/A hold74/X vssd1 vssd1 vccd1 vccd1 _1320_/A sky130_fd_sc_hd__nand2_1
X_1244_ _1262_/B _1244_/B vssd1 vssd1 vccd1 vccd1 _1307_/A sky130_fd_sc_hd__or2_1
X_1175_ _1175_/A _1178_/B vssd1 vssd1 vccd1 vccd1 _1175_/Y sky130_fd_sc_hd__nand2_1
X_0959_ _0959_/A vssd1 vssd1 vccd1 vccd1 _1466_/D sky130_fd_sc_hd__clkbuf_1
XFILLER_0_42_230 vssd1 vssd1 vccd1 vccd1 sky130_ef_sc_hd__decap_12
XFILLER_0_34_208 vssd1 vssd1 vccd1 vccd1 sky130_fd_sc_hd__fill_2
XFILLER_0_27_293 vssd1 vssd1 vccd1 vccd1 sky130_fd_sc_hd__decap_6
XANTENNA__1430__RESET_B fanout127/X vssd1 vssd1 vccd1 vccd1 sky130_fd_sc_hd__diode_2
XFILLER_0_17_35 vssd1 vssd1 vccd1 vccd1 sky130_ef_sc_hd__decap_12
XFILLER_0_17_57 vssd1 vssd1 vccd1 vccd1 sky130_fd_sc_hd__decap_4
X_0813_ _0813_/A _0813_/B _1045_/A vssd1 vssd1 vccd1 vccd1 _0816_/B sky130_fd_sc_hd__nand3_1
XFILLER_0_24_230 vssd1 vssd1 vccd1 vccd1 sky130_ef_sc_hd__decap_12
Xinput21 sport_i[22] vssd1 vssd1 vccd1 vccd1 input21/X sky130_fd_sc_hd__buf_1
Xinput10 sport_i[12] vssd1 vssd1 vccd1 vccd1 _1293_/B sky130_fd_sc_hd__buf_1
Xinput32 sport_i[32] vssd1 vssd1 vccd1 vccd1 input32/X sky130_fd_sc_hd__clkbuf_1
Xinput43 sport_i[42] vssd1 vssd1 vccd1 vccd1 _0992_/A sky130_fd_sc_hd__buf_1
Xinput54 sport_i[52] vssd1 vssd1 vccd1 vccd1 _1027_/A sky130_fd_sc_hd__buf_1
X_0744_ _1404_/B vssd1 vssd1 vccd1 vccd1 _1223_/B sky130_fd_sc_hd__clkinv_4
Xinput65 sport_i[62] vssd1 vssd1 vccd1 vccd1 _1013_/B sky130_fd_sc_hd__clkbuf_1
X_1158_ hold6/X _1158_/B vssd1 vssd1 vccd1 vccd1 _1158_/Y sky130_fd_sc_hd__nor2_1
X_1227_ _1227_/A _1398_/B vssd1 vssd1 vccd1 vccd1 _1230_/A sky130_fd_sc_hd__nand2_1
X_1089_ hold91/X input33/X _1117_/S vssd1 vssd1 vccd1 vccd1 _1090_/A sky130_fd_sc_hd__mux2_1
X_1012_ hold1/A _1012_/B vssd1 vssd1 vccd1 vccd1 _1012_/Y sky130_fd_sc_hd__nand2_1
X_0727_ _0729_/B _1071_/B vssd1 vssd1 vccd1 vccd1 _0900_/B sky130_fd_sc_hd__nand2_4
XFILLER_0_40_3 vssd1 vssd1 vccd1 vccd1 sky130_fd_sc_hd__decap_3
XFILLER_0_7_260 vssd1 vssd1 vccd1 vccd1 sky130_fd_sc_hd__fill_1
XANTENNA__1533__RESET_B fanout126/X vssd1 vssd1 vccd1 vccd1 sky130_fd_sc_hd__diode_2
XFILLER_0_14_58 vssd1 vssd1 vccd1 vccd1 sky130_fd_sc_hd__decap_4
XFILLER_0_39_55 vssd1 vssd1 vccd1 vccd1 sky130_fd_sc_hd__fill_1
XTAP_269 vssd1 vccd1 sky130_fd_sc_hd__tapvpwrvgnd_1
XTAP_258 vssd1 vccd1 sky130_fd_sc_hd__tapvpwrvgnd_1
XTAP_247 vssd1 vccd1 sky130_fd_sc_hd__tapvpwrvgnd_1
XTAP_236 vssd1 vccd1 sky130_fd_sc_hd__tapvpwrvgnd_1
XTAP_225 vssd1 vccd1 sky130_fd_sc_hd__tapvpwrvgnd_1
X_1492_ _1521_/CLK _1492_/D fanout122/X vssd1 vssd1 vccd1 vccd1 _1492_/Q sky130_fd_sc_hd__dfrtp_1
XTAP_203 vssd1 vccd1 sky130_fd_sc_hd__tapvpwrvgnd_1
XTAP_214 vssd1 vccd1 sky130_fd_sc_hd__tapvpwrvgnd_1
Xclkbuf_4_10_0_clk_i clkbuf_0_clk_i/X vssd1 vssd1 vccd1 vccd1 _1505_/CLK sky130_fd_sc_hd__clkbuf_8
XFILLER_0_25_24 vssd1 vssd1 vccd1 vccd1 sky130_fd_sc_hd__decap_3
X_0992_ _0992_/A vssd1 vssd1 vccd1 vccd1 _0993_/B sky130_fd_sc_hd__inv_2
XFILLER_0_41_169 vssd1 vssd1 vccd1 vccd1 sky130_fd_sc_hd__fill_2
X_1544_ _1544_/A vssd1 vssd1 vccd1 vccd1 _1544_/X sky130_fd_sc_hd__buf_1
XFILLER_0_1_244 vssd1 vssd1 vccd1 vccd1 sky130_fd_sc_hd__fill_2
XFILLER_0_5_45 vssd1 vssd1 vccd1 vccd1 sky130_fd_sc_hd__decap_8
X_1475_ _1506_/CLK _1475_/D fanout127/X vssd1 vssd1 vccd1 vccd1 _1475_/Q sky130_fd_sc_hd__dfstp_2
XFILLER_0_32_169 vssd1 vssd1 vccd1 vccd1 sky130_ef_sc_hd__decap_12
XFILLER_0_23_147 vssd1 vssd1 vccd1 vccd1 sky130_fd_sc_hd__fill_1
X_1191_ _1222_/A _1223_/B vssd1 vssd1 vccd1 vccd1 _1252_/A sky130_fd_sc_hd__nand2_4
Xinput8 sport_i[10] vssd1 vssd1 vccd1 vccd1 input8/X sky130_fd_sc_hd__buf_1
X_1260_ _1313_/A hold22/X vssd1 vssd1 vccd1 vccd1 _1267_/A sky130_fd_sc_hd__nand2_1
XTAP_97 vssd1 vccd1 sky130_fd_sc_hd__tapvpwrvgnd_1
X_0975_ _0975_/A vssd1 vssd1 vccd1 vccd1 _1034_/B sky130_fd_sc_hd__inv_2
X_1527_ _1539_/CLK _1527_/D fanout125/X vssd1 vssd1 vccd1 vccd1 _1527_/Q sky130_fd_sc_hd__dfrtp_1
X_1458_ _1531_/CLK _1458_/D fanout124/X vssd1 vssd1 vccd1 vccd1 _1458_/Q sky130_fd_sc_hd__dfrtp_1
X_1389_ _1422_/A hold67/X vssd1 vssd1 vccd1 vccd1 _1395_/A sky130_fd_sc_hd__nand2_1
XFILLER_0_37_217 vssd1 vssd1 vccd1 vccd1 sky130_fd_sc_hd__fill_2
XFILLER_0_45_261 vssd1 vssd1 vccd1 vccd1 sky130_ef_sc_hd__decap_12
XFILLER_0_20_139 vssd1 vssd1 vccd1 vccd1 sky130_fd_sc_hd__fill_1
XPHY_92 vssd1 vssd1 vccd1 vccd1 sky130_fd_sc_hd__decap_3
XPHY_81 vssd1 vssd1 vccd1 vccd1 sky130_fd_sc_hd__decap_3
XPHY_70 vssd1 vssd1 vccd1 vccd1 sky130_fd_sc_hd__decap_3
XFILLER_0_28_217 vssd1 vssd1 vccd1 vccd1 sky130_fd_sc_hd__fill_2
X_0760_ _0760_/A _1047_/A vssd1 vssd1 vccd1 vccd1 _1164_/B sky130_fd_sc_hd__nand2_4
XFILLER_0_22_25 vssd1 vssd1 vccd1 vccd1 sky130_fd_sc_hd__decap_3
XFILLER_0_11_117 vssd1 vssd1 vccd1 vccd1 sky130_ef_sc_hd__decap_12
X_1174_ _1174_/A vssd1 vssd1 vccd1 vccd1 _1175_/A sky130_fd_sc_hd__inv_2
X_1312_ _1312_/A _1312_/B vssd1 vssd1 vccd1 vccd1 hold47/A sky130_fd_sc_hd__nand2_1
XFILLER_0_2_57 vssd1 vssd1 vccd1 vccd1 sky130_fd_sc_hd__decap_4
X_1243_ _1252_/A _1432_/Q vssd1 vssd1 vccd1 vccd1 _1244_/B sky130_fd_sc_hd__nand2_1
X_0958_ hold134/X hold28/X _0966_/S vssd1 vssd1 vccd1 vccd1 _0959_/A sky130_fd_sc_hd__mux2_1
XFILLER_0_42_297 vssd1 vssd1 vccd1 vccd1 sky130_fd_sc_hd__fill_2
XFILLER_0_42_253 vssd1 vssd1 vccd1 vccd1 sky130_ef_sc_hd__decap_12
XFILLER_0_42_242 vssd1 vssd1 vccd1 vccd1 sky130_fd_sc_hd__decap_8
XFILLER_0_6_111 vssd1 vssd1 vccd1 vccd1 sky130_fd_sc_hd__decap_3
XFILLER_0_6_188 vssd1 vssd1 vccd1 vccd1 sky130_fd_sc_hd__decap_8
X_0889_ _1167_/C _1498_/Q vssd1 vssd1 vccd1 vccd1 _0889_/Y sky130_fd_sc_hd__nand2_1
XANTENNA_fanout124_A fanout125/X vssd1 vssd1 vccd1 vccd1 sky130_fd_sc_hd__diode_2
XANTENNA__1470__RESET_B fanout125/X vssd1 vssd1 vccd1 vccd1 sky130_fd_sc_hd__diode_2
Xoutput120 _1447_/Q vssd1 vssd1 vccd1 vccd1 sport_o[8] sky130_fd_sc_hd__buf_12
XFILLER_0_10_194 vssd1 vssd1 vccd1 vccd1 sky130_fd_sc_hd__fill_2
XFILLER_0_17_47 vssd1 vssd1 vccd1 vccd1 sky130_fd_sc_hd__fill_1
XFILLER_0_17_69 vssd1 vssd1 vccd1 vccd1 sky130_fd_sc_hd__fill_1
XFILLER_0_33_79 vssd1 vssd1 vccd1 vccd1 sky130_fd_sc_hd__fill_2
XFILLER_0_33_68 vssd1 vssd1 vccd1 vccd1 sky130_fd_sc_hd__fill_1
X_0743_ _0743_/A vssd1 vssd1 vccd1 vccd1 _1404_/B sky130_fd_sc_hd__clkbuf_8
Xinput66 sport_i[63] vssd1 vssd1 vccd1 vccd1 _1013_/A sky130_fd_sc_hd__clkbuf_1
X_0812_ _1288_/A _1287_/B _0809_/Y _0810_/Y _0811_/Y vssd1 vssd1 vccd1 vccd1 _0813_/B
+ sky130_fd_sc_hd__o2111ai_1
XFILLER_0_24_275 vssd1 vssd1 vccd1 vccd1 sky130_fd_sc_hd__fill_1
XFILLER_0_24_242 vssd1 vssd1 vccd1 vccd1 sky130_fd_sc_hd__decap_3
Xinput22 sport_i[23] vssd1 vssd1 vccd1 vccd1 input22/X sky130_fd_sc_hd__buf_1
XFILLER_0_3_169 vssd1 vssd1 vccd1 vccd1 sky130_ef_sc_hd__decap_12
Xinput11 sport_i[13] vssd1 vssd1 vccd1 vccd1 _1301_/B sky130_fd_sc_hd__buf_1
Xinput33 sport_i[33] vssd1 vssd1 vccd1 vccd1 input33/X sky130_fd_sc_hd__clkbuf_1
Xinput44 sport_i[43] vssd1 vssd1 vccd1 vccd1 _0991_/A sky130_fd_sc_hd__buf_1
Xinput55 sport_i[53] vssd1 vssd1 vccd1 vccd1 _1026_/A sky130_fd_sc_hd__buf_1
X_1157_ _1157_/A vssd1 vssd1 vccd1 vccd1 _1158_/B sky130_fd_sc_hd__clkinvlp_2
X_1226_ hold36/X _1221_/Y _1223_/Y _1291_/A vssd1 vssd1 vccd1 vccd1 _1227_/A sky130_fd_sc_hd__o2bb2ai_1
X_1088_ _1088_/A vssd1 vssd1 vccd1 vccd1 _1478_/D sky130_fd_sc_hd__clkbuf_1
XFILLER_0_15_297 vssd1 vssd1 vccd1 vccd1 sky130_fd_sc_hd__fill_2
XFILLER_0_28_24 vssd1 vssd1 vccd1 vccd1 sky130_fd_sc_hd__fill_2
X_1011_ _1011_/A _1011_/B vssd1 vssd1 vccd1 vccd1 _1032_/A sky130_fd_sc_hd__nor2_1
XANTENNA__0905__S _0933_/S vssd1 vssd1 vccd1 vccd1 sky130_fd_sc_hd__diode_2
XFILLER_0_8_239 vssd1 vssd1 vccd1 vccd1 sky130_fd_sc_hd__fill_2
XFILLER_0_8_56 vssd1 vssd1 vccd1 vccd1 sky130_fd_sc_hd__fill_2
XFILLER_0_8_78 vssd1 vssd1 vccd1 vccd1 sky130_fd_sc_hd__decap_6
X_0726_ _1077_/B vssd1 vssd1 vccd1 vccd1 _0729_/B sky130_fd_sc_hd__inv_2
X_1209_ _1216_/A _1209_/B vssd1 vssd1 vccd1 vccd1 _1209_/X sky130_fd_sc_hd__and2_1
XANTENNA__1502__RESET_B fanout129/X vssd1 vssd1 vccd1 vccd1 sky130_fd_sc_hd__diode_2
XFILLER_0_39_89 vssd1 vssd1 vccd1 vccd1 sky130_fd_sc_hd__fill_1
XTAP_259 vssd1 vccd1 sky130_fd_sc_hd__tapvpwrvgnd_1
XTAP_248 vssd1 vccd1 sky130_fd_sc_hd__tapvpwrvgnd_1
XTAP_237 vssd1 vccd1 sky130_fd_sc_hd__tapvpwrvgnd_1
XTAP_226 vssd1 vccd1 sky130_fd_sc_hd__tapvpwrvgnd_1
X_1491_ _1491_/CLK _1491_/D fanout122/X vssd1 vssd1 vccd1 vccd1 _1491_/Q sky130_fd_sc_hd__dfrtp_1
XTAP_204 vssd1 vccd1 sky130_fd_sc_hd__tapvpwrvgnd_1
XTAP_215 vssd1 vccd1 sky130_fd_sc_hd__tapvpwrvgnd_1
XFILLER_0_44_167 vssd1 vssd1 vccd1 vccd1 sky130_fd_sc_hd__decap_3
XFILLER_0_4_286 vssd1 vssd1 vccd1 vccd1 sky130_fd_sc_hd__decap_3
XFILLER_0_4_253 vssd1 vssd1 vccd1 vccd1 sky130_fd_sc_hd__fill_2
XFILLER_0_35_156 vssd1 vssd1 vccd1 vccd1 sky130_fd_sc_hd__fill_1
X_0991_ _0991_/A vssd1 vssd1 vccd1 vccd1 _0993_/A sky130_fd_sc_hd__inv_2
X_1543_ _1544_/A vssd1 vssd1 vccd1 vccd1 _1543_/X sky130_fd_sc_hd__buf_1
XFILLER_0_1_223 vssd1 vssd1 vccd1 vccd1 sky130_fd_sc_hd__fill_1
X_1474_ _1505_/CLK _1474_/D fanout129/X vssd1 vssd1 vccd1 vccd1 _1474_/Q sky130_fd_sc_hd__dfrtp_1
XFILLER_0_5_57 vssd1 vssd1 vccd1 vccd1 sky130_fd_sc_hd__decap_6
XFILLER_0_17_123 vssd1 vssd1 vccd1 vccd1 sky130_fd_sc_hd__decap_3
XFILLER_0_40_181 vssd1 vssd1 vccd1 vccd1 sky130_fd_sc_hd__decap_8
Xclkbuf_4_8_0_clk_i clkbuf_0_clk_i/X vssd1 vssd1 vccd1 vccd1 _1506_/CLK sky130_fd_sc_hd__clkbuf_8
XFILLER_0_23_137 vssd1 vssd1 vccd1 vccd1 sky130_fd_sc_hd__decap_3
XFILLER_0_23_159 vssd1 vssd1 vccd1 vccd1 sky130_fd_sc_hd__fill_2
Xinput9 sport_i[11] vssd1 vssd1 vccd1 vccd1 input9/X sky130_fd_sc_hd__buf_1
X_1190_ _1313_/A hold23/X vssd1 vssd1 vccd1 vccd1 _1199_/A sky130_fd_sc_hd__nand2_1
XFILLER_0_46_207 vssd1 vssd1 vccd1 vccd1 sky130_fd_sc_hd__fill_2
XTAP_98 vssd1 vccd1 sky130_fd_sc_hd__tapvpwrvgnd_1
XFILLER_0_39_281 vssd1 vssd1 vccd1 vccd1 sky130_ef_sc_hd__decap_12
XANTENNA__0913__S _0933_/S vssd1 vssd1 vccd1 vccd1 sky130_fd_sc_hd__diode_2
X_0974_ _0974_/A _0974_/B vssd1 vssd1 vccd1 vccd1 _0981_/A sky130_fd_sc_hd__nand2_1
X_1457_ _1539_/CLK _1457_/D fanout125/X vssd1 vssd1 vccd1 vccd1 _1457_/Q sky130_fd_sc_hd__dfrtp_1
X_1526_ _1531_/CLK hold82/X fanout125/X vssd1 vssd1 vccd1 vccd1 hold81/A sky130_fd_sc_hd__dfrtp_1
X_1388_ _1388_/A _1388_/B vssd1 vssd1 vccd1 vccd1 _1535_/D sky130_fd_sc_hd__nand2_1
XFILLER_0_45_273 vssd1 vssd1 vccd1 vccd1 sky130_fd_sc_hd__decap_6
XPHY_82 vssd1 vssd1 vccd1 vccd1 sky130_fd_sc_hd__decap_3
XPHY_71 vssd1 vssd1 vccd1 vccd1 sky130_fd_sc_hd__decap_3
XPHY_60 vssd1 vssd1 vccd1 vccd1 sky130_fd_sc_hd__decap_3
XPHY_93 vssd1 vssd1 vccd1 vccd1 sky130_fd_sc_hd__decap_3
XFILLER_0_36_251 vssd1 vssd1 vccd1 vccd1 sky130_fd_sc_hd__fill_1
XFILLER_0_11_129 vssd1 vssd1 vccd1 vccd1 sky130_ef_sc_hd__decap_12
X_1311_ _1311_/A _1426_/A _1334_/C vssd1 vssd1 vccd1 vccd1 _1312_/B sky130_fd_sc_hd__nand3_1
X_1173_ _1262_/B _1171_/X _0872_/A _1180_/A vssd1 vssd1 vccd1 vccd1 _1507_/D sky130_fd_sc_hd__o22ai_1
X_1242_ _1313_/A hold57/X vssd1 vssd1 vccd1 vccd1 _1250_/A sky130_fd_sc_hd__nand2_1
XFILLER_0_27_240 vssd1 vssd1 vccd1 vccd1 sky130_fd_sc_hd__decap_3
XFILLER_0_19_229 vssd1 vssd1 vccd1 vccd1 sky130_fd_sc_hd__fill_2
X_0957_ _0957_/A vssd1 vssd1 vccd1 vccd1 _1465_/D sky130_fd_sc_hd__clkbuf_1
XFILLER_0_42_265 vssd1 vssd1 vccd1 vccd1 sky130_ef_sc_hd__decap_12
XFILLER_0_42_210 vssd1 vssd1 vccd1 vccd1 sky130_fd_sc_hd__fill_2
Xoutput121 _1448_/Q vssd1 vssd1 vccd1 vccd1 sport_o[9] sky130_fd_sc_hd__buf_12
Xoutput110 _1441_/Q vssd1 vssd1 vccd1 vccd1 sport_o[2] sky130_fd_sc_hd__buf_12
X_0888_ _1082_/A _1494_/Q vssd1 vssd1 vccd1 vccd1 _0888_/Y sky130_fd_sc_hd__nand2_1
XFILLER_0_12_70 vssd1 vssd1 vccd1 vccd1 sky130_fd_sc_hd__fill_2
X_1509_ _1509_/CLK _1509_/D fanout129/X vssd1 vssd1 vccd1 vccd1 _1509_/Q sky130_fd_sc_hd__dfrtp_1
XFILLER_0_10_173 vssd1 vssd1 vccd1 vccd1 sky130_fd_sc_hd__decap_6
XFILLER_0_18_240 vssd1 vssd1 vccd1 vccd1 sky130_fd_sc_hd__decap_4
XFILLER_0_18_262 vssd1 vssd1 vccd1 vccd1 sky130_fd_sc_hd__fill_1
XANTENNA__1527__RESET_B fanout125/X vssd1 vssd1 vccd1 vccd1 sky130_fd_sc_hd__diode_2
Xinput67 sport_i[64] vssd1 vssd1 vccd1 vccd1 _1012_/B sky130_fd_sc_hd__buf_1
X_0811_ _1222_/A hold23/X _1404_/B vssd1 vssd1 vccd1 vccd1 _0811_/Y sky130_fd_sc_hd__a21oi_1
Xinput12 sport_i[14] vssd1 vssd1 vccd1 vccd1 _1309_/B sky130_fd_sc_hd__buf_1
Xinput23 sport_i[24] vssd1 vssd1 vccd1 vccd1 _1378_/B sky130_fd_sc_hd__buf_1
Xinput34 sport_i[34] vssd1 vssd1 vccd1 vccd1 input34/X sky130_fd_sc_hd__clkbuf_1
Xinput45 sport_i[44] vssd1 vssd1 vccd1 vccd1 _1007_/A sky130_fd_sc_hd__buf_1
X_0742_ _0973_/A hold25/X vssd1 vssd1 vccd1 vccd1 hold26/A sky130_fd_sc_hd__nand2_1
Xinput56 sport_i[54] vssd1 vssd1 vccd1 vccd1 _1024_/A sky130_fd_sc_hd__clkbuf_1
XANTENNA__1323__A _1430_/Q vssd1 vssd1 vccd1 vccd1 sky130_fd_sc_hd__diode_2
X_1087_ hold98/X input32/X _1117_/S vssd1 vssd1 vccd1 vccd1 _1088_/A sky130_fd_sc_hd__mux2_1
X_1156_ _1163_/A vssd1 vssd1 vccd1 vccd1 _1162_/A sky130_fd_sc_hd__inv_2
X_1225_ _1262_/B _1225_/B vssd1 vssd1 vccd1 vccd1 _1291_/A sky130_fd_sc_hd__or2_1
XANTENNA__1408__A _1426_/A vssd1 vssd1 vccd1 vccd1 sky130_fd_sc_hd__diode_2
X_1010_ _1010_/A _1010_/B vssd1 vssd1 vccd1 vccd1 _1011_/B sky130_fd_sc_hd__nand2_1
XANTENNA__0921__S _0933_/S vssd1 vssd1 vccd1 vccd1 sky130_fd_sc_hd__diode_2
X_0725_ _1061_/B vssd1 vssd1 vccd1 vccd1 _0741_/B sky130_fd_sc_hd__inv_2
X_1208_ _1208_/A vssd1 vssd1 vccd1 vccd1 _1208_/X sky130_fd_sc_hd__buf_4
X_1139_ _1133_/Y _1165_/A hold30/X vssd1 vssd1 vccd1 vccd1 hold31/A sky130_fd_sc_hd__o21ai_1
XFILLER_0_39_35 vssd1 vssd1 vccd1 vccd1 sky130_fd_sc_hd__fill_2
X_1490_ _1521_/CLK _1490_/D fanout122/X vssd1 vssd1 vccd1 vccd1 _1490_/Q sky130_fd_sc_hd__dfrtp_1
XTAP_205 vssd1 vccd1 sky130_fd_sc_hd__tapvpwrvgnd_1
XTAP_249 vssd1 vccd1 sky130_fd_sc_hd__tapvpwrvgnd_1
XTAP_238 vssd1 vccd1 sky130_fd_sc_hd__tapvpwrvgnd_1
XTAP_227 vssd1 vccd1 sky130_fd_sc_hd__tapvpwrvgnd_1
Xhold1 hold1/A vssd1 vssd1 vccd1 vccd1 hold1/X sky130_fd_sc_hd__dlygate4sd3_1
XTAP_216 vssd1 vccd1 sky130_fd_sc_hd__tapvpwrvgnd_1
XFILLER_0_44_135 vssd1 vssd1 vccd1 vccd1 sky130_fd_sc_hd__fill_2
XFILLER_0_29_198 vssd1 vssd1 vccd1 vccd1 sky130_fd_sc_hd__decap_3
Xclkbuf_4_4_0_clk_i clkbuf_0_clk_i/X vssd1 vssd1 vccd1 vccd1 _1520_/CLK sky130_fd_sc_hd__clkbuf_8
XFILLER_0_26_124 vssd1 vssd1 vccd1 vccd1 sky130_fd_sc_hd__decap_3
X_0990_ _0990_/A _0990_/B _0990_/C vssd1 vssd1 vccd1 vccd1 _1058_/A sky130_fd_sc_hd__nand3_1
XFILLER_0_1_279 vssd1 vssd1 vccd1 vccd1 sky130_fd_sc_hd__fill_1
X_1473_ _1505_/CLK _1473_/D fanout129/X vssd1 vssd1 vccd1 vccd1 _1473_/Q sky130_fd_sc_hd__dfrtp_1
X_1542_ _1544_/A vssd1 vssd1 vccd1 vccd1 _1542_/X sky130_fd_sc_hd__buf_1
XANTENNA__1340__A2 input16/X vssd1 vssd1 vccd1 vccd1 sky130_fd_sc_hd__diode_2
XFILLER_0_10_6 vssd1 vssd1 vccd1 vccd1 sky130_fd_sc_hd__fill_2
XANTENNA__1464__RESET_B fanout128/X vssd1 vssd1 vccd1 vccd1 sky130_fd_sc_hd__diode_2
XFILLER_0_17_102 vssd1 vssd1 vccd1 vccd1 sky130_fd_sc_hd__fill_2
XFILLER_0_17_113 vssd1 vssd1 vccd1 vccd1 sky130_fd_sc_hd__fill_2
XFILLER_0_31_91 vssd1 vssd1 vccd1 vccd1 sky130_fd_sc_hd__fill_2
XFILLER_0_23_116 vssd1 vssd1 vccd1 vccd1 sky130_ef_sc_hd__decap_12
XFILLER_0_39_293 vssd1 vssd1 vccd1 vccd1 sky130_fd_sc_hd__fill_2
XTAP_99 vssd1 vccd1 sky130_fd_sc_hd__tapvpwrvgnd_1
X_0973_ _0973_/A hold25/A _1046_/A vssd1 vssd1 vccd1 vccd1 _0974_/B sky130_fd_sc_hd__nand3_1
X_1456_ _1531_/CLK _1456_/D fanout124/X vssd1 vssd1 vccd1 vccd1 _1456_/Q sky130_fd_sc_hd__dfrtp_2
X_1387_ _1401_/A _1426_/B _1387_/C vssd1 vssd1 vccd1 vccd1 _1388_/B sky130_fd_sc_hd__nand3_1
X_1525_ _1525_/CLK hold75/X fanout127/X vssd1 vssd1 vccd1 vccd1 hold74/A sky130_fd_sc_hd__dfrtp_1
XFILLER_0_13_160 vssd1 vssd1 vccd1 vccd1 sky130_fd_sc_hd__decap_6
XPHY_83 vssd1 vssd1 vccd1 vccd1 sky130_fd_sc_hd__decap_3
XPHY_72 vssd1 vssd1 vccd1 vccd1 sky130_fd_sc_hd__decap_3
XPHY_61 vssd1 vssd1 vccd1 vccd1 sky130_fd_sc_hd__decap_3
XFILLER_0_28_208 vssd1 vssd1 vccd1 vccd1 sky130_fd_sc_hd__fill_1
XPHY_50 vssd1 vssd1 vccd1 vccd1 sky130_fd_sc_hd__decap_3
X_1241_ _1241_/A _1241_/B vssd1 vssd1 vccd1 vccd1 hold44/A sky130_fd_sc_hd__nand2_1
X_1310_ _1310_/A _1310_/B vssd1 vssd1 vccd1 vccd1 _1311_/A sky130_fd_sc_hd__nand2_1
X_1172_ _1262_/B _1174_/A _1186_/B _1171_/A vssd1 vssd1 vccd1 vccd1 _1180_/A sky130_fd_sc_hd__o211ai_4
X_0956_ hold151/X hold67/X _0966_/S vssd1 vssd1 vccd1 vccd1 _0957_/A sky130_fd_sc_hd__mux2_1
XFILLER_0_42_200 vssd1 vssd1 vccd1 vccd1 sky130_fd_sc_hd__decap_4
XFILLER_0_27_252 vssd1 vssd1 vccd1 vccd1 sky130_fd_sc_hd__fill_2
Xoutput100 _1459_/Q vssd1 vssd1 vccd1 vccd1 sport_o[20] sky130_fd_sc_hd__buf_12
Xoutput111 _1469_/Q vssd1 vssd1 vccd1 vccd1 sport_o[30] sky130_fd_sc_hd__buf_12
XFILLER_0_42_277 vssd1 vssd1 vccd1 vccd1 sky130_ef_sc_hd__decap_12
XFILLER_0_10_141 vssd1 vssd1 vccd1 vccd1 sky130_fd_sc_hd__decap_3
X_0887_ _0887_/A _1045_/A vssd1 vssd1 vccd1 vccd1 _0896_/B sky130_fd_sc_hd__nand2_1
X_1508_ _1509_/CLK _1508_/D fanout129/X vssd1 vssd1 vccd1 vccd1 _1508_/Q sky130_fd_sc_hd__dfrtp_4
X_1439_ _1520_/CLK _1439_/D fanout124/X vssd1 vssd1 vccd1 vccd1 _1439_/Q sky130_fd_sc_hd__dfrtp_1
XFILLER_0_33_244 vssd1 vssd1 vccd1 vccd1 sky130_fd_sc_hd__fill_2
Xinput13 sport_i[15] vssd1 vssd1 vccd1 vccd1 _1317_/B sky130_fd_sc_hd__buf_1
X_0810_ _1351_/A hold36/X vssd1 vssd1 vccd1 vccd1 _0810_/Y sky130_fd_sc_hd__nand2_1
Xinput68 sport_i[65] vssd1 vssd1 vccd1 vccd1 _0762_/A sky130_fd_sc_hd__buf_1
Xinput57 sport_i[55] vssd1 vssd1 vccd1 vccd1 _1023_/A sky130_fd_sc_hd__clkbuf_1
XFILLER_0_3_116 vssd1 vssd1 vccd1 vccd1 sky130_ef_sc_hd__decap_12
Xinput24 sport_i[25] vssd1 vssd1 vccd1 vccd1 _1385_/B sky130_fd_sc_hd__buf_1
Xinput35 sport_i[35] vssd1 vssd1 vccd1 vccd1 input35/X sky130_fd_sc_hd__buf_1
X_0741_ hold24/X _0741_/B vssd1 vssd1 vccd1 vccd1 hold25/A sky130_fd_sc_hd__nor2_1
Xinput46 sport_i[45] vssd1 vssd1 vccd1 vccd1 _1006_/A sky130_fd_sc_hd__buf_1
XANTENNA__0919__S _0933_/S vssd1 vssd1 vccd1 vccd1 sky130_fd_sc_hd__diode_2
X_1224_ _1252_/A _1430_/Q vssd1 vssd1 vccd1 vccd1 _1225_/B sky130_fd_sc_hd__nand2_1
X_1155_ _1153_/X _1165_/A hold10/X vssd1 vssd1 vccd1 vccd1 hold11/A sky130_fd_sc_hd__o21ai_1
X_1086_ _1129_/S vssd1 vssd1 vccd1 vccd1 _1117_/S sky130_fd_sc_hd__clkbuf_8
X_0939_ _0939_/A vssd1 vssd1 vccd1 vccd1 _1456_/D sky130_fd_sc_hd__clkbuf_1
XFILLER_0_15_233 vssd1 vssd1 vccd1 vccd1 sky130_ef_sc_hd__decap_12
XFILLER_0_0_108 vssd1 vssd1 vccd1 vccd1 sky130_fd_sc_hd__decap_4
XFILLER_0_21_225 vssd1 vssd1 vccd1 vccd1 sky130_fd_sc_hd__decap_3
X_0724_ hold24/X vssd1 vssd1 vccd1 vccd1 _0753_/A sky130_fd_sc_hd__inv_2
XANTENNA__1334__A _1401_/A vssd1 vssd1 vccd1 vccd1 sky130_fd_sc_hd__diode_2
X_1207_ _1432_/Q hold68/X _1252_/A vssd1 vssd1 vccd1 vccd1 _1207_/X sky130_fd_sc_hd__mux2_1
XFILLER_0_18_70 vssd1 vssd1 vccd1 vccd1 sky130_ef_sc_hd__decap_12
XFILLER_0_19_3 vssd1 vssd1 vccd1 vccd1 sky130_fd_sc_hd__fill_1
X_1138_ _1165_/A hold29/X vssd1 vssd1 vccd1 vccd1 hold30/A sky130_fd_sc_hd__nand2_1
X_1069_ _1073_/B _1079_/B _1067_/Y _1047_/A _1075_/B vssd1 vssd1 vccd1 vccd1 _1070_/C
+ sky130_fd_sc_hd__o2111ai_1
XFILLER_0_7_263 vssd1 vssd1 vccd1 vccd1 sky130_ef_sc_hd__decap_12
Xclkbuf_4_0_0_clk_i clkbuf_0_clk_i/X vssd1 vssd1 vccd1 vccd1 _1491_/CLK sky130_fd_sc_hd__clkbuf_8
XFILLER_0_38_188 vssd1 vssd1 vccd1 vccd1 sky130_fd_sc_hd__fill_2
XFILLER_0_30_49 vssd1 vssd1 vccd1 vccd1 sky130_fd_sc_hd__fill_1
XTAP_239 vssd1 vccd1 sky130_fd_sc_hd__tapvpwrvgnd_1
XTAP_228 vssd1 vccd1 sky130_fd_sc_hd__tapvpwrvgnd_1
XTAP_206 vssd1 vccd1 sky130_fd_sc_hd__tapvpwrvgnd_1
XTAP_217 vssd1 vccd1 sky130_fd_sc_hd__tapvpwrvgnd_1
Xhold2 hold2/A vssd1 vssd1 vccd1 vccd1 hold2/X sky130_fd_sc_hd__dlygate4sd3_1
XFILLER_0_29_166 vssd1 vssd1 vccd1 vccd1 sky130_fd_sc_hd__fill_2
XFILLER_0_35_136 vssd1 vssd1 vccd1 vccd1 sky130_fd_sc_hd__fill_2
XFILLER_0_0_81 vssd1 vssd1 vccd1 vccd1 sky130_fd_sc_hd__decap_3
XFILLER_0_8_3 vssd1 vssd1 vccd1 vccd1 sky130_fd_sc_hd__fill_2
XANTENNA_clkbuf_4_2_0_clk_i_A clkbuf_0_clk_i/X vssd1 vssd1 vccd1 vccd1 sky130_fd_sc_hd__diode_2
XFILLER_0_26_158 vssd1 vssd1 vccd1 vccd1 sky130_ef_sc_hd__decap_12
XFILLER_0_1_225 vssd1 vssd1 vccd1 vccd1 sky130_fd_sc_hd__fill_1
X_1541_ _1541_/CLK hold49/X fanout126/X vssd1 vssd1 vccd1 vccd1 _1541_/Q sky130_fd_sc_hd__dfrtp_1
XFILLER_0_5_37 vssd1 vssd1 vccd1 vccd1 sky130_fd_sc_hd__decap_4
X_1472_ _1505_/CLK _1472_/D fanout127/X vssd1 vssd1 vccd1 vccd1 hold24/A sky130_fd_sc_hd__dfrtp_1
XANTENNA__0927__S _0933_/S vssd1 vssd1 vccd1 vccd1 sky130_fd_sc_hd__diode_2
XFILLER_0_17_169 vssd1 vssd1 vccd1 vccd1 sky130_fd_sc_hd__fill_1
XFILLER_0_40_161 vssd1 vssd1 vccd1 vccd1 sky130_fd_sc_hd__fill_2
XANTENNA__1433__RESET_B fanout129/X vssd1 vssd1 vccd1 vccd1 sky130_fd_sc_hd__diode_2
XFILLER_0_32_139 vssd1 vssd1 vccd1 vccd1 sky130_fd_sc_hd__fill_1
XANTENNA__1316__B1 _1398_/B vssd1 vssd1 vccd1 vccd1 sky130_fd_sc_hd__diode_2
XFILLER_0_23_128 vssd1 vssd1 vccd1 vccd1 sky130_fd_sc_hd__fill_1
XFILLER_0_36_59 vssd1 vssd1 vccd1 vccd1 sky130_fd_sc_hd__fill_1
X_0972_ _1167_/A _0972_/B vssd1 vssd1 vccd1 vccd1 _0974_/A sky130_fd_sc_hd__nand2_1
X_1524_ _1540_/CLK hold47/X fanout128/X vssd1 vssd1 vccd1 vccd1 hold46/A sky130_fd_sc_hd__dfrtp_1
XFILLER_0_14_139 vssd1 vssd1 vccd1 vccd1 sky130_fd_sc_hd__fill_1
XFILLER_0_22_194 vssd1 vssd1 vccd1 vccd1 sky130_fd_sc_hd__fill_2
X_1455_ _1531_/CLK _1455_/D fanout124/X vssd1 vssd1 vccd1 vccd1 _1455_/Q sky130_fd_sc_hd__dfrtp_1
X_1386_ _1386_/A _1386_/B vssd1 vssd1 vccd1 vccd1 _1387_/C sky130_fd_sc_hd__nand2_1
XPHY_84 vssd1 vssd1 vccd1 vccd1 sky130_fd_sc_hd__decap_3
XPHY_73 vssd1 vssd1 vccd1 vccd1 sky130_fd_sc_hd__decap_3
XFILLER_0_36_253 vssd1 vssd1 vccd1 vccd1 sky130_ef_sc_hd__decap_12
XPHY_62 vssd1 vssd1 vccd1 vccd1 sky130_fd_sc_hd__decap_3
XPHY_51 vssd1 vssd1 vccd1 vccd1 sky130_fd_sc_hd__decap_3
XPHY_40 vssd1 vssd1 vccd1 vccd1 sky130_fd_sc_hd__decap_3
XFILLER_0_36_297 vssd1 vssd1 vccd1 vccd1 sky130_fd_sc_hd__fill_2
X_1171_ _1171_/A _1186_/B vssd1 vssd1 vccd1 vccd1 _1171_/X sky130_fd_sc_hd__and2_1
X_1240_ _1240_/A _1426_/A _1334_/C vssd1 vssd1 vccd1 vccd1 _1241_/B sky130_fd_sc_hd__nand3_1
X_0955_ _0955_/A vssd1 vssd1 vccd1 vccd1 _1464_/D sky130_fd_sc_hd__clkbuf_1
XANTENNA__0940__S _0966_/S vssd1 vssd1 vccd1 vccd1 sky130_fd_sc_hd__diode_2
X_0886_ _0886_/A _0886_/B vssd1 vssd1 vccd1 vccd1 _0887_/A sky130_fd_sc_hd__nand2_1
Xoutput112 _1470_/Q vssd1 vssd1 vccd1 vccd1 sport_o[31] sky130_fd_sc_hd__buf_12
Xoutput101 _1460_/Q vssd1 vssd1 vccd1 vccd1 sport_o[21] sky130_fd_sc_hd__buf_12
XFILLER_0_42_289 vssd1 vssd1 vccd1 vccd1 sky130_fd_sc_hd__decap_8
X_1507_ _1507_/CLK _1507_/D fanout129/X vssd1 vssd1 vccd1 vccd1 _1507_/Q sky130_fd_sc_hd__dfrtp_1
XFILLER_0_10_186 vssd1 vssd1 vccd1 vccd1 sky130_fd_sc_hd__decap_8
X_1438_ _1509_/CLK _1438_/D fanout128/X vssd1 vssd1 vccd1 vccd1 _1438_/Q sky130_fd_sc_hd__dfrtp_1
X_1369_ _1422_/A hold89/X vssd1 vssd1 vccd1 vccd1 _1374_/A sky130_fd_sc_hd__nand2_1
XFILLER_0_10_197 vssd1 vssd1 vccd1 vccd1 sky130_fd_sc_hd__fill_2
XFILLER_0_33_278 vssd1 vssd1 vccd1 vccd1 sky130_fd_sc_hd__fill_2
XFILLER_0_33_234 vssd1 vssd1 vccd1 vccd1 sky130_fd_sc_hd__fill_2
XFILLER_0_33_223 vssd1 vssd1 vccd1 vccd1 sky130_fd_sc_hd__fill_1
XANTENNA__1536__RESET_B fanout128/X vssd1 vssd1 vccd1 vccd1 sky130_fd_sc_hd__diode_2
Xinput14 sport_i[16] vssd1 vssd1 vccd1 vccd1 input14/X sky130_fd_sc_hd__buf_1
Xinput25 sport_i[26] vssd1 vssd1 vccd1 vccd1 _1392_/B sky130_fd_sc_hd__buf_1
Xinput36 sport_i[36] vssd1 vssd1 vccd1 vccd1 input36/X sky130_fd_sc_hd__buf_1
X_0740_ _0814_/A vssd1 vssd1 vccd1 vccd1 _0973_/A sky130_fd_sc_hd__inv_2
Xinput69 sport_i[66] vssd1 vssd1 vccd1 vccd1 _0975_/A sky130_fd_sc_hd__dlymetal6s2s_1
Xinput58 sport_i[56] vssd1 vssd1 vccd1 vccd1 _1020_/A sky130_fd_sc_hd__clkbuf_1
XFILLER_0_3_128 vssd1 vssd1 vccd1 vccd1 sky130_ef_sc_hd__decap_12
Xinput47 sport_i[46] vssd1 vssd1 vccd1 vccd1 _1004_/A sky130_fd_sc_hd__buf_1
X_1223_ _1289_/A _1223_/B _1287_/B vssd1 vssd1 vccd1 vccd1 _1223_/Y sky130_fd_sc_hd__nand3_2
X_1154_ _1165_/A hold9/X vssd1 vssd1 vccd1 vccd1 hold10/A sky130_fd_sc_hd__nand2_1
X_1085_ _0974_/A _1084_/A _1084_/Y hold78/X vssd1 vssd1 vccd1 vccd1 hold79/A sky130_fd_sc_hd__a22o_1
X_0938_ hold160/X hold80/X _0966_/S vssd1 vssd1 vccd1 vccd1 _0939_/A sky130_fd_sc_hd__mux2_1
XFILLER_0_30_215 vssd1 vssd1 vccd1 vccd1 sky130_fd_sc_hd__decap_3
X_0869_ _1222_/A hold68/X _1404_/B vssd1 vssd1 vccd1 vccd1 _0869_/Y sky130_fd_sc_hd__a21oi_1
XFILLER_0_15_223 vssd1 vssd1 vccd1 vccd1 sky130_fd_sc_hd__fill_1
XFILLER_0_15_245 vssd1 vssd1 vccd1 vccd1 sky130_ef_sc_hd__decap_12
XFILLER_0_3_81 vssd1 vssd1 vccd1 vccd1 sky130_fd_sc_hd__fill_2
XFILLER_0_21_215 vssd1 vssd1 vccd1 vccd1 sky130_fd_sc_hd__fill_1
XFILLER_0_8_48 vssd1 vssd1 vccd1 vccd1 sky130_fd_sc_hd__decap_8
X_0723_ _1134_/B vssd1 vssd1 vccd1 vccd1 _0723_/Y sky130_fd_sc_hd__inv_6
X_1206_ _1313_/A hold68/X vssd1 vssd1 vccd1 vccd1 _1213_/A sky130_fd_sc_hd__nand2_1
X_1137_ _0969_/C _1170_/A _0723_/Y _1136_/Y vssd1 vssd1 vccd1 vccd1 _1165_/A sky130_fd_sc_hd__o31ai_4
XFILLER_0_18_82 vssd1 vssd1 vccd1 vccd1 sky130_fd_sc_hd__fill_2
XFILLER_0_18_93 vssd1 vssd1 vccd1 vccd1 sky130_fd_sc_hd__fill_2
XFILLER_0_7_275 vssd1 vssd1 vccd1 vccd1 sky130_fd_sc_hd__decap_4
X_1068_ _1077_/B _0759_/B _0734_/Y _0817_/A vssd1 vssd1 vccd1 vccd1 _1075_/B sky130_fd_sc_hd__a22o_1
XFILLER_0_11_281 vssd1 vssd1 vccd1 vccd1 sky130_fd_sc_hd__fill_2
XANTENNA__0927__A1 hold41/X vssd1 vssd1 vccd1 vccd1 sky130_fd_sc_hd__diode_2
XTAP_229 vssd1 vccd1 sky130_fd_sc_hd__tapvpwrvgnd_1
XTAP_207 vssd1 vccd1 sky130_fd_sc_hd__tapvpwrvgnd_1
XTAP_218 vssd1 vccd1 sky130_fd_sc_hd__tapvpwrvgnd_1
Xhold3 hold3/A vssd1 vssd1 vccd1 vccd1 hold3/X sky130_fd_sc_hd__dlygate4sd3_1
XFILLER_0_44_126 vssd1 vssd1 vccd1 vccd1 sky130_fd_sc_hd__fill_1
XFILLER_0_29_101 vssd1 vssd1 vccd1 vccd1 sky130_fd_sc_hd__decap_8
XFILLER_0_4_278 vssd1 vssd1 vccd1 vccd1 sky130_fd_sc_hd__decap_4
XFILLER_0_20_83 vssd1 vssd1 vccd1 vccd1 sky130_fd_sc_hd__fill_1
XFILLER_0_29_70 vssd1 vssd1 vccd1 vccd1 sky130_ef_sc_hd__decap_12
XANTENNA__1064__B _1426_/B vssd1 vssd1 vccd1 vccd1 sky130_fd_sc_hd__diode_2
X_1540_ _1540_/CLK hold15/X fanout128/X vssd1 vssd1 vccd1 vccd1 _1540_/Q sky130_fd_sc_hd__dfrtp_1
XANTENNA_clkbuf_4_6_0_clk_i_A clkbuf_0_clk_i/X vssd1 vssd1 vccd1 vccd1 sky130_fd_sc_hd__diode_2
XFILLER_0_1_248 vssd1 vssd1 vccd1 vccd1 sky130_fd_sc_hd__fill_2
X_1471_ _1471_/CLK _1471_/D fanout127/X vssd1 vssd1 vccd1 vccd1 _1471_/Q sky130_fd_sc_hd__dfrtp_1
XFILLER_0_40_173 vssd1 vssd1 vccd1 vccd1 sky130_fd_sc_hd__fill_2
XFILLER_0_0_281 vssd1 vssd1 vccd1 vccd1 sky130_fd_sc_hd__fill_2
XANTENNA__1473__RESET_B fanout129/X vssd1 vssd1 vccd1 vccd1 sky130_fd_sc_hd__diode_2
X_0971_ _1084_/B _1167_/B vssd1 vssd1 vccd1 vccd1 _0972_/B sky130_fd_sc_hd__nand2_1
X_1454_ _1540_/CLK _1454_/D fanout128/X vssd1 vssd1 vccd1 vccd1 _1454_/Q sky130_fd_sc_hd__dfrtp_2
X_1523_ _1525_/CLK hold77/X fanout126/X vssd1 vssd1 vccd1 vccd1 hold76/A sky130_fd_sc_hd__dfrtp_1
XANTENNA__0938__S _0966_/S vssd1 vssd1 vccd1 vccd1 sky130_fd_sc_hd__diode_2
X_1385_ _1418_/A _1385_/B vssd1 vssd1 vccd1 vccd1 _1386_/B sky130_fd_sc_hd__nand2_1
XFILLER_0_45_221 vssd1 vssd1 vccd1 vccd1 sky130_fd_sc_hd__decap_3
XFILLER_0_9_134 vssd1 vssd1 vccd1 vccd1 sky130_ef_sc_hd__decap_12
XFILLER_0_13_184 vssd1 vssd1 vccd1 vccd1 sky130_fd_sc_hd__fill_2
XPHY_30 vssd1 vssd1 vccd1 vccd1 sky130_fd_sc_hd__decap_3
XANTENNA__1252__B _1433_/Q vssd1 vssd1 vccd1 vccd1 sky130_fd_sc_hd__diode_2
XPHY_85 vssd1 vssd1 vccd1 vccd1 sky130_fd_sc_hd__decap_3
XPHY_74 vssd1 vssd1 vccd1 vccd1 sky130_fd_sc_hd__decap_3
XFILLER_0_36_265 vssd1 vssd1 vccd1 vccd1 sky130_ef_sc_hd__decap_12
XPHY_63 vssd1 vssd1 vccd1 vccd1 sky130_fd_sc_hd__decap_3
XPHY_52 vssd1 vssd1 vccd1 vccd1 sky130_fd_sc_hd__decap_3
XPHY_41 vssd1 vssd1 vccd1 vccd1 sky130_fd_sc_hd__decap_3
XFILLER_0_22_29 vssd1 vssd1 vccd1 vccd1 sky130_fd_sc_hd__decap_8
X_1170_ _1170_/A _1174_/A vssd1 vssd1 vccd1 vccd1 _1186_/B sky130_fd_sc_hd__nand2_2
X_0954_ hold150/X hold55/X _0966_/S vssd1 vssd1 vccd1 vccd1 _0955_/A sky130_fd_sc_hd__mux2_1
X_0885_ _0885_/A _1223_/B vssd1 vssd1 vccd1 vccd1 _0886_/B sky130_fd_sc_hd__nand2_1
XFILLER_0_12_51 vssd1 vssd1 vccd1 vccd1 sky130_fd_sc_hd__decap_8
Xoutput102 _1461_/Q vssd1 vssd1 vccd1 vccd1 sport_o[22] sky130_fd_sc_hd__buf_12
Xoutput113 _0733_/A vssd1 vssd1 vccd1 vccd1 sport_o[32] sky130_fd_sc_hd__buf_12
X_1506_ _1506_/CLK _1506_/D fanout127/X vssd1 vssd1 vccd1 vccd1 hold87/A sky130_fd_sc_hd__dfrtp_1
XFILLER_0_10_132 vssd1 vssd1 vccd1 vccd1 sky130_fd_sc_hd__decap_8
X_1437_ _1471_/CLK hold61/X fanout127/X vssd1 vssd1 vccd1 vccd1 hold59/A sky130_fd_sc_hd__dfrtp_2
X_1368_ _1368_/A _1368_/B vssd1 vssd1 vccd1 vccd1 hold40/A sky130_fd_sc_hd__nand2_1
X_1299_ _1299_/A _1315_/B vssd1 vssd1 vccd1 vccd1 _1299_/Y sky130_fd_sc_hd__nor2_1
XFILLER_0_33_213 vssd1 vssd1 vccd1 vccd1 sky130_fd_sc_hd__fill_1
XFILLER_0_5_181 vssd1 vssd1 vccd1 vccd1 sky130_ef_sc_hd__decap_12
Xinput59 sport_i[57] vssd1 vssd1 vccd1 vccd1 _1019_/A sky130_fd_sc_hd__clkbuf_1
Xinput15 sport_i[17] vssd1 vssd1 vccd1 vccd1 input15/X sky130_fd_sc_hd__buf_1
XANTENNA__1505__RESET_B fanout129/X vssd1 vssd1 vccd1 vccd1 sky130_fd_sc_hd__diode_2
Xinput26 sport_i[27] vssd1 vssd1 vccd1 vccd1 _1399_/B sky130_fd_sc_hd__buf_1
Xinput37 sport_i[37] vssd1 vssd1 vccd1 vccd1 _0998_/C sky130_fd_sc_hd__buf_1
Xinput48 sport_i[47] vssd1 vssd1 vccd1 vccd1 _1003_/A sky130_fd_sc_hd__buf_1
XFILLER_0_28_9 vssd1 vssd1 vccd1 vccd1 sky130_fd_sc_hd__fill_2
X_1222_ _1222_/A vssd1 vssd1 vccd1 vccd1 _1289_/A sky130_fd_sc_hd__inv_2
X_1153_ _1164_/B _1157_/A _1152_/Y _1131_/Y vssd1 vssd1 vccd1 vccd1 _1153_/X sky130_fd_sc_hd__a31o_1
X_1084_ _1084_/A _1084_/B vssd1 vssd1 vccd1 vccd1 _1084_/Y sky130_fd_sc_hd__nand2_1
XFILLER_0_23_50 vssd1 vssd1 vccd1 vccd1 sky130_fd_sc_hd__decap_4
X_0937_ _0937_/A vssd1 vssd1 vccd1 vccd1 _1455_/D sky130_fd_sc_hd__clkbuf_1
XANTENNA__1348__A _1401_/A vssd1 vssd1 vccd1 vccd1 sky130_fd_sc_hd__diode_2
XFILLER_0_30_238 vssd1 vssd1 vccd1 vccd1 sky130_fd_sc_hd__fill_1
X_0799_ _1046_/A _1508_/Q vssd1 vssd1 vccd1 vccd1 _1287_/B sky130_fd_sc_hd__nand2_4
X_0868_ _1351_/A hold57/X vssd1 vssd1 vccd1 vccd1 _0868_/Y sky130_fd_sc_hd__nand2_1
XFILLER_0_15_257 vssd1 vssd1 vccd1 vccd1 sky130_ef_sc_hd__decap_12
XFILLER_0_28_17 vssd1 vssd1 vccd1 vccd1 sky130_fd_sc_hd__decap_4
XFILLER_0_21_249 vssd1 vssd1 vccd1 vccd1 sky130_ef_sc_hd__decap_12
XFILLER_0_12_205 vssd1 vssd1 vccd1 vccd1 sky130_fd_sc_hd__fill_2
X_0722_ _0822_/A _0822_/B vssd1 vssd1 vccd1 vccd1 _1134_/B sky130_fd_sc_hd__nand2_2
XFILLER_0_40_8 vssd1 vssd1 vccd1 vccd1 sky130_fd_sc_hd__fill_2
XFILLER_0_33_7 vssd1 vssd1 vccd1 vccd1 sky130_fd_sc_hd__fill_1
XANTENNA__0946__S _0966_/S vssd1 vssd1 vccd1 vccd1 sky130_fd_sc_hd__diode_2
X_1136_ _1136_/A _1136_/B vssd1 vssd1 vccd1 vccd1 _1136_/Y sky130_fd_sc_hd__nor2_1
X_1067_ hold25/X _0987_/B _0987_/A vssd1 vssd1 vccd1 vccd1 _1067_/Y sky130_fd_sc_hd__o21ai_1
X_1205_ _1205_/A _1205_/B vssd1 vssd1 vccd1 vccd1 _1511_/D sky130_fd_sc_hd__nand2_1
XFILLER_0_7_210 vssd1 vssd1 vccd1 vccd1 sky130_ef_sc_hd__decap_12
XFILLER_0_7_298 vssd1 vssd1 vccd1 vccd1 sky130_fd_sc_hd__fill_1
Xhold4 hold4/A vssd1 vssd1 vccd1 vccd1 hold4/X sky130_fd_sc_hd__dlygate4sd3_1
XTAP_208 vssd1 vccd1 sky130_fd_sc_hd__tapvpwrvgnd_1
XTAP_219 vssd1 vccd1 sky130_fd_sc_hd__tapvpwrvgnd_1
XFILLER_0_29_113 vssd1 vssd1 vccd1 vccd1 sky130_ef_sc_hd__decap_12
XFILLER_0_4_213 vssd1 vssd1 vccd1 vccd1 sky130_fd_sc_hd__fill_1
XANTENNA__1361__A _1401_/A vssd1 vssd1 vccd1 vccd1 sky130_fd_sc_hd__diode_2
XFILLER_0_29_82 vssd1 vssd1 vccd1 vccd1 sky130_ef_sc_hd__decap_12
XFILLER_0_0_50 vssd1 vssd1 vccd1 vccd1 sky130_fd_sc_hd__decap_6
X_1119_ hold122/X _1001_/B _1129_/S vssd1 vssd1 vccd1 vccd1 _1119_/X sky130_fd_sc_hd__mux2_1
XANTENNA__1255__B _1398_/B vssd1 vssd1 vccd1 vccd1 sky130_fd_sc_hd__diode_2
XANTENNA_clkbuf_4_13_0_clk_i_A clkbuf_0_clk_i/X vssd1 vssd1 vccd1 vccd1 sky130_fd_sc_hd__diode_2
XFILLER_0_25_29 vssd1 vssd1 vccd1 vccd1 sky130_fd_sc_hd__fill_2
XFILLER_0_19_190 vssd1 vssd1 vccd1 vccd1 sky130_fd_sc_hd__decap_8
X_1470_ _1531_/CLK _1470_/D fanout125/X vssd1 vssd1 vccd1 vccd1 _1470_/Q sky130_fd_sc_hd__dfrtp_1
XFILLER_0_15_51 vssd1 vssd1 vccd1 vccd1 sky130_fd_sc_hd__decap_4
XFILLER_0_25_193 vssd1 vssd1 vccd1 vccd1 sky130_fd_sc_hd__fill_1
XFILLER_0_40_141 vssd1 vssd1 vccd1 vccd1 sky130_fd_sc_hd__decap_4
XFILLER_0_16_193 vssd1 vssd1 vccd1 vccd1 sky130_fd_sc_hd__decap_3
XANTENNA__1266__A _1401_/A vssd1 vssd1 vccd1 vccd1 sky130_fd_sc_hd__diode_2
X_0970_ _0970_/A _0970_/B vssd1 vssd1 vccd1 vccd1 _1187_/A sky130_fd_sc_hd__nand2_1
X_1453_ _1540_/CLK _1453_/D fanout128/X vssd1 vssd1 vccd1 vccd1 _1453_/Q sky130_fd_sc_hd__dfrtp_2
X_1522_ _1522_/CLK hold42/X fanout123/X vssd1 vssd1 vccd1 vccd1 _1522_/Q sky130_fd_sc_hd__dfrtp_1
XFILLER_0_22_141 vssd1 vssd1 vccd1 vccd1 sky130_fd_sc_hd__decap_6
XANTENNA__0954__S _0966_/S vssd1 vssd1 vccd1 vccd1 sky130_fd_sc_hd__diode_2
X_1384_ _1384_/A _1398_/B vssd1 vssd1 vccd1 vccd1 _1386_/A sky130_fd_sc_hd__nand2_1
XFILLER_0_9_102 vssd1 vssd1 vccd1 vccd1 sky130_fd_sc_hd__fill_1
XFILLER_0_9_113 vssd1 vssd1 vccd1 vccd1 sky130_fd_sc_hd__fill_2
XFILLER_0_9_124 vssd1 vssd1 vccd1 vccd1 sky130_fd_sc_hd__fill_2
XFILLER_0_9_146 vssd1 vssd1 vccd1 vccd1 sky130_ef_sc_hd__decap_12
XFILLER_0_9_179 vssd1 vssd1 vccd1 vccd1 sky130_fd_sc_hd__decap_8
XPHY_64 vssd1 vssd1 vccd1 vccd1 sky130_fd_sc_hd__decap_3
XPHY_53 vssd1 vssd1 vccd1 vccd1 sky130_fd_sc_hd__decap_3
XPHY_20 vssd1 vssd1 vccd1 vccd1 sky130_fd_sc_hd__decap_3
XPHY_31 vssd1 vssd1 vccd1 vccd1 sky130_fd_sc_hd__decap_3
XPHY_42 vssd1 vssd1 vccd1 vccd1 sky130_fd_sc_hd__decap_3
XPHY_86 vssd1 vssd1 vccd1 vccd1 sky130_fd_sc_hd__decap_3
XPHY_75 vssd1 vssd1 vccd1 vccd1 sky130_fd_sc_hd__decap_3
XFILLER_0_36_277 vssd1 vssd1 vccd1 vccd1 sky130_ef_sc_hd__decap_12
X_0953_ _0953_/A vssd1 vssd1 vccd1 vccd1 _1463_/D sky130_fd_sc_hd__clkbuf_1
Xoutput114 _1438_/Q vssd1 vssd1 vccd1 vccd1 sport_o[33] sky130_fd_sc_hd__buf_12
Xoutput103 _1462_/Q vssd1 vssd1 vccd1 vccd1 sport_o[23] sky130_fd_sc_hd__buf_12
X_0884_ _0884_/A _0884_/B vssd1 vssd1 vccd1 vccd1 _0885_/A sky130_fd_sc_hd__nand2_1
XFILLER_0_12_85 vssd1 vssd1 vccd1 vccd1 sky130_fd_sc_hd__fill_1
X_1367_ _1401_/A _1426_/B _1367_/C vssd1 vssd1 vccd1 vccd1 _1368_/B sky130_fd_sc_hd__nand3_1
X_1505_ _1505_/CLK hold21/X fanout129/X vssd1 vssd1 vccd1 vccd1 hold19/A sky130_fd_sc_hd__dfrtp_1
X_1436_ _1471_/CLK hold85/X fanout127/X vssd1 vssd1 vccd1 vccd1 hold83/A sky130_fd_sc_hd__dfrtp_1
X_1298_ _1404_/B _1287_/B hold76/X vssd1 vssd1 vccd1 vccd1 _1298_/X sky130_fd_sc_hd__o21a_1
XFILLER_0_5_193 vssd1 vssd1 vccd1 vccd1 sky130_fd_sc_hd__decap_4
XFILLER_0_24_258 vssd1 vssd1 vccd1 vccd1 sky130_fd_sc_hd__fill_2
Xinput16 sport_i[18] vssd1 vssd1 vccd1 vccd1 input16/X sky130_fd_sc_hd__buf_1
Xinput27 sport_i[28] vssd1 vssd1 vccd1 vccd1 _1406_/B sky130_fd_sc_hd__buf_1
Xinput38 sport_i[38] vssd1 vssd1 vccd1 vccd1 _0998_/B sky130_fd_sc_hd__buf_1
Xinput49 sport_i[48] vssd1 vssd1 vccd1 vccd1 _1001_/B sky130_fd_sc_hd__buf_1
X_1221_ _1351_/A _1223_/B vssd1 vssd1 vccd1 vccd1 _1221_/Y sky130_fd_sc_hd__nand2_1
X_1083_ _1079_/B _1082_/Y _0794_/A _1084_/A vssd1 vssd1 vccd1 vccd1 _1083_/X sky130_fd_sc_hd__o22a_1
X_1152_ _1152_/A hold9/X vssd1 vssd1 vccd1 vccd1 _1152_/Y sky130_fd_sc_hd__nand2_1
X_0936_ hold165/X hold81/X _0966_/S vssd1 vssd1 vccd1 vccd1 _0937_/A sky130_fd_sc_hd__mux2_1
X_0798_ hold12/X vssd1 vssd1 vccd1 vccd1 _0798_/Y sky130_fd_sc_hd__inv_2
X_0867_ _0867_/A hold32/X vssd1 vssd1 vccd1 vccd1 _0867_/Y sky130_fd_sc_hd__nand2_1
XFILLER_0_2_141 vssd1 vssd1 vccd1 vccd1 sky130_ef_sc_hd__decap_12
XFILLER_0_15_269 vssd1 vssd1 vccd1 vccd1 sky130_fd_sc_hd__fill_2
X_1419_ _1056_/B _1417_/X _1418_/Y vssd1 vssd1 vccd1 vccd1 _1420_/B sky130_fd_sc_hd__o21ai_1
XANTENNA__1258__B _1426_/A vssd1 vssd1 vccd1 vccd1 sky130_fd_sc_hd__diode_2
XFILLER_0_28_29 vssd1 vssd1 vccd1 vccd1 sky130_fd_sc_hd__fill_1
X_0721_ hold2/A _0979_/A vssd1 vssd1 vccd1 vccd1 _0822_/B sky130_fd_sc_hd__nor2_1
X_1204_ _1204_/A _1426_/A _1426_/B vssd1 vssd1 vccd1 vccd1 _1205_/B sky130_fd_sc_hd__nand3_1
XANTENNA__0962__S _0966_/S vssd1 vssd1 vccd1 vccd1 sky130_fd_sc_hd__diode_2
X_1135_ _1167_/A _1164_/B _0974_/A vssd1 vssd1 vccd1 vccd1 _1136_/B sky130_fd_sc_hd__o21ai_1
X_1066_ _1066_/A _1066_/B vssd1 vssd1 vccd1 vccd1 _1066_/Y sky130_fd_sc_hd__nand2_1
XANTENNA__1467__RESET_B fanout125/X vssd1 vssd1 vccd1 vccd1 sky130_fd_sc_hd__diode_2
X_0919_ hold152/X hold22/X _0933_/S vssd1 vssd1 vccd1 vccd1 _0920_/A sky130_fd_sc_hd__mux2_1
XFILLER_0_7_222 vssd1 vssd1 vccd1 vccd1 sky130_fd_sc_hd__fill_2
Xhold5 hold5/A vssd1 vssd1 vccd1 vccd1 hold5/X sky130_fd_sc_hd__dlygate4sd3_1
XTAP_209 vssd1 vccd1 sky130_fd_sc_hd__tapvpwrvgnd_1
XFILLER_0_29_125 vssd1 vssd1 vccd1 vccd1 sky130_ef_sc_hd__decap_12
XFILLER_0_29_169 vssd1 vssd1 vccd1 vccd1 sky130_fd_sc_hd__decap_4
XFILLER_0_29_158 vssd1 vssd1 vccd1 vccd1 sky130_fd_sc_hd__decap_8
XFILLER_0_4_247 vssd1 vssd1 vccd1 vccd1 sky130_fd_sc_hd__fill_2
XANTENNA__1361__B _1426_/B vssd1 vssd1 vccd1 vccd1 sky130_fd_sc_hd__diode_2
XFILLER_0_29_94 vssd1 vssd1 vccd1 vccd1 sky130_fd_sc_hd__decap_4
XFILLER_0_35_128 vssd1 vssd1 vccd1 vccd1 sky130_fd_sc_hd__fill_2
X_1118_ _1118_/A vssd1 vssd1 vccd1 vccd1 _1493_/D sky130_fd_sc_hd__clkbuf_1
X_1049_ _1049_/A _1049_/B vssd1 vssd1 vccd1 vccd1 _1050_/A sky130_fd_sc_hd__nand2_1
XFILLER_0_34_194 vssd1 vssd1 vccd1 vccd1 sky130_fd_sc_hd__fill_2
XFILLER_0_17_106 vssd1 vssd1 vccd1 vccd1 sky130_fd_sc_hd__decap_6
XFILLER_0_40_153 vssd1 vssd1 vccd1 vccd1 sky130_fd_sc_hd__fill_2
XFILLER_0_40_197 vssd1 vssd1 vccd1 vccd1 sky130_fd_sc_hd__fill_1
XFILLER_0_0_261 vssd1 vssd1 vccd1 vccd1 sky130_fd_sc_hd__decap_3
XFILLER_0_23_109 vssd1 vssd1 vccd1 vccd1 sky130_fd_sc_hd__decap_3
XFILLER_0_31_186 vssd1 vssd1 vccd1 vccd1 sky130_ef_sc_hd__decap_12
XFILLER_0_36_29 vssd1 vssd1 vccd1 vccd1 sky130_fd_sc_hd__fill_1
X_1452_ _1539_/CLK _1452_/D fanout125/X vssd1 vssd1 vccd1 vccd1 _1452_/Q sky130_fd_sc_hd__dfrtp_2
X_1383_ _1431_/Q hold55/X _1397_/S vssd1 vssd1 vccd1 vccd1 _1384_/A sky130_fd_sc_hd__mux2_1
X_1521_ _1521_/CLK _1521_/D fanout123/X vssd1 vssd1 vccd1 vccd1 _1521_/Q sky130_fd_sc_hd__dfrtp_1
XFILLER_0_22_197 vssd1 vssd1 vccd1 vccd1 sky130_fd_sc_hd__fill_2
XFILLER_0_9_158 vssd1 vssd1 vccd1 vccd1 sky130_fd_sc_hd__decap_4
XFILLER_0_9_169 vssd1 vssd1 vccd1 vccd1 sky130_fd_sc_hd__fill_2
XANTENNA__1367__A _1401_/A vssd1 vssd1 vccd1 vccd1 sky130_fd_sc_hd__diode_2
XFILLER_0_13_197 vssd1 vssd1 vccd1 vccd1 sky130_fd_sc_hd__decap_4
XPHY_87 vssd1 vssd1 vccd1 vccd1 sky130_fd_sc_hd__decap_3
XPHY_76 vssd1 vssd1 vccd1 vccd1 sky130_fd_sc_hd__decap_3
XPHY_65 vssd1 vssd1 vccd1 vccd1 sky130_fd_sc_hd__decap_3
XPHY_54 vssd1 vssd1 vccd1 vccd1 sky130_fd_sc_hd__decap_3
XPHY_10 vssd1 vssd1 vccd1 vccd1 sky130_fd_sc_hd__decap_3
XPHY_21 vssd1 vssd1 vccd1 vccd1 sky130_fd_sc_hd__decap_3
XPHY_32 vssd1 vssd1 vccd1 vccd1 sky130_fd_sc_hd__decap_3
XPHY_43 vssd1 vssd1 vccd1 vccd1 sky130_fd_sc_hd__decap_3
XFILLER_0_36_289 vssd1 vssd1 vccd1 vccd1 sky130_fd_sc_hd__decap_8
X_0952_ hold157/X hold45/X _0966_/S vssd1 vssd1 vccd1 vccd1 _0953_/A sky130_fd_sc_hd__mux2_1
XFILLER_0_27_278 vssd1 vssd1 vccd1 vccd1 sky130_fd_sc_hd__fill_2
XFILLER_0_27_256 vssd1 vssd1 vccd1 vccd1 sky130_fd_sc_hd__fill_2
XFILLER_0_6_117 vssd1 vssd1 vccd1 vccd1 sky130_fd_sc_hd__fill_2
Xoutput104 _1463_/Q vssd1 vssd1 vccd1 vccd1 sport_o[24] sky130_fd_sc_hd__buf_12
Xoutput115 _1442_/Q vssd1 vssd1 vccd1 vccd1 sport_o[3] sky130_fd_sc_hd__buf_12
X_0883_ _1222_/A hold99/A _1351_/A hold72/A vssd1 vssd1 vccd1 vccd1 _0884_/B sky130_fd_sc_hd__a22oi_1
X_1504_ _1505_/CLK hold8/X fanout129/X vssd1 vssd1 vccd1 vccd1 hold6/A sky130_fd_sc_hd__dfrtp_1
XFILLER_0_12_97 vssd1 vssd1 vccd1 vccd1 sky130_fd_sc_hd__decap_4
X_1366_ _1216_/A input21/X _1208_/X _1365_/Y vssd1 vssd1 vccd1 vccd1 _1367_/C sky130_fd_sc_hd__a22o_1
XFILLER_0_10_167 vssd1 vssd1 vccd1 vccd1 sky130_fd_sc_hd__decap_3
X_1435_ _1471_/CLK hold71/X fanout127/X vssd1 vssd1 vccd1 vccd1 hold69/A sky130_fd_sc_hd__dfrtp_1
X_1297_ _1313_/A hold76/X vssd1 vssd1 vccd1 vccd1 _1304_/A sky130_fd_sc_hd__nand2_1
XFILLER_0_18_234 vssd1 vssd1 vccd1 vccd1 sky130_fd_sc_hd__fill_1
XFILLER_0_18_256 vssd1 vssd1 vccd1 vccd1 sky130_fd_sc_hd__decap_6
XFILLER_0_41_281 vssd1 vssd1 vccd1 vccd1 sky130_ef_sc_hd__decap_12
XFILLER_0_41_270 vssd1 vssd1 vccd1 vccd1 sky130_fd_sc_hd__decap_8
Xinput17 sport_i[19] vssd1 vssd1 vccd1 vccd1 input17/X sky130_fd_sc_hd__buf_1
Xinput28 sport_i[29] vssd1 vssd1 vccd1 vccd1 input28/X sky130_fd_sc_hd__buf_1
Xinput39 sport_i[39] vssd1 vssd1 vccd1 vccd1 _0998_/A sky130_fd_sc_hd__buf_1
X_1151_ _1149_/X _1165_/A hold34/X vssd1 vssd1 vccd1 vccd1 hold35/A sky130_fd_sc_hd__o21ai_1
X_1220_ _1313_/A hold36/X vssd1 vssd1 vccd1 vccd1 _1232_/A sky130_fd_sc_hd__nand2_1
X_1082_ _1082_/A _1167_/C vssd1 vssd1 vccd1 vccd1 _1082_/Y sky130_fd_sc_hd__nor2_1
X_0935_ _0935_/A vssd1 vssd1 vccd1 vccd1 _0966_/S sky130_fd_sc_hd__clkbuf_8
X_0866_ hold46/X vssd1 vssd1 vccd1 vccd1 _1306_/A sky130_fd_sc_hd__inv_2
X_0797_ hold78/A _0783_/X _0895_/B _0796_/Y vssd1 vssd1 vccd1 vccd1 _0816_/A sky130_fd_sc_hd__o211ai_1
XFILLER_0_2_153 vssd1 vssd1 vccd1 vccd1 sky130_ef_sc_hd__decap_12
XFILLER_0_23_281 vssd1 vssd1 vccd1 vccd1 sky130_fd_sc_hd__fill_1
X_1349_ _1349_/A _1349_/B vssd1 vssd1 vccd1 vccd1 hold66/A sky130_fd_sc_hd__nand2_1
XANTENNA__1380__A _1401_/A vssd1 vssd1 vccd1 vccd1 sky130_fd_sc_hd__diode_2
X_1418_ _1418_/A _1418_/B vssd1 vssd1 vccd1 vccd1 _1418_/Y sky130_fd_sc_hd__nand2_1
X_0720_ _0900_/A _0814_/A vssd1 vssd1 vccd1 vccd1 _0979_/A sky130_fd_sc_hd__nor2_1
XFILLER_0_18_41 vssd1 vssd1 vccd1 vccd1 sky130_fd_sc_hd__decap_8
XFILLER_0_18_85 vssd1 vssd1 vccd1 vccd1 sky130_fd_sc_hd__fill_2
X_1134_ _1170_/A _1134_/B vssd1 vssd1 vccd1 vccd1 _1136_/A sky130_fd_sc_hd__nor2_1
X_1203_ _1201_/X _1398_/B _1202_/X vssd1 vssd1 vccd1 vccd1 _1204_/A sky130_fd_sc_hd__a21o_1
XFILLER_0_34_95 vssd1 vssd1 vccd1 vccd1 sky130_fd_sc_hd__decap_3
X_1065_ _1077_/A hold24/X vssd1 vssd1 vccd1 vccd1 _1066_/B sky130_fd_sc_hd__nand2_1
X_0918_ _0918_/A vssd1 vssd1 vccd1 vccd1 _1446_/D sky130_fd_sc_hd__clkbuf_1
X_0849_ _1404_/A hold63/X vssd1 vssd1 vccd1 vccd1 _0850_/C sky130_fd_sc_hd__nand2_1
XFILLER_0_7_256 vssd1 vssd1 vccd1 vccd1 sky130_fd_sc_hd__decap_4
XANTENNA__1436__RESET_B fanout127/X vssd1 vssd1 vccd1 vccd1 sky130_fd_sc_hd__diode_2
XFILLER_0_46_192 vssd1 vssd1 vccd1 vccd1 sky130_fd_sc_hd__fill_2
XFILLER_0_46_181 vssd1 vssd1 vccd1 vccd1 sky130_fd_sc_hd__fill_2
Xhold6 hold6/A vssd1 vssd1 vccd1 vccd1 hold6/X sky130_fd_sc_hd__dlygate4sd3_1
XFILLER_0_29_137 vssd1 vssd1 vccd1 vccd1 sky130_ef_sc_hd__decap_12
XFILLER_0_20_75 vssd1 vssd1 vccd1 vccd1 sky130_fd_sc_hd__decap_4
XFILLER_0_29_51 vssd1 vssd1 vccd1 vccd1 sky130_fd_sc_hd__fill_2
X_1117_ hold108/X _1003_/A _1117_/S vssd1 vssd1 vccd1 vccd1 _1118_/A sky130_fd_sc_hd__mux2_1
XFILLER_0_0_96 vssd1 vssd1 vccd1 vccd1 sky130_ef_sc_hd__decap_12
X_1048_ _1048_/A _1048_/B vssd1 vssd1 vccd1 vccd1 _1049_/A sky130_fd_sc_hd__nor2_1
XFILLER_0_19_181 vssd1 vssd1 vccd1 vccd1 sky130_fd_sc_hd__fill_1
XFILLER_0_15_20 vssd1 vssd1 vccd1 vccd1 sky130_fd_sc_hd__fill_2
XFILLER_0_40_165 vssd1 vssd1 vccd1 vccd1 sky130_fd_sc_hd__fill_2
XFILLER_0_16_162 vssd1 vssd1 vccd1 vccd1 sky130_fd_sc_hd__decap_3
XFILLER_0_31_198 vssd1 vssd1 vccd1 vccd1 sky130_fd_sc_hd__decap_8
XFILLER_0_31_165 vssd1 vssd1 vccd1 vccd1 sky130_fd_sc_hd__decap_3
XFILLER_0_39_298 vssd1 vssd1 vccd1 vccd1 sky130_fd_sc_hd__fill_1
XANTENNA__1539__RESET_B fanout126/X vssd1 vssd1 vccd1 vccd1 sky130_fd_sc_hd__diode_2
X_1520_ _1520_/CLK _1520_/D fanout124/X vssd1 vssd1 vccd1 vccd1 _1520_/Q sky130_fd_sc_hd__dfrtp_1
X_1382_ _1422_/A hold55/X vssd1 vssd1 vccd1 vccd1 _1388_/A sky130_fd_sc_hd__nand2_1
X_1451_ _1531_/CLK _1451_/D fanout124/X vssd1 vssd1 vccd1 vccd1 _1451_/Q sky130_fd_sc_hd__dfrtp_1
XFILLER_0_26_41 vssd1 vssd1 vccd1 vccd1 sky130_ef_sc_hd__decap_12
XFILLER_0_45_279 vssd1 vssd1 vccd1 vccd1 sky130_fd_sc_hd__fill_1
XFILLER_0_45_213 vssd1 vssd1 vccd1 vccd1 sky130_fd_sc_hd__decap_8
XANTENNA__1367__B _1426_/B vssd1 vssd1 vccd1 vccd1 sky130_fd_sc_hd__diode_2
XPHY_88 vssd1 vssd1 vccd1 vccd1 sky130_fd_sc_hd__decap_3
XPHY_77 vssd1 vssd1 vccd1 vccd1 sky130_fd_sc_hd__decap_3
XFILLER_0_36_235 vssd1 vssd1 vccd1 vccd1 sky130_fd_sc_hd__fill_2
XPHY_66 vssd1 vssd1 vccd1 vccd1 sky130_fd_sc_hd__decap_3
XPHY_55 vssd1 vssd1 vccd1 vccd1 sky130_fd_sc_hd__decap_3
XPHY_11 vssd1 vssd1 vccd1 vccd1 sky130_fd_sc_hd__decap_3
XPHY_22 vssd1 vssd1 vccd1 vccd1 sky130_fd_sc_hd__decap_3
XPHY_33 vssd1 vssd1 vccd1 vccd1 sky130_fd_sc_hd__decap_3
XPHY_44 vssd1 vssd1 vccd1 vccd1 sky130_fd_sc_hd__decap_3
X_0951_ _0951_/A vssd1 vssd1 vccd1 vccd1 _1462_/D sky130_fd_sc_hd__clkbuf_1
X_0882_ _1404_/A hold74/A hold56/X _0867_/A vssd1 vssd1 vccd1 vccd1 _0884_/A sky130_fd_sc_hd__a22oi_1
XFILLER_0_12_21 vssd1 vssd1 vccd1 vccd1 sky130_fd_sc_hd__decap_6
Xoutput105 _1464_/Q vssd1 vssd1 vccd1 vccd1 sport_o[25] sky130_fd_sc_hd__buf_12
Xoutput116 _1443_/Q vssd1 vssd1 vccd1 vccd1 sport_o[4] sky130_fd_sc_hd__buf_12
X_1503_ _1505_/CLK hold11/X fanout129/X vssd1 vssd1 vccd1 vccd1 hold9/A sky130_fd_sc_hd__dfrtp_1
X_1365_ _1337_/Y _1370_/A _1364_/Y vssd1 vssd1 vccd1 vccd1 _1365_/Y sky130_fd_sc_hd__o21ai_1
XFILLER_0_10_179 vssd1 vssd1 vccd1 vccd1 sky130_fd_sc_hd__fill_1
X_1296_ _1296_/A _1296_/B vssd1 vssd1 vccd1 vccd1 hold42/A sky130_fd_sc_hd__nand2_1
X_1434_ _1471_/CLK hold52/X fanout127/X vssd1 vssd1 vccd1 vccd1 hold50/A sky130_fd_sc_hd__dfrtp_1
XFILLER_0_33_238 vssd1 vssd1 vccd1 vccd1 sky130_fd_sc_hd__decap_4
XFILLER_0_41_293 vssd1 vssd1 vccd1 vccd1 sky130_fd_sc_hd__decap_3
XTAP_190 vssd1 vccd1 sky130_fd_sc_hd__tapvpwrvgnd_1
Xinput18 sport_i[1] vssd1 vssd1 vccd1 vccd1 _1202_/B sky130_fd_sc_hd__buf_1
Xinput29 sport_i[2] vssd1 vssd1 vccd1 vccd1 _1209_/B sky130_fd_sc_hd__clkbuf_1
X_1150_ _1165_/A hold33/X vssd1 vssd1 vccd1 vccd1 hold34/A sky130_fd_sc_hd__nand2_1
X_1081_ _1081_/A vssd1 vssd1 vccd1 vccd1 _1475_/D sky130_fd_sc_hd__clkbuf_1
XFILLER_0_23_64 vssd1 vssd1 vccd1 vccd1 sky130_fd_sc_hd__fill_2
X_0934_ _0934_/A vssd1 vssd1 vccd1 vccd1 _1454_/D sky130_fd_sc_hd__clkbuf_1
X_0865_ _0861_/Y _1287_/B _0862_/Y _0863_/Y _0864_/Y vssd1 vssd1 vccd1 vccd1 _0871_/A
+ sky130_fd_sc_hd__o2111ai_1
XFILLER_0_15_205 vssd1 vssd1 vccd1 vccd1 sky130_ef_sc_hd__decap_12
X_1417_ _1337_/Y _0861_/Y _1423_/A vssd1 vssd1 vccd1 vccd1 _1417_/X sky130_fd_sc_hd__mux2_1
X_0796_ _0796_/A _0796_/B vssd1 vssd1 vccd1 vccd1 _0796_/Y sky130_fd_sc_hd__nand2_1
XFILLER_0_2_165 vssd1 vssd1 vccd1 vccd1 sky130_ef_sc_hd__decap_12
XANTENNA__1380__B _1426_/B vssd1 vssd1 vccd1 vccd1 sky130_fd_sc_hd__diode_2
X_1348_ _1401_/A _1348_/B _1420_/C vssd1 vssd1 vccd1 vccd1 _1349_/B sky130_fd_sc_hd__nand3_1
X_1279_ _1279_/A _1279_/B vssd1 vssd1 vccd1 vccd1 _1520_/D sky130_fd_sc_hd__nand2_1
XFILLER_0_3_85 vssd1 vssd1 vccd1 vccd1 sky130_fd_sc_hd__fill_2
XFILLER_0_14_271 vssd1 vssd1 vccd1 vccd1 sky130_fd_sc_hd__decap_3
XFILLER_0_20_230 vssd1 vssd1 vccd1 vccd1 sky130_fd_sc_hd__decap_8
X_1133_ _1133_/A vssd1 vssd1 vccd1 vccd1 _1133_/Y sky130_fd_sc_hd__inv_2
X_1064_ _1076_/A _1426_/B _1064_/C vssd1 vssd1 vccd1 vccd1 _1064_/Y sky130_fd_sc_hd__nand3_1
X_1202_ _1216_/A _1202_/B vssd1 vssd1 vccd1 vccd1 _1202_/X sky130_fd_sc_hd__and2_1
XFILLER_0_18_97 vssd1 vssd1 vccd1 vccd1 sky130_ef_sc_hd__decap_12
X_0776__1 _1525_/CLK vssd1 vssd1 vccd1 vccd1 _1429_/CLK sky130_fd_sc_hd__inv_2
XFILLER_0_34_85 vssd1 vssd1 vccd1 vccd1 sky130_fd_sc_hd__fill_2
X_0917_ hold163/X hold72/X _0933_/S vssd1 vssd1 vccd1 vccd1 _0918_/A sky130_fd_sc_hd__mux2_1
X_0848_ _1222_/A _1527_/Q _1351_/A _1531_/Q vssd1 vssd1 vccd1 vccd1 _0850_/B sky130_fd_sc_hd__a22oi_1
XFILLER_0_7_279 vssd1 vssd1 vccd1 vccd1 sky130_fd_sc_hd__fill_1
XFILLER_0_11_241 vssd1 vssd1 vccd1 vccd1 sky130_fd_sc_hd__fill_1
XFILLER_0_11_263 vssd1 vssd1 vccd1 vccd1 sky130_fd_sc_hd__fill_1
Xhold7 hold7/A vssd1 vssd1 vccd1 vccd1 hold7/X sky130_fd_sc_hd__dlygate4sd3_1
XFILLER_0_29_149 vssd1 vssd1 vccd1 vccd1 sky130_fd_sc_hd__decap_6
XFILLER_0_29_30 vssd1 vssd1 vccd1 vccd1 sky130_fd_sc_hd__fill_2
X_1116_ _1116_/A vssd1 vssd1 vccd1 vccd1 _1492_/D sky130_fd_sc_hd__clkbuf_1
X_1047_ _1047_/A _1134_/B vssd1 vssd1 vccd1 vccd1 _1048_/B sky130_fd_sc_hd__nor2_1
XFILLER_0_34_163 vssd1 vssd1 vccd1 vccd1 sky130_fd_sc_hd__fill_1
XFILLER_0_34_141 vssd1 vssd1 vccd1 vccd1 sky130_fd_sc_hd__decap_6
XFILLER_0_15_65 vssd1 vssd1 vccd1 vccd1 sky130_fd_sc_hd__fill_2
XFILLER_0_31_53 vssd1 vssd1 vccd1 vccd1 sky130_fd_sc_hd__fill_1
XFILLER_0_15_87 vssd1 vssd1 vccd1 vccd1 sky130_fd_sc_hd__decap_3
XFILLER_0_40_177 vssd1 vssd1 vccd1 vccd1 sky130_fd_sc_hd__fill_1
XFILLER_0_31_111 vssd1 vssd1 vccd1 vccd1 sky130_fd_sc_hd__fill_1
XFILLER_0_31_177 vssd1 vssd1 vccd1 vccd1 sky130_fd_sc_hd__decap_3
XFILLER_0_39_277 vssd1 vssd1 vccd1 vccd1 sky130_fd_sc_hd__decap_3
XFILLER_0_39_233 vssd1 vssd1 vccd1 vccd1 sky130_ef_sc_hd__decap_12
X_1450_ _1531_/CLK _1450_/D fanout124/X vssd1 vssd1 vccd1 vccd1 _1450_/Q sky130_fd_sc_hd__dfrtp_2
XANTENNA__1508__RESET_B fanout129/X vssd1 vssd1 vccd1 vccd1 sky130_fd_sc_hd__diode_2
X_1381_ _1381_/A _1381_/B vssd1 vssd1 vccd1 vccd1 _1534_/D sky130_fd_sc_hd__nand2_1
XFILLER_0_26_53 vssd1 vssd1 vccd1 vccd1 sky130_ef_sc_hd__decap_12
XFILLER_0_45_225 vssd1 vssd1 vccd1 vccd1 sky130_ef_sc_hd__decap_12
Xclkbuf_4_13_0_clk_i clkbuf_0_clk_i/X vssd1 vssd1 vccd1 vccd1 _1537_/CLK sky130_fd_sc_hd__clkbuf_8
XFILLER_0_13_133 vssd1 vssd1 vccd1 vccd1 sky130_fd_sc_hd__fill_2
XPHY_12 vssd1 vssd1 vccd1 vccd1 sky130_fd_sc_hd__decap_3
XPHY_89 vssd1 vssd1 vccd1 vccd1 sky130_fd_sc_hd__decap_3
XPHY_78 vssd1 vssd1 vccd1 vccd1 sky130_fd_sc_hd__decap_3
XPHY_67 vssd1 vssd1 vccd1 vccd1 sky130_fd_sc_hd__decap_3
XPHY_56 vssd1 vssd1 vccd1 vccd1 sky130_fd_sc_hd__decap_3
XPHY_23 vssd1 vssd1 vccd1 vccd1 sky130_fd_sc_hd__decap_3
XPHY_34 vssd1 vssd1 vccd1 vccd1 sky130_fd_sc_hd__decap_3
XPHY_45 vssd1 vssd1 vccd1 vccd1 sky130_fd_sc_hd__decap_3
X_0950_ hold161/X hold89/X _0966_/S vssd1 vssd1 vccd1 vccd1 _0951_/A sky130_fd_sc_hd__mux2_1
XFILLER_0_42_206 vssd1 vssd1 vccd1 vccd1 sky130_fd_sc_hd__fill_2
X_0881_ _0881_/A _1404_/B vssd1 vssd1 vccd1 vccd1 _0886_/A sky130_fd_sc_hd__nand2_1
Xoutput106 _1465_/Q vssd1 vssd1 vccd1 vccd1 sport_o[26] sky130_fd_sc_hd__buf_12
X_1433_ _1433_/CLK input6/X fanout129/X vssd1 vssd1 vccd1 vccd1 _1433_/Q sky130_fd_sc_hd__dfrtp_4
Xoutput117 _1444_/Q vssd1 vssd1 vccd1 vccd1 sport_o[5] sky130_fd_sc_hd__buf_12
X_1502_ _1505_/CLK hold35/X fanout129/X vssd1 vssd1 vccd1 vccd1 hold33/A sky130_fd_sc_hd__dfrtp_1
XFILLER_0_10_147 vssd1 vssd1 vccd1 vccd1 sky130_ef_sc_hd__decap_12
X_1364_ _1370_/A hold39/X vssd1 vssd1 vccd1 vccd1 _1364_/Y sky130_fd_sc_hd__nand2_1
X_1295_ _1295_/A _1426_/A _1334_/C vssd1 vssd1 vccd1 vccd1 _1296_/B sky130_fd_sc_hd__nand3_1
XANTENNA__1394__A _1401_/A vssd1 vssd1 vccd1 vccd1 sky130_fd_sc_hd__diode_2
XANTENNA__1376__A0 _1430_/Q vssd1 vssd1 vccd1 vccd1 sky130_fd_sc_hd__diode_2
XFILLER_0_5_130 vssd1 vssd1 vccd1 vccd1 sky130_fd_sc_hd__decap_8
XTAP_180 vssd1 vccd1 sky130_fd_sc_hd__tapvpwrvgnd_1
XTAP_191 vssd1 vccd1 sky130_fd_sc_hd__tapvpwrvgnd_1
XANTENNA__1300__B1 _1398_/B vssd1 vssd1 vccd1 vccd1 sky130_fd_sc_hd__diode_2
Xinput19 sport_i[20] vssd1 vssd1 vccd1 vccd1 input19/X sky130_fd_sc_hd__buf_1
X_1080_ _1084_/A _1079_/B _1080_/S vssd1 vssd1 vccd1 vccd1 _1081_/A sky130_fd_sc_hd__mux2_1
XANTENNA__1198__B _1426_/A vssd1 vssd1 vccd1 vccd1 sky130_fd_sc_hd__diode_2
XANTENNA__1523__RESET_B fanout126/X vssd1 vssd1 vccd1 vccd1 sky130_fd_sc_hd__diode_2
XFILLER_0_23_87 vssd1 vssd1 vccd1 vccd1 sky130_ef_sc_hd__decap_12
X_0933_ hold164/X hold74/X _0933_/S vssd1 vssd1 vccd1 vccd1 _0934_/A sky130_fd_sc_hd__mux2_1
X_0864_ _1222_/A hold53/X _1223_/B vssd1 vssd1 vccd1 vccd1 _0864_/Y sky130_fd_sc_hd__a21oi_1
XFILLER_0_30_209 vssd1 vssd1 vccd1 vccd1 sky130_fd_sc_hd__decap_3
X_0795_ _1084_/B hold94/A _1082_/A _1491_/Q vssd1 vssd1 vccd1 vccd1 _0796_/B sky130_fd_sc_hd__a22oi_1
XFILLER_0_15_217 vssd1 vssd1 vccd1 vccd1 sky130_fd_sc_hd__decap_6
X_1416_ _1422_/A hold14/X vssd1 vssd1 vccd1 vccd1 _1421_/A sky130_fd_sc_hd__nand2_1
X_1347_ _1216_/A input17/X _1208_/X _1346_/Y vssd1 vssd1 vccd1 vccd1 _1348_/B sky130_fd_sc_hd__a22o_1
XFILLER_0_2_177 vssd1 vssd1 vccd1 vccd1 sky130_ef_sc_hd__decap_12
X_1278_ _1401_/A _1278_/B _1334_/C vssd1 vssd1 vccd1 vccd1 _1279_/B sky130_fd_sc_hd__nand3_1
X_1201_ _1431_/Q hold38/X _1252_/A vssd1 vssd1 vccd1 vccd1 _1201_/X sky130_fd_sc_hd__mux2_1
XFILLER_0_20_242 vssd1 vssd1 vccd1 vccd1 sky130_fd_sc_hd__fill_2
X_1132_ hold29/X _1170_/A _1131_/Y vssd1 vssd1 vccd1 vccd1 _1133_/A sky130_fd_sc_hd__o21bai_1
X_1063_ _1071_/B _0900_/A _0982_/A _0817_/A vssd1 vssd1 vccd1 vccd1 _1063_/X sky130_fd_sc_hd__o211a_1
X_0916_ _0916_/A vssd1 vssd1 vccd1 vccd1 _1445_/D sky130_fd_sc_hd__clkbuf_1
XFILLER_0_7_225 vssd1 vssd1 vccd1 vccd1 sky130_ef_sc_hd__decap_12
X_0847_ _0867_/A hold55/X _1223_/B vssd1 vssd1 vccd1 vccd1 _0847_/X sky130_fd_sc_hd__a21o_1
XANTENNA__1391__B _1398_/B vssd1 vssd1 vccd1 vccd1 sky130_fd_sc_hd__diode_2
XFILLER_0_38_128 vssd1 vssd1 vccd1 vccd1 sky130_fd_sc_hd__fill_1
XANTENNA__1445__RESET_B fanout128/X vssd1 vssd1 vccd1 vccd1 sky130_fd_sc_hd__diode_2
Xhold8 hold8/A vssd1 vssd1 vccd1 vccd1 hold8/X sky130_fd_sc_hd__dlygate4sd3_1
X_1115_ hold119/X _1004_/A _1117_/S vssd1 vssd1 vccd1 vccd1 _1116_/A sky130_fd_sc_hd__mux2_1
XFILLER_0_17_6 vssd1 vssd1 vccd1 vccd1 sky130_fd_sc_hd__fill_2
X_1046_ _1046_/A _1404_/B _1183_/C vssd1 vssd1 vccd1 vccd1 _1048_/A sky130_fd_sc_hd__nor3_1
XFILLER_0_28_183 vssd1 vssd1 vccd1 vccd1 sky130_ef_sc_hd__decap_12
XFILLER_0_34_131 vssd1 vssd1 vccd1 vccd1 sky130_fd_sc_hd__decap_8
XFILLER_0_15_55 vssd1 vssd1 vccd1 vccd1 sky130_fd_sc_hd__fill_1
XFILLER_0_40_189 vssd1 vssd1 vccd1 vccd1 sky130_fd_sc_hd__fill_2
XFILLER_0_40_145 vssd1 vssd1 vccd1 vccd1 sky130_fd_sc_hd__fill_1
XFILLER_0_0_253 vssd1 vssd1 vccd1 vccd1 sky130_fd_sc_hd__decap_8
X_1029_ _1029_/A _1029_/B vssd1 vssd1 vccd1 vccd1 _1030_/B sky130_fd_sc_hd__nor2_1
XFILLER_0_16_153 vssd1 vssd1 vccd1 vccd1 sky130_fd_sc_hd__decap_6
XFILLER_0_16_197 vssd1 vssd1 vccd1 vccd1 sky130_fd_sc_hd__fill_2
XANTENNA__1460__RESET_B fanout125/X vssd1 vssd1 vccd1 vccd1 sky130_fd_sc_hd__diode_2
XFILLER_0_39_245 vssd1 vssd1 vccd1 vccd1 sky130_ef_sc_hd__decap_12
X_1380_ _1401_/A _1426_/B _1380_/C vssd1 vssd1 vccd1 vccd1 _1381_/B sky130_fd_sc_hd__nand3_1
XFILLER_0_26_65 vssd1 vssd1 vccd1 vccd1 sky130_fd_sc_hd__fill_2
XFILLER_0_45_237 vssd1 vssd1 vccd1 vccd1 sky130_ef_sc_hd__decap_12
XFILLER_0_42_97 vssd1 vssd1 vccd1 vccd1 sky130_fd_sc_hd__fill_2
XFILLER_0_13_123 vssd1 vssd1 vccd1 vccd1 sky130_fd_sc_hd__fill_1
XFILLER_0_6_64 vssd1 vssd1 vccd1 vccd1 sky130_fd_sc_hd__fill_2
XPHY_13 vssd1 vssd1 vccd1 vccd1 sky130_fd_sc_hd__decap_3
XPHY_24 vssd1 vssd1 vccd1 vccd1 sky130_fd_sc_hd__decap_3
XPHY_35 vssd1 vssd1 vccd1 vccd1 sky130_fd_sc_hd__decap_3
XPHY_46 vssd1 vssd1 vccd1 vccd1 sky130_fd_sc_hd__decap_3
XPHY_79 vssd1 vssd1 vccd1 vccd1 sky130_fd_sc_hd__decap_3
XPHY_68 vssd1 vssd1 vccd1 vccd1 sky130_fd_sc_hd__decap_3
XPHY_57 vssd1 vssd1 vccd1 vccd1 sky130_fd_sc_hd__decap_3
XFILLER_0_8_150 vssd1 vssd1 vccd1 vccd1 sky130_fd_sc_hd__decap_8
Xoutput107 _1466_/Q vssd1 vssd1 vccd1 vccd1 sport_o[27] sky130_fd_sc_hd__buf_12
XFILLER_0_35_281 vssd1 vssd1 vccd1 vccd1 sky130_fd_sc_hd__fill_2
X_0880_ _0880_/A _0880_/B vssd1 vssd1 vccd1 vccd1 _0881_/A sky130_fd_sc_hd__nand2_1
X_1363_ _1422_/A hold39/X vssd1 vssd1 vccd1 vccd1 _1368_/A sky130_fd_sc_hd__nand2_1
Xoutput118 _1445_/Q vssd1 vssd1 vccd1 vccd1 sport_o[6] sky130_fd_sc_hd__buf_12
X_1432_ _1432_/CLK input5/X fanout129/X vssd1 vssd1 vccd1 vccd1 _1432_/Q sky130_fd_sc_hd__dfrtp_2
X_1501_ _1506_/CLK hold5/X fanout127/X vssd1 vssd1 vccd1 vccd1 hold3/A sky130_fd_sc_hd__dfrtp_1
XFILLER_0_10_159 vssd1 vssd1 vccd1 vccd1 sky130_fd_sc_hd__decap_8
XFILLER_0_37_97 vssd1 vssd1 vccd1 vccd1 sky130_fd_sc_hd__fill_1
X_1294_ _1294_/A _1294_/B vssd1 vssd1 vccd1 vccd1 _1295_/A sky130_fd_sc_hd__nand2_1
XANTENNA__1394__B _1426_/B vssd1 vssd1 vccd1 vccd1 sky130_fd_sc_hd__diode_2
XFILLER_0_5_197 vssd1 vssd1 vccd1 vccd1 sky130_fd_sc_hd__fill_1
XTAP_170 vssd1 vccd1 sky130_fd_sc_hd__tapvpwrvgnd_1
XTAP_181 vssd1 vccd1 sky130_fd_sc_hd__tapvpwrvgnd_1
XTAP_192 vssd1 vccd1 sky130_fd_sc_hd__tapvpwrvgnd_1
XFILLER_0_24_218 vssd1 vssd1 vccd1 vccd1 sky130_fd_sc_hd__decap_4
XFILLER_0_17_281 vssd1 vssd1 vccd1 vccd1 sky130_fd_sc_hd__fill_2
X_0932_ _0932_/A vssd1 vssd1 vccd1 vccd1 _1453_/D sky130_fd_sc_hd__clkbuf_1
XANTENNA__1198__C _1426_/B vssd1 vssd1 vccd1 vccd1 sky130_fd_sc_hd__diode_2
X_0863_ _1351_/A hold39/X vssd1 vssd1 vccd1 vccd1 _0863_/Y sky130_fd_sc_hd__nand2_1
X_0794_ _0794_/A _0794_/B vssd1 vssd1 vccd1 vccd1 _1082_/A sky130_fd_sc_hd__nor2_2
XFILLER_0_2_189 vssd1 vssd1 vccd1 vccd1 sky130_fd_sc_hd__decap_4
XFILLER_0_23_273 vssd1 vssd1 vccd1 vccd1 sky130_fd_sc_hd__fill_1
X_1415_ _1415_/A _1415_/B vssd1 vssd1 vccd1 vccd1 hold64/A sky130_fd_sc_hd__nand2_1
X_1346_ _1344_/Y _1345_/A _1345_/Y vssd1 vssd1 vccd1 vccd1 _1346_/Y sky130_fd_sc_hd__o21ai_1
XFILLER_0_3_32 vssd1 vssd1 vccd1 vccd1 sky130_fd_sc_hd__fill_1
X_1277_ _1216_/A input8/X _1276_/Y _1208_/X vssd1 vssd1 vccd1 vccd1 _1278_/B sky130_fd_sc_hd__a22o_1
XFILLER_0_14_240 vssd1 vssd1 vccd1 vccd1 sky130_fd_sc_hd__fill_1
XFILLER_0_20_221 vssd1 vssd1 vccd1 vccd1 sky130_fd_sc_hd__fill_1
XFILLER_0_20_298 vssd1 vssd1 vccd1 vccd1 sky130_fd_sc_hd__fill_1
X_1200_ _1313_/A hold38/X vssd1 vssd1 vccd1 vccd1 _1205_/A sky130_fd_sc_hd__nand2_1
X_1131_ hold87/A _1164_/B vssd1 vssd1 vccd1 vccd1 _1131_/Y sky130_fd_sc_hd__nor2_1
X_1062_ _1062_/A _1062_/B vssd1 vssd1 vccd1 vccd1 _1062_/Y sky130_fd_sc_hd__nand2_1
X_0915_ hold154/X hold57/X _0933_/S vssd1 vssd1 vccd1 vccd1 _0916_/A sky130_fd_sc_hd__mux2_1
XFILLER_0_7_237 vssd1 vssd1 vccd1 vccd1 sky130_ef_sc_hd__decap_12
X_0846_ _0842_/X _0846_/B _0846_/C vssd1 vssd1 vccd1 vccd1 _0851_/A sky130_fd_sc_hd__nand3b_1
X_1329_ _1422_/A hold80/X vssd1 vssd1 vccd1 vccd1 _1335_/A sky130_fd_sc_hd__nand2_1
XFILLER_0_6_270 vssd1 vssd1 vccd1 vccd1 sky130_ef_sc_hd__decap_12
Xhold9 hold9/A vssd1 vssd1 vccd1 vccd1 hold9/X sky130_fd_sc_hd__clkdlybuf4s25_1
XFILLER_0_20_23 vssd1 vssd1 vccd1 vccd1 sky130_fd_sc_hd__fill_1
XFILLER_0_29_98 vssd1 vssd1 vccd1 vccd1 sky130_fd_sc_hd__fill_1
X_1114_ _1114_/A vssd1 vssd1 vccd1 vccd1 _1491_/D sky130_fd_sc_hd__clkbuf_1
X_1045_ _1045_/A _1045_/B vssd1 vssd1 vccd1 vccd1 _1183_/C sky130_fd_sc_hd__nand2_1
XFILLER_0_43_165 vssd1 vssd1 vccd1 vccd1 sky130_fd_sc_hd__decap_3
XFILLER_0_28_195 vssd1 vssd1 vccd1 vccd1 sky130_fd_sc_hd__fill_1
XFILLER_0_9_42 vssd1 vssd1 vccd1 vccd1 sky130_fd_sc_hd__fill_1
XFILLER_0_9_64 vssd1 vssd1 vccd1 vccd1 sky130_fd_sc_hd__fill_1
X_0829_ _0898_/A hold50/X vssd1 vssd1 vccd1 vccd1 hold51/A sky130_fd_sc_hd__nand2_1
XFILLER_0_34_110 vssd1 vssd1 vccd1 vccd1 sky130_fd_sc_hd__fill_2
XFILLER_0_15_12 vssd1 vssd1 vccd1 vccd1 sky130_fd_sc_hd__decap_8
XFILLER_0_25_110 vssd1 vssd1 vccd1 vccd1 sky130_fd_sc_hd__fill_2
XFILLER_0_40_157 vssd1 vssd1 vccd1 vccd1 sky130_fd_sc_hd__fill_2
XFILLER_0_0_221 vssd1 vssd1 vccd1 vccd1 sky130_fd_sc_hd__decap_3
X_1028_ _1028_/A _1028_/B vssd1 vssd1 vccd1 vccd1 _1029_/B sky130_fd_sc_hd__nand2_1
XFILLER_0_31_113 vssd1 vssd1 vccd1 vccd1 sky130_fd_sc_hd__fill_2
XFILLER_0_39_257 vssd1 vssd1 vccd1 vccd1 sky130_ef_sc_hd__decap_12
XFILLER_0_22_113 vssd1 vssd1 vccd1 vccd1 sky130_fd_sc_hd__fill_2
XFILLER_0_22_157 vssd1 vssd1 vccd1 vccd1 sky130_ef_sc_hd__decap_12
XANTENNA__1517__RESET_B fanout127/X vssd1 vssd1 vccd1 vccd1 sky130_fd_sc_hd__diode_2
XFILLER_0_45_249 vssd1 vssd1 vccd1 vccd1 sky130_ef_sc_hd__decap_12
XFILLER_0_13_146 vssd1 vssd1 vccd1 vccd1 sky130_fd_sc_hd__fill_1
XTAP_330 vssd1 vccd1 sky130_fd_sc_hd__tapvpwrvgnd_1
XPHY_69 vssd1 vssd1 vccd1 vccd1 sky130_fd_sc_hd__decap_3
XPHY_58 vssd1 vssd1 vccd1 vccd1 sky130_fd_sc_hd__decap_3
XPHY_14 vssd1 vssd1 vccd1 vccd1 sky130_fd_sc_hd__decap_3
XPHY_25 vssd1 vssd1 vccd1 vccd1 sky130_fd_sc_hd__decap_3
XPHY_36 vssd1 vssd1 vccd1 vccd1 sky130_fd_sc_hd__decap_3
XPHY_47 vssd1 vssd1 vccd1 vccd1 sky130_fd_sc_hd__decap_3
Xclkbuf_4_7_0_clk_i clkbuf_0_clk_i/X vssd1 vssd1 vccd1 vccd1 _1539_/CLK sky130_fd_sc_hd__clkbuf_8
XFILLER_0_8_184 vssd1 vssd1 vccd1 vccd1 sky130_ef_sc_hd__decap_12
XFILLER_0_27_205 vssd1 vssd1 vccd1 vccd1 sky130_fd_sc_hd__decap_8
Xoutput108 _1467_/Q vssd1 vssd1 vccd1 vccd1 sport_o[28] sky130_fd_sc_hd__buf_12
Xoutput119 _1446_/Q vssd1 vssd1 vccd1 vccd1 sport_o[7] sky130_fd_sc_hd__buf_12
X_1500_ _1506_/CLK hold31/X fanout127/X vssd1 vssd1 vccd1 vccd1 hold29/A sky130_fd_sc_hd__dfrtp_1
X_1362_ _1362_/A _1362_/B vssd1 vssd1 vccd1 vccd1 _1362_/Y sky130_fd_sc_hd__nand2_1
Xoutput90 _1450_/Q vssd1 vssd1 vccd1 vccd1 sport_o[11] sky130_fd_sc_hd__buf_12
X_1431_ _1431_/CLK input4/X fanout129/X vssd1 vssd1 vccd1 vccd1 _1431_/Q sky130_fd_sc_hd__dfrtp_4
X_1293_ _1418_/A _1293_/B vssd1 vssd1 vccd1 vccd1 _1294_/B sky130_fd_sc_hd__nand2_1
XTAP_160 vssd1 vccd1 sky130_fd_sc_hd__tapvpwrvgnd_1
XTAP_171 vssd1 vccd1 sky130_fd_sc_hd__tapvpwrvgnd_1
XTAP_182 vssd1 vccd1 sky130_fd_sc_hd__tapvpwrvgnd_1
XTAP_193 vssd1 vccd1 sky130_fd_sc_hd__tapvpwrvgnd_1
X_0931_ hold159/X hold46/X _0933_/S vssd1 vssd1 vccd1 vccd1 _0932_/A sky130_fd_sc_hd__mux2_1
X_0862_ _0867_/A hold67/X vssd1 vssd1 vccd1 vccd1 _0862_/Y sky130_fd_sc_hd__nand2_1
XANTENNA__1532__RESET_B fanout126/X vssd1 vssd1 vccd1 vccd1 sky130_fd_sc_hd__diode_2
XFILLER_0_2_113 vssd1 vssd1 vccd1 vccd1 sky130_ef_sc_hd__decap_12
X_0793_ _1475_/Q _1476_/Q vssd1 vssd1 vccd1 vccd1 _1084_/B sky130_fd_sc_hd__nor2_2
X_1414_ _1426_/A _1426_/B _1414_/C vssd1 vssd1 vccd1 vccd1 _1415_/B sky130_fd_sc_hd__nand3_1
X_1345_ _1345_/A hold65/X vssd1 vssd1 vccd1 vccd1 _1345_/Y sky130_fd_sc_hd__nand2_1
X_1276_ _1281_/A _1244_/B _1275_/Y vssd1 vssd1 vccd1 vccd1 _1276_/Y sky130_fd_sc_hd__o21ai_1
X_1130_ hold97/X vssd1 vssd1 vccd1 vccd1 _1499_/D sky130_fd_sc_hd__clkbuf_1
XFILLER_0_18_23 vssd1 vssd1 vccd1 vccd1 sky130_fd_sc_hd__decap_4
XFILLER_0_18_89 vssd1 vssd1 vccd1 vccd1 sky130_fd_sc_hd__fill_2
X_1061_ _1077_/A _1061_/B vssd1 vssd1 vccd1 vccd1 _1061_/Y sky130_fd_sc_hd__nand2_1
X_0914_ _0914_/A vssd1 vssd1 vccd1 vccd1 _1444_/D sky130_fd_sc_hd__clkbuf_1
X_0845_ _1404_/A hold76/A vssd1 vssd1 vccd1 vccd1 _0846_/C sky130_fd_sc_hd__nand2_1
XFILLER_0_7_249 vssd1 vssd1 vccd1 vccd1 sky130_fd_sc_hd__fill_1
XFILLER_0_38_3 vssd1 vssd1 vccd1 vccd1 sky130_fd_sc_hd__fill_1
X_1328_ _1328_/A _1328_/B vssd1 vssd1 vccd1 vccd1 hold82/A sky130_fd_sc_hd__nand2_1
X_1259_ _1259_/A _1259_/B vssd1 vssd1 vccd1 vccd1 hold73/A sky130_fd_sc_hd__nand2_1
XFILLER_0_46_185 vssd1 vssd1 vccd1 vccd1 sky130_fd_sc_hd__decap_4
XANTENNA__1454__RESET_B fanout128/X vssd1 vssd1 vccd1 vccd1 sky130_fd_sc_hd__diode_2
XFILLER_0_6_282 vssd1 vssd1 vccd1 vccd1 sky130_ef_sc_hd__decap_12
XFILLER_0_29_66 vssd1 vssd1 vccd1 vccd1 sky130_fd_sc_hd__fill_2
XFILLER_0_29_55 vssd1 vssd1 vccd1 vccd1 sky130_fd_sc_hd__fill_1
XFILLER_0_20_79 vssd1 vssd1 vccd1 vccd1 sky130_fd_sc_hd__fill_1
X_1113_ hold106/X _1006_/A _1117_/S vssd1 vssd1 vccd1 vccd1 _1114_/A sky130_fd_sc_hd__mux2_1
X_1044_ _1187_/A _1058_/A _1058_/B vssd1 vssd1 vccd1 vccd1 _1076_/A sky130_fd_sc_hd__nor3_2
XFILLER_0_28_141 vssd1 vssd1 vccd1 vccd1 sky130_ef_sc_hd__decap_12
X_0759_ _0987_/A _0759_/B vssd1 vssd1 vccd1 vccd1 _1047_/A sky130_fd_sc_hd__nand2_2
X_0828_ _0828_/A _0897_/B vssd1 vssd1 vccd1 vccd1 _0830_/A sky130_fd_sc_hd__nand2_1
XFILLER_0_34_155 vssd1 vssd1 vccd1 vccd1 sky130_fd_sc_hd__fill_2
XFILLER_0_19_163 vssd1 vssd1 vccd1 vccd1 sky130_fd_sc_hd__fill_2
XFILLER_0_40_169 vssd1 vssd1 vccd1 vccd1 sky130_fd_sc_hd__fill_2
XFILLER_0_31_45 vssd1 vssd1 vccd1 vccd1 sky130_fd_sc_hd__fill_2
X_1027_ _1027_/A vssd1 vssd1 vccd1 vccd1 _1028_/B sky130_fd_sc_hd__inv_2
XFILLER_0_31_169 vssd1 vssd1 vccd1 vccd1 sky130_fd_sc_hd__decap_8
Xclkbuf_4_3_0_clk_i clkbuf_0_clk_i/X vssd1 vssd1 vccd1 vccd1 _1522_/CLK sky130_fd_sc_hd__clkbuf_8
XFILLER_0_39_269 vssd1 vssd1 vccd1 vccd1 sky130_fd_sc_hd__decap_8
XFILLER_0_39_225 vssd1 vssd1 vccd1 vccd1 sky130_fd_sc_hd__fill_2
XANTENNA__1397__A0 _1433_/Q vssd1 vssd1 vccd1 vccd1 sky130_fd_sc_hd__diode_2
Xhold90 hold90/A vssd1 vssd1 vccd1 vccd1 hold90/X sky130_fd_sc_hd__dlygate4sd3_1
XFILLER_0_6_44 vssd1 vssd1 vccd1 vccd1 sky130_ef_sc_hd__decap_12
XFILLER_0_13_169 vssd1 vssd1 vccd1 vccd1 sky130_fd_sc_hd__fill_2
XTAP_331 vssd1 vccd1 sky130_fd_sc_hd__tapvpwrvgnd_1
XTAP_320 vssd1 vccd1 sky130_fd_sc_hd__tapvpwrvgnd_1
XFILLER_0_6_99 vssd1 vssd1 vccd1 vccd1 sky130_ef_sc_hd__decap_12
XPHY_59 vssd1 vssd1 vccd1 vccd1 sky130_fd_sc_hd__decap_3
XPHY_15 vssd1 vssd1 vccd1 vccd1 sky130_fd_sc_hd__decap_3
XPHY_26 vssd1 vssd1 vccd1 vccd1 sky130_fd_sc_hd__decap_3
XPHY_37 vssd1 vssd1 vccd1 vccd1 sky130_fd_sc_hd__decap_3
XPHY_48 vssd1 vssd1 vccd1 vccd1 sky130_fd_sc_hd__decap_3
XFILLER_0_36_239 vssd1 vssd1 vccd1 vccd1 sky130_ef_sc_hd__decap_12
XFILLER_0_8_141 vssd1 vssd1 vccd1 vccd1 sky130_fd_sc_hd__decap_4
XFILLER_0_12_191 vssd1 vssd1 vccd1 vccd1 sky130_fd_sc_hd__decap_4
XFILLER_0_35_250 vssd1 vssd1 vccd1 vccd1 sky130_ef_sc_hd__decap_12
Xoutput109 _1468_/Q vssd1 vssd1 vccd1 vccd1 sport_o[29] sky130_fd_sc_hd__buf_12
X_0779__4 _1507_/CLK vssd1 vssd1 vccd1 vccd1 _1432_/CLK sky130_fd_sc_hd__inv_2
X_1430_ _1430_/CLK input3/X fanout127/X vssd1 vssd1 vccd1 vccd1 _1430_/Q sky130_fd_sc_hd__dfrtp_4
Xoutput91 _1451_/Q vssd1 vssd1 vccd1 vccd1 sport_o[12] sky130_fd_sc_hd__buf_12
X_1361_ _1401_/A _1426_/B _1361_/C vssd1 vssd1 vccd1 vccd1 _1362_/B sky130_fd_sc_hd__nand3_1
Xoutput80 hold50/A vssd1 vssd1 vccd1 vccd1 spi_mosi_o[0] sky130_fd_sc_hd__buf_12
X_1292_ _1288_/Y _1291_/Y _1398_/B vssd1 vssd1 vccd1 vccd1 _1294_/A sky130_fd_sc_hd__o21ai_1
XFILLER_0_26_261 vssd1 vssd1 vccd1 vccd1 sky130_fd_sc_hd__fill_2
XFILLER_0_5_111 vssd1 vssd1 vccd1 vccd1 sky130_fd_sc_hd__fill_1
XTAP_150 vssd1 vccd1 sky130_fd_sc_hd__tapvpwrvgnd_1
XTAP_161 vssd1 vccd1 sky130_fd_sc_hd__tapvpwrvgnd_1
XTAP_172 vssd1 vccd1 sky130_fd_sc_hd__tapvpwrvgnd_1
XTAP_183 vssd1 vccd1 sky130_fd_sc_hd__tapvpwrvgnd_1
XTAP_194 vssd1 vccd1 sky130_fd_sc_hd__tapvpwrvgnd_1
X_0930_ _0930_/A vssd1 vssd1 vccd1 vccd1 _1452_/D sky130_fd_sc_hd__clkbuf_1
X_0861_ hold14/X vssd1 vssd1 vccd1 vccd1 _0861_/Y sky130_fd_sc_hd__inv_2
X_0792_ _0789_/Y _0790_/Y hold78/A _0837_/B vssd1 vssd1 vccd1 vccd1 _0796_/A sky130_fd_sc_hd__a31o_1
XFILLER_0_23_231 vssd1 vssd1 vccd1 vccd1 sky130_fd_sc_hd__decap_8
X_1413_ _1412_/Y _1208_/X input28/X _1418_/A vssd1 vssd1 vccd1 vccd1 _1414_/C sky130_fd_sc_hd__a22o_1
XFILLER_0_2_125 vssd1 vssd1 vccd1 vccd1 sky130_ef_sc_hd__decap_12
X_1344_ _1433_/Q vssd1 vssd1 vccd1 vccd1 _1344_/Y sky130_fd_sc_hd__inv_2
XANTENNA__1501__RESET_B fanout127/X vssd1 vssd1 vccd1 vccd1 sky130_fd_sc_hd__diode_2
X_1275_ _1281_/A hold32/X vssd1 vssd1 vccd1 vccd1 _1275_/Y sky130_fd_sc_hd__nand2_1
Xfanout122 fanout123/X vssd1 vssd1 vccd1 vccd1 fanout122/X sky130_fd_sc_hd__clkbuf_8
XFILLER_0_20_201 vssd1 vssd1 vccd1 vccd1 sky130_fd_sc_hd__fill_1
XFILLER_0_20_256 vssd1 vssd1 vccd1 vccd1 sky130_fd_sc_hd__decap_3
X_1060_ _1060_/A _1420_/C _1060_/C vssd1 vssd1 vccd1 vccd1 _1077_/A sky130_fd_sc_hd__nand3_2
XFILLER_0_34_89 vssd1 vssd1 vccd1 vccd1 sky130_fd_sc_hd__fill_2
X_0913_ hold143/X hold43/X _0933_/S vssd1 vssd1 vccd1 vccd1 _0914_/A sky130_fd_sc_hd__mux2_1
X_0844_ _1287_/B vssd1 vssd1 vccd1 vccd1 _1404_/A sky130_fd_sc_hd__inv_2
X_0775_ _0765_/X _0774_/A hold17/X vssd1 vssd1 vccd1 vccd1 hold18/A sky130_fd_sc_hd__o21ai_1
XFILLER_0_11_201 vssd1 vssd1 vccd1 vccd1 sky130_fd_sc_hd__fill_2
XANTENNA_clkbuf_4_1_0_clk_i_A clkbuf_0_clk_i/X vssd1 vssd1 vccd1 vccd1 sky130_fd_sc_hd__diode_2
X_1327_ _1401_/A _1327_/B _1334_/C vssd1 vssd1 vccd1 vccd1 _1328_/B sky130_fd_sc_hd__nand3_1
X_1189_ _1321_/A vssd1 vssd1 vccd1 vccd1 _1313_/A sky130_fd_sc_hd__buf_6
X_1258_ _1258_/A _1426_/A _1334_/C vssd1 vssd1 vccd1 vccd1 _1259_/B sky130_fd_sc_hd__nand3_1
XFILLER_0_46_197 vssd1 vssd1 vccd1 vccd1 sky130_fd_sc_hd__decap_4
XFILLER_0_6_294 vssd1 vssd1 vccd1 vccd1 sky130_fd_sc_hd__decap_4
XFILLER_0_29_109 vssd1 vssd1 vccd1 vccd1 sky130_fd_sc_hd__decap_3
XFILLER_0_37_186 vssd1 vssd1 vccd1 vccd1 sky130_fd_sc_hd__decap_3
XFILLER_0_45_44 vssd1 vssd1 vccd1 vccd1 sky130_fd_sc_hd__fill_1
X_1112_ _1112_/A vssd1 vssd1 vccd1 vccd1 _1490_/D sky130_fd_sc_hd__clkbuf_1
X_1043_ _1043_/A _1043_/B vssd1 vssd1 vccd1 vccd1 _1058_/B sky130_fd_sc_hd__nand2_1
XFILLER_0_28_197 vssd1 vssd1 vccd1 vccd1 sky130_fd_sc_hd__decap_4
XFILLER_0_28_153 vssd1 vssd1 vccd1 vccd1 sky130_ef_sc_hd__decap_12
XFILLER_0_0_57 vssd1 vssd1 vccd1 vccd1 sky130_ef_sc_hd__decap_12
X_0758_ _0900_/B vssd1 vssd1 vccd1 vccd1 _0987_/A sky130_fd_sc_hd__inv_4
X_0827_ _0898_/A vssd1 vssd1 vccd1 vccd1 _0897_/B sky130_fd_sc_hd__inv_2
XANTENNA__1204__B _1426_/A vssd1 vssd1 vccd1 vccd1 sky130_fd_sc_hd__diode_2
XFILLER_0_34_123 vssd1 vssd1 vccd1 vccd1 sky130_fd_sc_hd__fill_2
XFILLER_0_31_57 vssd1 vssd1 vccd1 vccd1 sky130_fd_sc_hd__fill_1
XFILLER_0_40_148 vssd1 vssd1 vccd1 vccd1 sky130_fd_sc_hd__fill_2
XFILLER_0_25_189 vssd1 vssd1 vccd1 vccd1 sky130_fd_sc_hd__decap_4
XFILLER_0_25_167 vssd1 vssd1 vccd1 vccd1 sky130_fd_sc_hd__fill_1
XFILLER_0_0_267 vssd1 vssd1 vccd1 vccd1 sky130_ef_sc_hd__decap_12
X_1026_ _1026_/A vssd1 vssd1 vccd1 vccd1 _1028_/A sky130_fd_sc_hd__inv_2
XFILLER_0_16_101 vssd1 vssd1 vccd1 vccd1 sky130_fd_sc_hd__fill_2
XFILLER_0_22_137 vssd1 vssd1 vccd1 vccd1 sky130_fd_sc_hd__decap_3
Xhold80 hold80/A vssd1 vssd1 vccd1 vccd1 hold80/X sky130_fd_sc_hd__buf_1
Xhold91 hold91/A vssd1 vssd1 vccd1 vccd1 hold91/X sky130_fd_sc_hd__dlygate4sd3_1
XANTENNA__1526__RESET_B fanout125/X vssd1 vssd1 vccd1 vccd1 sky130_fd_sc_hd__diode_2
XANTENNA__0903__S _0933_/S vssd1 vssd1 vccd1 vccd1 sky130_fd_sc_hd__diode_2
XTAP_332 vssd1 vccd1 sky130_fd_sc_hd__tapvpwrvgnd_1
XTAP_321 vssd1 vccd1 sky130_fd_sc_hd__tapvpwrvgnd_1
XTAP_310 vssd1 vccd1 sky130_fd_sc_hd__tapvpwrvgnd_1
XFILLER_0_6_78 vssd1 vssd1 vccd1 vccd1 sky130_fd_sc_hd__decap_6
XFILLER_0_6_56 vssd1 vssd1 vccd1 vccd1 sky130_fd_sc_hd__decap_8
XFILLER_0_6_12 vssd1 vssd1 vccd1 vccd1 sky130_ef_sc_hd__decap_12
XFILLER_0_13_137 vssd1 vssd1 vccd1 vccd1 sky130_fd_sc_hd__decap_3
XFILLER_0_29_281 vssd1 vssd1 vccd1 vccd1 sky130_fd_sc_hd__fill_2
XPHY_49 vssd1 vssd1 vccd1 vccd1 sky130_fd_sc_hd__decap_3
XPHY_16 vssd1 vssd1 vccd1 vccd1 sky130_fd_sc_hd__decap_3
XPHY_27 vssd1 vssd1 vccd1 vccd1 sky130_fd_sc_hd__decap_3
X_1009_ _1009_/A _1009_/B vssd1 vssd1 vccd1 vccd1 _1010_/B sky130_fd_sc_hd__nor2_1
XPHY_38 vssd1 vssd1 vccd1 vccd1 sky130_fd_sc_hd__decap_3
XFILLER_0_44_240 vssd1 vssd1 vccd1 vccd1 sky130_ef_sc_hd__decap_12
XFILLER_0_8_197 vssd1 vssd1 vccd1 vccd1 sky130_fd_sc_hd__decap_4
XFILLER_0_4_6 vssd1 vssd1 vccd1 vccd1 sky130_fd_sc_hd__fill_2
XFILLER_0_35_262 vssd1 vssd1 vccd1 vccd1 sky130_ef_sc_hd__decap_12
XFILLER_0_12_59 vssd1 vssd1 vccd1 vccd1 sky130_fd_sc_hd__fill_1
X_1360_ _1216_/A input20/X _1208_/X _1359_/Y vssd1 vssd1 vccd1 vccd1 _1361_/C sky130_fd_sc_hd__a22o_1
XFILLER_0_10_107 vssd1 vssd1 vccd1 vccd1 sky130_fd_sc_hd__fill_1
Xoutput92 _1452_/Q vssd1 vssd1 vccd1 vccd1 sport_o[13] sky130_fd_sc_hd__buf_12
Xoutput81 hold69/A vssd1 vssd1 vccd1 vccd1 spi_mosi_o[1] sky130_fd_sc_hd__buf_12
X_1291_ _1291_/A _1315_/B vssd1 vssd1 vccd1 vccd1 _1291_/Y sky130_fd_sc_hd__nor2_1
XFILLER_0_18_218 vssd1 vssd1 vccd1 vccd1 sky130_fd_sc_hd__decap_4
XFILLER_0_26_251 vssd1 vssd1 vccd1 vccd1 sky130_fd_sc_hd__fill_1
XFILLER_0_5_123 vssd1 vssd1 vccd1 vccd1 sky130_fd_sc_hd__decap_4
XTAP_140 vssd1 vccd1 sky130_fd_sc_hd__tapvpwrvgnd_1
XTAP_151 vssd1 vccd1 sky130_fd_sc_hd__tapvpwrvgnd_1
X_1489_ _1491_/CLK _1489_/D fanout122/X vssd1 vssd1 vccd1 vccd1 _1489_/Q sky130_fd_sc_hd__dfrtp_1
XTAP_162 vssd1 vccd1 sky130_fd_sc_hd__tapvpwrvgnd_1
XTAP_173 vssd1 vccd1 sky130_fd_sc_hd__tapvpwrvgnd_1
XTAP_184 vssd1 vccd1 sky130_fd_sc_hd__tapvpwrvgnd_1
XANTENNA__1212__B _1426_/A vssd1 vssd1 vccd1 vccd1 sky130_fd_sc_hd__diode_2
XTAP_195 vssd1 vccd1 sky130_fd_sc_hd__tapvpwrvgnd_1
XFILLER_0_17_240 vssd1 vssd1 vccd1 vccd1 sky130_ef_sc_hd__decap_12
XFILLER_0_32_276 vssd1 vssd1 vccd1 vccd1 sky130_ef_sc_hd__decap_12
XFILLER_0_2_3 vssd1 vssd1 vccd1 vccd1 sky130_fd_sc_hd__fill_2
XFILLER_0_23_69 vssd1 vssd1 vccd1 vccd1 sky130_fd_sc_hd__fill_1
X_0791_ _0794_/A vssd1 vssd1 vccd1 vccd1 _0837_/B sky130_fd_sc_hd__inv_2
XFILLER_0_2_137 vssd1 vssd1 vccd1 vccd1 sky130_fd_sc_hd__decap_3
X_0860_ _0856_/X _0857_/X _0895_/B _0859_/X vssd1 vssd1 vccd1 vccd1 _0873_/A sky130_fd_sc_hd__o211ai_1
XFILLER_0_23_243 vssd1 vssd1 vccd1 vccd1 sky130_ef_sc_hd__decap_12
X_1343_ _1422_/A hold65/X vssd1 vssd1 vccd1 vccd1 _1349_/A sky130_fd_sc_hd__nand2_1
X_1412_ _1330_/Y _1423_/A _1411_/Y vssd1 vssd1 vccd1 vccd1 _1412_/Y sky130_fd_sc_hd__o21ai_1
XFILLER_0_23_276 vssd1 vssd1 vccd1 vccd1 sky130_fd_sc_hd__fill_1
XFILLER_0_23_298 vssd1 vssd1 vccd1 vccd1 sky130_fd_sc_hd__fill_1
XFILLER_0_3_57 vssd1 vssd1 vccd1 vccd1 sky130_fd_sc_hd__decap_3
X_1274_ _1313_/A hold32/X vssd1 vssd1 vccd1 vccd1 _1279_/A sky130_fd_sc_hd__nand2_1
XANTENNA__1541__RESET_B fanout126/X vssd1 vssd1 vccd1 vccd1 sky130_fd_sc_hd__diode_2
X_0989_ _1038_/B _1035_/A _0988_/Y vssd1 vssd1 vccd1 vccd1 _0990_/C sky130_fd_sc_hd__o21ai_1
Xfanout123 fanout126/X vssd1 vssd1 vccd1 vccd1 fanout123/X sky130_fd_sc_hd__clkbuf_8
XFILLER_0_1_181 vssd1 vssd1 vccd1 vccd1 sky130_ef_sc_hd__decap_12
XFILLER_0_9_281 vssd1 vssd1 vccd1 vccd1 sky130_ef_sc_hd__decap_12
XFILLER_0_18_58 vssd1 vssd1 vccd1 vccd1 sky130_ef_sc_hd__decap_12
X_0912_ _0912_/A vssd1 vssd1 vccd1 vccd1 _1443_/D sky130_fd_sc_hd__clkbuf_1
XANTENNA__0911__S _0933_/S vssd1 vssd1 vccd1 vccd1 sky130_fd_sc_hd__diode_2
X_0774_ _0774_/A hold16/X vssd1 vssd1 vccd1 vccd1 hold17/A sky130_fd_sc_hd__nand2_1
X_0843_ _1222_/A hold38/X _1351_/A hold43/X vssd1 vssd1 vccd1 vccd1 _0846_/B sky130_fd_sc_hd__a22oi_1
XANTENNA_clkbuf_4_5_0_clk_i_A clkbuf_0_clk_i/X vssd1 vssd1 vccd1 vccd1 sky130_fd_sc_hd__diode_2
X_1326_ _1216_/A input14/X _1208_/X _1325_/Y vssd1 vssd1 vccd1 vccd1 _1327_/B sky130_fd_sc_hd__a22o_1
XFILLER_0_11_279 vssd1 vssd1 vccd1 vccd1 sky130_fd_sc_hd__fill_1
X_1188_ _1261_/A _1420_/C vssd1 vssd1 vccd1 vccd1 _1321_/A sky130_fd_sc_hd__nand2_1
X_1257_ _1257_/A _1257_/B vssd1 vssd1 vccd1 vccd1 _1258_/A sky130_fd_sc_hd__nand2_1
XANTENNA__1463__RESET_B fanout128/X vssd1 vssd1 vccd1 vccd1 sky130_fd_sc_hd__diode_2
XFILLER_0_20_15 vssd1 vssd1 vccd1 vccd1 sky130_fd_sc_hd__decap_8
XFILLER_0_20_37 vssd1 vssd1 vccd1 vccd1 sky130_fd_sc_hd__fill_2
XFILLER_0_29_57 vssd1 vssd1 vccd1 vccd1 sky130_fd_sc_hd__fill_2
X_1042_ _1042_/A _1042_/B vssd1 vssd1 vccd1 vccd1 _1043_/B sky130_fd_sc_hd__nor2_1
X_1111_ hold105/X _1007_/A _1117_/S vssd1 vssd1 vccd1 vccd1 _1112_/A sky130_fd_sc_hd__mux2_1
XFILLER_0_28_165 vssd1 vssd1 vccd1 vccd1 sky130_fd_sc_hd__decap_3
XFILLER_0_28_121 vssd1 vssd1 vccd1 vccd1 sky130_ef_sc_hd__decap_12
XFILLER_0_0_69 vssd1 vssd1 vccd1 vccd1 sky130_ef_sc_hd__decap_12
X_0757_ _0973_/A _0759_/B vssd1 vssd1 vccd1 vccd1 _0760_/A sky130_fd_sc_hd__nand2_1
X_0826_ _0826_/A _0826_/B _1049_/B vssd1 vssd1 vccd1 vccd1 _0898_/A sky130_fd_sc_hd__nand3_2
XFILLER_0_43_3 vssd1 vssd1 vccd1 vccd1 sky130_fd_sc_hd__fill_2
X_1309_ _1418_/A _1309_/B vssd1 vssd1 vccd1 vccd1 _1310_/B sky130_fd_sc_hd__nand2_1
XANTENNA__1204__C _1426_/B vssd1 vssd1 vccd1 vccd1 sky130_fd_sc_hd__diode_2
XFILLER_0_19_143 vssd1 vssd1 vccd1 vccd1 sky130_fd_sc_hd__decap_6
XFILLER_0_19_198 vssd1 vssd1 vccd1 vccd1 sky130_fd_sc_hd__decap_3
XFILLER_0_40_138 vssd1 vssd1 vccd1 vccd1 sky130_fd_sc_hd__fill_2
XFILLER_0_0_279 vssd1 vssd1 vccd1 vccd1 sky130_fd_sc_hd__fill_1
XFILLER_0_0_213 vssd1 vssd1 vccd1 vccd1 sky130_fd_sc_hd__fill_1
X_1025_ _1025_/A _1025_/B vssd1 vssd1 vccd1 vccd1 _1029_/A sky130_fd_sc_hd__nand2_1
X_0809_ _0867_/A hold22/X vssd1 vssd1 vccd1 vccd1 _0809_/Y sky130_fd_sc_hd__nand2_1
XFILLER_0_16_168 vssd1 vssd1 vccd1 vccd1 sky130_fd_sc_hd__fill_1
Xhold81 hold81/A vssd1 vssd1 vccd1 vccd1 hold81/X sky130_fd_sc_hd__clkdlybuf4s25_1
Xhold92 hold92/A vssd1 vssd1 vccd1 vccd1 hold92/X sky130_fd_sc_hd__dlygate4sd3_1
Xhold70 hold70/A vssd1 vssd1 vccd1 vccd1 hold70/X sky130_fd_sc_hd__dlygate4sd3_1
XANTENNA_1 _0998_/A vssd1 vssd1 vccd1 vccd1 sky130_fd_sc_hd__diode_2
XTAP_333 vssd1 vccd1 sky130_fd_sc_hd__tapvpwrvgnd_1
XTAP_322 vssd1 vccd1 sky130_fd_sc_hd__tapvpwrvgnd_1
XTAP_311 vssd1 vccd1 sky130_fd_sc_hd__tapvpwrvgnd_1
XTAP_300 vssd1 vccd1 sky130_fd_sc_hd__tapvpwrvgnd_1
XFILLER_0_6_24 vssd1 vssd1 vccd1 vccd1 sky130_fd_sc_hd__decap_4
XFILLER_0_21_160 vssd1 vssd1 vccd1 vccd1 sky130_fd_sc_hd__fill_2
XFILLER_0_21_182 vssd1 vssd1 vccd1 vccd1 sky130_fd_sc_hd__fill_2
XPHY_17 vssd1 vssd1 vccd1 vccd1 sky130_fd_sc_hd__decap_3
XPHY_28 vssd1 vssd1 vccd1 vccd1 sky130_fd_sc_hd__decap_3
XFILLER_0_8_110 vssd1 vssd1 vccd1 vccd1 sky130_fd_sc_hd__fill_2
XFILLER_0_8_132 vssd1 vssd1 vccd1 vccd1 sky130_fd_sc_hd__decap_8
XFILLER_0_8_165 vssd1 vssd1 vccd1 vccd1 sky130_fd_sc_hd__fill_1
X_1008_ _1008_/A _1008_/B vssd1 vssd1 vccd1 vccd1 _1009_/B sky130_fd_sc_hd__nand2_1
XPHY_39 vssd1 vssd1 vccd1 vccd1 sky130_fd_sc_hd__decap_3
XFILLER_0_12_160 vssd1 vssd1 vccd1 vccd1 sky130_fd_sc_hd__fill_1
XFILLER_0_35_274 vssd1 vssd1 vccd1 vccd1 sky130_fd_sc_hd__decap_6
XFILLER_0_12_27 vssd1 vssd1 vccd1 vccd1 sky130_fd_sc_hd__fill_1
Xoutput93 _1453_/Q vssd1 vssd1 vccd1 vccd1 sport_o[14] sky130_fd_sc_hd__buf_12
Xoutput82 hold83/A vssd1 vssd1 vccd1 vccd1 spi_mosi_o[2] sky130_fd_sc_hd__buf_12
XFILLER_0_37_57 vssd1 vssd1 vccd1 vccd1 sky130_fd_sc_hd__fill_1
X_1290_ _1222_/A _1404_/A _1252_/A _1289_/Y vssd1 vssd1 vccd1 vccd1 _1315_/B sky130_fd_sc_hd__o211ai_4
XFILLER_0_5_102 vssd1 vssd1 vccd1 vccd1 sky130_fd_sc_hd__fill_1
XFILLER_0_5_113 vssd1 vssd1 vccd1 vccd1 sky130_fd_sc_hd__fill_2
XTAP_130 vssd1 vccd1 sky130_fd_sc_hd__tapvpwrvgnd_1
X_1488_ _1491_/CLK _1488_/D fanout122/X vssd1 vssd1 vccd1 vccd1 _1488_/Q sky130_fd_sc_hd__dfrtp_1
XTAP_141 vssd1 vccd1 sky130_fd_sc_hd__tapvpwrvgnd_1
XTAP_152 vssd1 vccd1 sky130_fd_sc_hd__tapvpwrvgnd_1
XTAP_163 vssd1 vccd1 sky130_fd_sc_hd__tapvpwrvgnd_1
XTAP_174 vssd1 vccd1 sky130_fd_sc_hd__tapvpwrvgnd_1
XTAP_185 vssd1 vccd1 sky130_fd_sc_hd__tapvpwrvgnd_1
XTAP_196 vssd1 vccd1 sky130_fd_sc_hd__tapvpwrvgnd_1
XFILLER_0_32_211 vssd1 vssd1 vccd1 vccd1 sky130_fd_sc_hd__decap_3
XFILLER_0_17_252 vssd1 vssd1 vccd1 vccd1 sky130_ef_sc_hd__decap_12
XFILLER_0_32_288 vssd1 vssd1 vccd1 vccd1 sky130_fd_sc_hd__decap_8
XFILLER_0_23_26 vssd1 vssd1 vccd1 vccd1 sky130_ef_sc_hd__decap_12
X_0790_ _1475_/Q hold96/A vssd1 vssd1 vccd1 vccd1 _0790_/Y sky130_fd_sc_hd__nand2_1
XFILLER_0_23_255 vssd1 vssd1 vccd1 vccd1 sky130_ef_sc_hd__decap_12
X_1342_ _1342_/A _1342_/B vssd1 vssd1 vccd1 vccd1 hold54/A sky130_fd_sc_hd__nand2_1
X_1411_ _1423_/A hold63/X vssd1 vssd1 vccd1 vccd1 _1411_/Y sky130_fd_sc_hd__nand2_1
XANTENNA__0909__S _0933_/S vssd1 vssd1 vccd1 vccd1 sky130_fd_sc_hd__diode_2
X_1273_ _1273_/A _1273_/B vssd1 vssd1 vccd1 vccd1 _1519_/D sky130_fd_sc_hd__nand2_1
XFILLER_0_3_69 vssd1 vssd1 vccd1 vccd1 sky130_fd_sc_hd__decap_3
X_0988_ _0988_/A _1056_/B vssd1 vssd1 vccd1 vccd1 _0988_/Y sky130_fd_sc_hd__nor2_1
XANTENNA_fanout127_A fanout129/X vssd1 vssd1 vccd1 vccd1 sky130_fd_sc_hd__diode_2
XFILLER_0_14_211 vssd1 vssd1 vccd1 vccd1 sky130_fd_sc_hd__decap_4
XFILLER_0_1_193 vssd1 vssd1 vccd1 vccd1 sky130_fd_sc_hd__decap_4
XFILLER_0_14_266 vssd1 vssd1 vccd1 vccd1 sky130_fd_sc_hd__decap_3
Xfanout124 fanout125/X vssd1 vssd1 vccd1 vccd1 fanout124/X sky130_fd_sc_hd__clkbuf_8
XFILLER_0_9_293 vssd1 vssd1 vccd1 vccd1 sky130_fd_sc_hd__decap_6
XANTENNA_clkbuf_4_12_0_clk_i_A clkbuf_0_clk_i/X vssd1 vssd1 vccd1 vccd1 sky130_fd_sc_hd__diode_2
XANTENNA__1414__A _1426_/A vssd1 vssd1 vccd1 vccd1 sky130_fd_sc_hd__diode_2
X_0911_ hold140/X hold36/X _0933_/S vssd1 vssd1 vccd1 vccd1 _0912_/A sky130_fd_sc_hd__mux2_1
X_0842_ _0867_/A hold62/X _1404_/B vssd1 vssd1 vccd1 vccd1 _0842_/X sky130_fd_sc_hd__a21o_1
X_0773_ _1398_/B _1164_/B _1171_/A vssd1 vssd1 vccd1 vccd1 _0774_/A sky130_fd_sc_hd__o21ai_1
XFILLER_0_11_225 vssd1 vssd1 vccd1 vccd1 sky130_fd_sc_hd__fill_1
X_1325_ _1323_/Y _1345_/A _1324_/Y vssd1 vssd1 vccd1 vccd1 _1325_/Y sky130_fd_sc_hd__o21ai_1
X_1256_ _1418_/A _1256_/B vssd1 vssd1 vccd1 vccd1 _1257_/B sky130_fd_sc_hd__nand2_1
XANTENNA_clkbuf_4_9_0_clk_i_A clkbuf_0_clk_i/X vssd1 vssd1 vccd1 vccd1 sky130_fd_sc_hd__diode_2
X_1187_ _1187_/A _1187_/B vssd1 vssd1 vccd1 vccd1 _1261_/A sky130_fd_sc_hd__nor2_1
XFILLER_0_46_177 vssd1 vssd1 vccd1 vccd1 sky130_fd_sc_hd__fill_2
XFILLER_0_46_166 vssd1 vssd1 vccd1 vccd1 sky130_fd_sc_hd__fill_2
XANTENNA__1218__B _1426_/A vssd1 vssd1 vccd1 vccd1 sky130_fd_sc_hd__diode_2
XFILLER_0_37_155 vssd1 vssd1 vccd1 vccd1 sky130_fd_sc_hd__fill_2
XFILLER_0_37_133 vssd1 vssd1 vccd1 vccd1 sky130_fd_sc_hd__fill_1
XANTENNA__1432__RESET_B fanout129/X vssd1 vssd1 vccd1 vccd1 sky130_fd_sc_hd__diode_2
XFILLER_0_20_27 vssd1 vssd1 vccd1 vccd1 sky130_fd_sc_hd__fill_1
X_1110_ _1110_/A vssd1 vssd1 vccd1 vccd1 _1489_/D sky130_fd_sc_hd__clkbuf_1
X_1041_ _1041_/A _1041_/B vssd1 vssd1 vccd1 vccd1 _1042_/B sky130_fd_sc_hd__nand2_1
XFILLER_0_28_133 vssd1 vssd1 vccd1 vccd1 sky130_fd_sc_hd__decap_6
XFILLER_0_0_26 vssd1 vssd1 vccd1 vccd1 sky130_fd_sc_hd__fill_2
XFILLER_0_43_169 vssd1 vssd1 vccd1 vccd1 sky130_fd_sc_hd__fill_2
XFILLER_0_9_57 vssd1 vssd1 vccd1 vccd1 sky130_fd_sc_hd__fill_1
X_0825_ _1134_/B _0872_/A _0969_/C vssd1 vssd1 vccd1 vccd1 _1049_/B sky130_fd_sc_hd__nand3_1
XFILLER_0_10_60 vssd1 vssd1 vccd1 vccd1 sky130_fd_sc_hd__fill_1
X_0756_ _1045_/A _1052_/B vssd1 vssd1 vccd1 vccd1 _0756_/Y sky130_fd_sc_hd__nor2_1
X_1239_ _1239_/A _1239_/B vssd1 vssd1 vccd1 vccd1 _1240_/A sky130_fd_sc_hd__nand2_1
X_1308_ _1306_/Y _1307_/Y _1398_/B vssd1 vssd1 vccd1 vccd1 _1310_/A sky130_fd_sc_hd__o21ai_1
XFILLER_0_34_114 vssd1 vssd1 vccd1 vccd1 sky130_fd_sc_hd__fill_1
XFILLER_0_19_100 vssd1 vssd1 vccd1 vccd1 sky130_fd_sc_hd__fill_2
XFILLER_0_25_125 vssd1 vssd1 vccd1 vccd1 sky130_fd_sc_hd__fill_2
XFILLER_0_0_225 vssd1 vssd1 vccd1 vccd1 sky130_fd_sc_hd__decap_8
XFILLER_0_0_236 vssd1 vssd1 vccd1 vccd1 sky130_ef_sc_hd__decap_12
XANTENNA__0917__S _0933_/S vssd1 vssd1 vccd1 vccd1 sky130_fd_sc_hd__diode_2
XFILLER_0_22_9 vssd1 vssd1 vccd1 vccd1 sky130_fd_sc_hd__decap_4
X_1024_ _1024_/A vssd1 vssd1 vccd1 vccd1 _1025_/B sky130_fd_sc_hd__inv_2
X_0808_ hold41/X vssd1 vssd1 vccd1 vccd1 _1288_/A sky130_fd_sc_hd__inv_2
X_0739_ _1208_/A vssd1 vssd1 vccd1 vccd1 _1398_/B sky130_fd_sc_hd__buf_4
XANTENNA__1231__B _1426_/A vssd1 vssd1 vccd1 vccd1 sky130_fd_sc_hd__diode_2
XFILLER_0_22_117 vssd1 vssd1 vccd1 vccd1 sky130_ef_sc_hd__decap_12
Xhold82 hold82/A vssd1 vssd1 vccd1 vccd1 hold82/X sky130_fd_sc_hd__dlygate4sd3_1
XFILLER_0_26_37 vssd1 vssd1 vccd1 vccd1 sky130_fd_sc_hd__fill_2
Xhold93 hold93/A vssd1 vssd1 vccd1 vccd1 hold93/X sky130_fd_sc_hd__dlygate4sd3_1
Xhold60 hold60/A vssd1 vssd1 vccd1 vccd1 hold60/X sky130_fd_sc_hd__dlygate4sd3_1
Xhold71 hold71/A vssd1 vssd1 vccd1 vccd1 hold71/X sky130_fd_sc_hd__dlygate4sd3_1
XFILLER_0_45_209 vssd1 vssd1 vccd1 vccd1 sky130_fd_sc_hd__fill_2
XTAP_334 vssd1 vccd1 sky130_fd_sc_hd__tapvpwrvgnd_1
XTAP_323 vssd1 vccd1 sky130_fd_sc_hd__tapvpwrvgnd_1
XTAP_312 vssd1 vccd1 sky130_fd_sc_hd__tapvpwrvgnd_1
XANTENNA__1535__RESET_B fanout128/X vssd1 vssd1 vccd1 vccd1 sky130_fd_sc_hd__diode_2
XTAP_301 vssd1 vccd1 sky130_fd_sc_hd__tapvpwrvgnd_1
XPHY_18 vssd1 vssd1 vccd1 vccd1 sky130_fd_sc_hd__decap_3
XPHY_29 vssd1 vssd1 vccd1 vccd1 sky130_fd_sc_hd__decap_3
X_1007_ _1007_/A vssd1 vssd1 vccd1 vccd1 _1008_/B sky130_fd_sc_hd__inv_2
XFILLER_0_44_253 vssd1 vssd1 vccd1 vccd1 sky130_ef_sc_hd__decap_12
Xoutput83 hold59/A vssd1 vssd1 vccd1 vccd1 spi_mosi_o[3] sky130_fd_sc_hd__buf_12
Xoutput94 _1454_/Q vssd1 vssd1 vccd1 vccd1 sport_o[15] sky130_fd_sc_hd__buf_12
XFILLER_0_18_209 vssd1 vssd1 vccd1 vccd1 sky130_fd_sc_hd__decap_4
XFILLER_0_41_278 vssd1 vssd1 vccd1 vccd1 sky130_fd_sc_hd__fill_2
XFILLER_0_41_234 vssd1 vssd1 vccd1 vccd1 sky130_ef_sc_hd__decap_12
XANTENNA__1327__A _1401_/A vssd1 vssd1 vccd1 vccd1 sky130_fd_sc_hd__diode_2
XFILLER_0_5_169 vssd1 vssd1 vccd1 vccd1 sky130_ef_sc_hd__decap_12
XTAP_131 vssd1 vccd1 sky130_fd_sc_hd__tapvpwrvgnd_1
XTAP_120 vssd1 vccd1 sky130_fd_sc_hd__tapvpwrvgnd_1
X_1487_ _1521_/CLK _1487_/D fanout122/X vssd1 vssd1 vccd1 vccd1 hold94/A sky130_fd_sc_hd__dfrtp_1
XTAP_142 vssd1 vccd1 sky130_fd_sc_hd__tapvpwrvgnd_1
XTAP_153 vssd1 vccd1 sky130_fd_sc_hd__tapvpwrvgnd_1
XTAP_164 vssd1 vccd1 sky130_fd_sc_hd__tapvpwrvgnd_1
XTAP_175 vssd1 vccd1 sky130_fd_sc_hd__tapvpwrvgnd_1
XTAP_186 vssd1 vccd1 sky130_fd_sc_hd__tapvpwrvgnd_1
XTAP_197 vssd1 vccd1 sky130_fd_sc_hd__tapvpwrvgnd_1
XFILLER_0_32_223 vssd1 vssd1 vccd1 vccd1 sky130_fd_sc_hd__fill_2
XFILLER_0_17_264 vssd1 vssd1 vccd1 vccd1 sky130_fd_sc_hd__decap_3
XANTENNA__1457__RESET_B fanout125/X vssd1 vssd1 vccd1 vccd1 sky130_fd_sc_hd__diode_2
XFILLER_0_4_191 vssd1 vssd1 vccd1 vccd1 sky130_fd_sc_hd__decap_3
XFILLER_0_23_38 vssd1 vssd1 vccd1 vccd1 sky130_ef_sc_hd__decap_12
X_1410_ _1422_/A hold63/X vssd1 vssd1 vccd1 vccd1 _1415_/A sky130_fd_sc_hd__nand2_1
XFILLER_0_23_267 vssd1 vssd1 vccd1 vccd1 sky130_fd_sc_hd__decap_6
X_1341_ _1401_/A _1341_/B _1420_/C vssd1 vssd1 vccd1 vccd1 _1342_/B sky130_fd_sc_hd__nand3_1
X_1272_ _1401_/A _1272_/B _1334_/C vssd1 vssd1 vccd1 vccd1 _1273_/B sky130_fd_sc_hd__nand3_1
XANTENNA__0925__S _0933_/S vssd1 vssd1 vccd1 vccd1 sky130_fd_sc_hd__diode_2
X_0987_ _0987_/A _0987_/B vssd1 vssd1 vccd1 vccd1 _1056_/B sky130_fd_sc_hd__nand2_2
XFILLER_0_13_82 vssd1 vssd1 vccd1 vccd1 sky130_fd_sc_hd__decap_3
XANTENNA__1203__A2 _1398_/B vssd1 vssd1 vccd1 vccd1 sky130_fd_sc_hd__diode_2
X_1539_ _1539_/CLK hold64/X fanout126/X vssd1 vssd1 vccd1 vccd1 hold63/A sky130_fd_sc_hd__dfrtp_1
Xfanout125 fanout126/X vssd1 vssd1 vccd1 vccd1 fanout125/X sky130_fd_sc_hd__clkbuf_8
XFILLER_0_1_161 vssd1 vssd1 vccd1 vccd1 sky130_fd_sc_hd__decap_6
Xhold190 _1527_/Q vssd1 vssd1 vccd1 vccd1 hold80/A sky130_fd_sc_hd__dlygate4sd3_1
XANTENNA__1414__B _1426_/B vssd1 vssd1 vccd1 vccd1 sky130_fd_sc_hd__diode_2
XFILLER_0_18_27 vssd1 vssd1 vccd1 vccd1 sky130_fd_sc_hd__fill_1
XFILLER_0_18_49 vssd1 vssd1 vccd1 vccd1 sky130_fd_sc_hd__fill_2
X_0910_ _0910_/A vssd1 vssd1 vccd1 vccd1 _1442_/D sky130_fd_sc_hd__clkbuf_1
X_0841_ _0832_/X _0834_/X _0895_/B _0840_/Y vssd1 vssd1 vccd1 vccd1 _0852_/B sky130_fd_sc_hd__o211ai_1
X_0772_ _0969_/C _0723_/Y _1164_/B vssd1 vssd1 vccd1 vccd1 _1171_/A sky130_fd_sc_hd__o21ai_2
XFILLER_0_11_215 vssd1 vssd1 vccd1 vccd1 sky130_fd_sc_hd__fill_1
X_1324_ _1345_/A hold81/X vssd1 vssd1 vccd1 vccd1 _1324_/Y sky130_fd_sc_hd__nand2_1
X_1186_ _1183_/Y _1186_/B _1186_/C vssd1 vssd1 vccd1 vccd1 _1187_/B sky130_fd_sc_hd__nand3b_1
X_1255_ _1255_/A _1398_/B vssd1 vssd1 vccd1 vccd1 _1257_/A sky130_fd_sc_hd__nand2_1
XFILLER_0_46_101 vssd1 vssd1 vccd1 vccd1 sky130_fd_sc_hd__fill_2
XFILLER_0_46_189 vssd1 vssd1 vccd1 vccd1 sky130_fd_sc_hd__fill_1
XFILLER_0_6_220 vssd1 vssd1 vccd1 vccd1 sky130_fd_sc_hd__decap_8
XANTENNA__1234__B _1431_/Q vssd1 vssd1 vccd1 vccd1 sky130_fd_sc_hd__diode_2
XANTENNA__1472__RESET_B fanout127/X vssd1 vssd1 vccd1 vccd1 sky130_fd_sc_hd__diode_2
X_1040_ _1045_/A _1040_/B _1040_/C vssd1 vssd1 vccd1 vccd1 _1041_/B sky130_fd_sc_hd__nand3_1
XFILLER_0_0_38 vssd1 vssd1 vccd1 vccd1 sky130_ef_sc_hd__decap_12
X_0755_ _0814_/A _0786_/A vssd1 vssd1 vccd1 vccd1 _1052_/B sky130_fd_sc_hd__nor2_1
XANTENNA__1319__B _1426_/A vssd1 vssd1 vccd1 vccd1 sky130_fd_sc_hd__diode_2
X_0824_ _0970_/B _0983_/A vssd1 vssd1 vccd1 vccd1 _0826_/B sky130_fd_sc_hd__and2_1
XFILLER_0_10_83 vssd1 vssd1 vccd1 vccd1 sky130_fd_sc_hd__fill_1
XFILLER_0_35_91 vssd1 vssd1 vccd1 vccd1 sky130_fd_sc_hd__fill_2
X_1169_ hold88/X vssd1 vssd1 vccd1 vccd1 _1506_/D sky130_fd_sc_hd__clkbuf_1
X_1238_ _1418_/A _1238_/B vssd1 vssd1 vccd1 vccd1 _1239_/B sky130_fd_sc_hd__nand2_1
X_1307_ _1307_/A _1315_/B vssd1 vssd1 vccd1 vccd1 _1307_/Y sky130_fd_sc_hd__nor2_1
XFILLER_0_34_159 vssd1 vssd1 vccd1 vccd1 sky130_fd_sc_hd__decap_4
XFILLER_0_19_167 vssd1 vssd1 vccd1 vccd1 sky130_fd_sc_hd__fill_1
XFILLER_0_42_170 vssd1 vssd1 vccd1 vccd1 sky130_fd_sc_hd__fill_1
XFILLER_0_40_129 vssd1 vssd1 vccd1 vccd1 sky130_fd_sc_hd__fill_1
XFILLER_0_31_49 vssd1 vssd1 vccd1 vccd1 sky130_fd_sc_hd__decap_4
XFILLER_0_25_159 vssd1 vssd1 vccd1 vccd1 sky130_fd_sc_hd__decap_8
XFILLER_0_0_248 vssd1 vssd1 vccd1 vccd1 sky130_fd_sc_hd__decap_4
X_1023_ _1023_/A vssd1 vssd1 vccd1 vccd1 _1025_/A sky130_fd_sc_hd__inv_2
XANTENNA__0933__S _0933_/S vssd1 vssd1 vccd1 vccd1 sky130_fd_sc_hd__diode_2
XFILLER_0_16_126 vssd1 vssd1 vccd1 vccd1 sky130_fd_sc_hd__fill_2
X_0807_ _0798_/Y _1287_/B _0802_/Y _0804_/Y _0806_/Y vssd1 vssd1 vccd1 vccd1 _0813_/A
+ sky130_fd_sc_hd__o2111ai_1
XFILLER_0_24_192 vssd1 vssd1 vccd1 vccd1 sky130_fd_sc_hd__fill_2
X_0738_ _0900_/B _0786_/A vssd1 vssd1 vccd1 vccd1 _1208_/A sky130_fd_sc_hd__nor2_2
XFILLER_0_39_229 vssd1 vssd1 vccd1 vccd1 sky130_fd_sc_hd__fill_1
XFILLER_0_15_181 vssd1 vssd1 vccd1 vccd1 sky130_ef_sc_hd__decap_12
XFILLER_0_22_129 vssd1 vssd1 vccd1 vccd1 sky130_fd_sc_hd__decap_8
XFILLER_0_26_27 vssd1 vssd1 vccd1 vccd1 sky130_fd_sc_hd__fill_1
Xhold94 hold94/A vssd1 vssd1 vccd1 vccd1 hold94/X sky130_fd_sc_hd__dlygate4sd3_1
Xhold72 hold72/A vssd1 vssd1 vccd1 vccd1 hold72/X sky130_fd_sc_hd__buf_1
Xhold50 hold50/A vssd1 vssd1 vccd1 vccd1 hold50/X sky130_fd_sc_hd__dlygate4sd3_1
Xhold61 hold61/A vssd1 vssd1 vccd1 vccd1 hold61/X sky130_fd_sc_hd__dlygate4sd3_1
Xhold83 hold83/A vssd1 vssd1 vccd1 vccd1 hold83/X sky130_fd_sc_hd__dlygate4sd3_1
XTAP_335 vssd1 vccd1 sky130_fd_sc_hd__tapvpwrvgnd_1
XTAP_324 vssd1 vccd1 sky130_fd_sc_hd__tapvpwrvgnd_1
XTAP_313 vssd1 vccd1 sky130_fd_sc_hd__tapvpwrvgnd_1
XTAP_302 vssd1 vccd1 sky130_fd_sc_hd__tapvpwrvgnd_1
XANTENNA__1504__RESET_B fanout129/X vssd1 vssd1 vccd1 vccd1 sky130_fd_sc_hd__diode_2
XPHY_19 vssd1 vssd1 vccd1 vccd1 sky130_fd_sc_hd__decap_3
XFILLER_0_16_82 vssd1 vssd1 vccd1 vccd1 sky130_fd_sc_hd__fill_2
X_1006_ _1006_/A vssd1 vssd1 vccd1 vccd1 _1008_/A sky130_fd_sc_hd__inv_2
XFILLER_0_44_265 vssd1 vssd1 vccd1 vccd1 sky130_ef_sc_hd__decap_12
XFILLER_0_12_195 vssd1 vssd1 vccd1 vccd1 sky130_fd_sc_hd__fill_1
XFILLER_0_12_29 vssd1 vssd1 vccd1 vccd1 sky130_fd_sc_hd__fill_2
Xoutput95 _1455_/Q vssd1 vssd1 vccd1 vccd1 sport_o[16] sky130_fd_sc_hd__buf_12
Xoutput84 _1542_/X vssd1 vssd1 vccd1 vccd1 spi_sio_en_o[0] sky130_fd_sc_hd__buf_12
XFILLER_0_26_221 vssd1 vssd1 vccd1 vccd1 sky130_fd_sc_hd__decap_4
XANTENNA__1215__A0 _1433_/Q vssd1 vssd1 vccd1 vccd1 sky130_fd_sc_hd__diode_2
XFILLER_0_41_246 vssd1 vssd1 vccd1 vccd1 sky130_ef_sc_hd__decap_12
XTAP_121 vssd1 vccd1 sky130_fd_sc_hd__tapvpwrvgnd_1
XTAP_110 vssd1 vccd1 sky130_fd_sc_hd__tapvpwrvgnd_1
XTAP_132 vssd1 vccd1 sky130_fd_sc_hd__tapvpwrvgnd_1
X_1486_ _1515_/CLK _1486_/D fanout123/X vssd1 vssd1 vccd1 vccd1 _1486_/Q sky130_fd_sc_hd__dfrtp_1
XTAP_143 vssd1 vccd1 sky130_fd_sc_hd__tapvpwrvgnd_1
XTAP_154 vssd1 vccd1 sky130_fd_sc_hd__tapvpwrvgnd_1
XTAP_165 vssd1 vccd1 sky130_fd_sc_hd__tapvpwrvgnd_1
XTAP_176 vssd1 vccd1 sky130_fd_sc_hd__tapvpwrvgnd_1
XTAP_187 vssd1 vccd1 sky130_fd_sc_hd__tapvpwrvgnd_1
XTAP_198 vssd1 vccd1 sky130_fd_sc_hd__tapvpwrvgnd_1
XANTENNA__1237__B _1398_/B vssd1 vssd1 vccd1 vccd1 sky130_fd_sc_hd__diode_2
X_1340_ _1216_/A input16/X _1208_/X _1339_/Y vssd1 vssd1 vccd1 vccd1 _1341_/B sky130_fd_sc_hd__a22o_1
X_1271_ _1216_/A input75/X _1270_/Y _1208_/X vssd1 vssd1 vccd1 vccd1 _1272_/B sky130_fd_sc_hd__a22o_1
X_0986_ _1046_/A _1182_/A vssd1 vssd1 vccd1 vccd1 _1035_/A sky130_fd_sc_hd__nor2_1
XFILLER_0_14_202 vssd1 vssd1 vccd1 vccd1 sky130_fd_sc_hd__decap_6
X_1469_ _1539_/CLK _1469_/D fanout128/X vssd1 vssd1 vccd1 vccd1 _1469_/Q sky130_fd_sc_hd__dfrtp_1
X_1538_ _1541_/CLK hold13/X fanout128/X vssd1 vssd1 vccd1 vccd1 hold12/A sky130_fd_sc_hd__dfrtp_1
Xfanout126 input1/X vssd1 vssd1 vccd1 vccd1 fanout126/X sky130_fd_sc_hd__buf_4
XANTENNA__1057__B _1426_/B vssd1 vssd1 vccd1 vccd1 sky130_fd_sc_hd__diode_2
Xhold180 _1535_/Q vssd1 vssd1 vccd1 vccd1 hold55/A sky130_fd_sc_hd__dlygate4sd3_1
XFILLER_0_20_205 vssd1 vssd1 vccd1 vccd1 sky130_fd_sc_hd__fill_2
XFILLER_0_20_238 vssd1 vssd1 vccd1 vccd1 sky130_fd_sc_hd__fill_1
Xhold191 _1540_/Q vssd1 vssd1 vccd1 vccd1 hold14/A sky130_fd_sc_hd__dlygate4sd3_1
XFILLER_0_0_3 vssd1 vssd1 vccd1 vccd1 sky130_fd_sc_hd__fill_2
X_0840_ _0840_/A _0840_/B _0840_/C vssd1 vssd1 vccd1 vccd1 _0840_/Y sky130_fd_sc_hd__nand3_1
X_0771_ _1163_/A _1162_/B vssd1 vssd1 vccd1 vccd1 _0969_/C sky130_fd_sc_hd__nand2_2
X_1323_ _1430_/Q vssd1 vssd1 vccd1 vccd1 _1323_/Y sky130_fd_sc_hd__inv_2
XANTENNA__0936__S _0966_/S vssd1 vssd1 vccd1 vccd1 sky130_fd_sc_hd__diode_2
X_1185_ _1345_/A _1262_/B _1045_/B hold26/A vssd1 vssd1 vccd1 vccd1 _1186_/C sky130_fd_sc_hd__a31o_1
X_1254_ hold72/X _1221_/Y _1223_/Y _1315_/A vssd1 vssd1 vccd1 vccd1 _1255_/A sky130_fd_sc_hd__o2bb2ai_1
XFILLER_0_6_298 vssd1 vssd1 vccd1 vccd1 sky130_fd_sc_hd__fill_1
X_0969_ _1134_/B _0969_/B _0969_/C vssd1 vssd1 vccd1 vccd1 _0970_/A sky130_fd_sc_hd__nand3_1
XFILLER_0_20_29 vssd1 vssd1 vccd1 vccd1 sky130_fd_sc_hd__decap_8
XANTENNA__1529__RESET_B fanout126/X vssd1 vssd1 vccd1 vccd1 sky130_fd_sc_hd__diode_2
X_0754_ _0814_/A _0754_/B vssd1 vssd1 vccd1 vccd1 _1045_/A sky130_fd_sc_hd__nor2_4
X_0823_ hold25/A hold1/A _0823_/C vssd1 vssd1 vccd1 vccd1 _0983_/A sky130_fd_sc_hd__nand3_1
X_1306_ _1306_/A _1306_/B vssd1 vssd1 vccd1 vccd1 _1306_/Y sky130_fd_sc_hd__nor2_1
X_1099_ hold117/X _0998_/B _1117_/S vssd1 vssd1 vccd1 vccd1 _1100_/A sky130_fd_sc_hd__mux2_1
X_1168_ hold87/X input2/X _1168_/S vssd1 vssd1 vccd1 vccd1 hold88/A sky130_fd_sc_hd__mux2_1
XANTENNA__1070__B _1426_/B vssd1 vssd1 vccd1 vccd1 sky130_fd_sc_hd__diode_2
X_1237_ _1237_/A _1398_/B vssd1 vssd1 vccd1 vccd1 _1239_/A sky130_fd_sc_hd__nand2_1
XFILLER_0_34_127 vssd1 vssd1 vccd1 vccd1 sky130_fd_sc_hd__fill_2
XFILLER_0_19_135 vssd1 vssd1 vccd1 vccd1 sky130_fd_sc_hd__fill_2
XFILLER_0_19_157 vssd1 vssd1 vccd1 vccd1 sky130_fd_sc_hd__fill_2
XFILLER_0_42_182 vssd1 vssd1 vccd1 vccd1 sky130_fd_sc_hd__decap_3
XFILLER_0_0_205 vssd1 vssd1 vccd1 vccd1 sky130_fd_sc_hd__fill_1
X_1022_ _1022_/A _1022_/B vssd1 vssd1 vccd1 vccd1 _1030_/A sky130_fd_sc_hd__nor2_1
XFILLER_0_16_105 vssd1 vssd1 vccd1 vccd1 sky130_fd_sc_hd__fill_1
XFILLER_0_16_138 vssd1 vssd1 vccd1 vccd1 sky130_fd_sc_hd__fill_2
XFILLER_0_16_149 vssd1 vssd1 vccd1 vccd1 sky130_fd_sc_hd__fill_2
X_0806_ _1222_/A hold81/A _1223_/B vssd1 vssd1 vccd1 vccd1 _0806_/Y sky130_fd_sc_hd__a21oi_1
XFILLER_0_24_171 vssd1 vssd1 vccd1 vccd1 sky130_fd_sc_hd__fill_1
X_0737_ _0741_/B hold24/X vssd1 vssd1 vccd1 vccd1 _0786_/A sky130_fd_sc_hd__nand2_1
XFILLER_0_15_193 vssd1 vssd1 vccd1 vccd1 sky130_ef_sc_hd__decap_12
Xhold40 hold40/A vssd1 vssd1 vccd1 vccd1 hold40/X sky130_fd_sc_hd__dlygate4sd3_1
Xhold95 hold95/A vssd1 vssd1 vccd1 vccd1 hold95/X sky130_fd_sc_hd__dlygate4sd3_1
Xhold51 hold51/A vssd1 vssd1 vccd1 vccd1 hold51/X sky130_fd_sc_hd__dlygate4sd3_1
Xhold73 hold73/A vssd1 vssd1 vccd1 vccd1 hold73/X sky130_fd_sc_hd__dlygate4sd3_1
Xhold62 hold62/A vssd1 vssd1 vccd1 vccd1 hold62/X sky130_fd_sc_hd__clkbuf_2
Xhold84 hold84/A vssd1 vssd1 vccd1 vccd1 hold84/X sky130_fd_sc_hd__dlygate4sd3_1
XTAP_314 vssd1 vccd1 sky130_fd_sc_hd__tapvpwrvgnd_1
XTAP_303 vssd1 vccd1 sky130_fd_sc_hd__tapvpwrvgnd_1
XFILLER_0_13_119 vssd1 vssd1 vccd1 vccd1 sky130_fd_sc_hd__fill_2
XTAP_336 vssd1 vccd1 sky130_fd_sc_hd__tapvpwrvgnd_1
XTAP_325 vssd1 vccd1 sky130_fd_sc_hd__tapvpwrvgnd_1
XANTENNA__0944__S _0966_/S vssd1 vssd1 vccd1 vccd1 sky130_fd_sc_hd__diode_2
XFILLER_0_29_252 vssd1 vssd1 vccd1 vccd1 sky130_fd_sc_hd__fill_2
XFILLER_0_16_72 vssd1 vssd1 vccd1 vccd1 sky130_fd_sc_hd__fill_1
X_1005_ _1005_/A _1005_/B vssd1 vssd1 vccd1 vccd1 _1009_/A sky130_fd_sc_hd__nand2_1
XFILLER_0_44_277 vssd1 vssd1 vccd1 vccd1 sky130_fd_sc_hd__decap_6
XFILLER_0_32_93 vssd1 vssd1 vccd1 vccd1 sky130_fd_sc_hd__decap_3
XFILLER_0_12_130 vssd1 vssd1 vccd1 vccd1 sky130_fd_sc_hd__fill_1
XFILLER_0_12_152 vssd1 vssd1 vccd1 vccd1 sky130_fd_sc_hd__fill_1
XFILLER_0_35_222 vssd1 vssd1 vccd1 vccd1 sky130_fd_sc_hd__fill_2
Xoutput96 _1456_/Q vssd1 vssd1 vccd1 vccd1 sport_o[17] sky130_fd_sc_hd__buf_12
Xoutput85 _1543_/X vssd1 vssd1 vccd1 vccd1 spi_sio_en_o[1] sky130_fd_sc_hd__buf_12
XFILLER_0_41_258 vssd1 vssd1 vccd1 vccd1 sky130_ef_sc_hd__decap_12
XFILLER_0_41_225 vssd1 vssd1 vccd1 vccd1 sky130_fd_sc_hd__decap_6
XFILLER_0_41_203 vssd1 vssd1 vccd1 vccd1 sky130_fd_sc_hd__fill_1
XFILLER_0_5_138 vssd1 vssd1 vccd1 vccd1 sky130_fd_sc_hd__fill_1
XTAP_122 vssd1 vccd1 sky130_fd_sc_hd__tapvpwrvgnd_1
XTAP_111 vssd1 vccd1 sky130_fd_sc_hd__tapvpwrvgnd_1
X_1485_ _1515_/CLK _1485_/D fanout123/X vssd1 vssd1 vccd1 vccd1 hold95/A sky130_fd_sc_hd__dfrtp_1
XTAP_100 vssd1 vccd1 sky130_fd_sc_hd__tapvpwrvgnd_1
XTAP_133 vssd1 vccd1 sky130_fd_sc_hd__tapvpwrvgnd_1
XTAP_144 vssd1 vccd1 sky130_fd_sc_hd__tapvpwrvgnd_1
XTAP_155 vssd1 vccd1 sky130_fd_sc_hd__tapvpwrvgnd_1
XTAP_166 vssd1 vccd1 sky130_fd_sc_hd__tapvpwrvgnd_1
.ends
